* NGSPICE file created from i2c_master_axil.ext - technology: sky130A

* Black-box entry subcircuit for sky130_fd_sc_hd__tapvpwrvgnd_1 abstract view
.subckt sky130_fd_sc_hd__tapvpwrvgnd_1 VGND VPWR
.ends

* Black-box entry subcircuit for sky130_fd_sc_hd__mux2_1 abstract view
.subckt sky130_fd_sc_hd__mux2_1 A0 A1 S VGND VNB VPB VPWR X
.ends

* Black-box entry subcircuit for sky130_fd_sc_hd__fill_1 abstract view
.subckt sky130_fd_sc_hd__fill_1 VGND VNB VPB VPWR
.ends

* Black-box entry subcircuit for sky130_ef_sc_hd__decap_40_12 abstract view
.subckt sky130_ef_sc_hd__decap_40_12 VPWR VGND VPB VNB
.ends

* Black-box entry subcircuit for sky130_fd_sc_hd__diode_2 abstract view
.subckt sky130_fd_sc_hd__diode_2 DIODE VGND VNB VPB VPWR
.ends

* Black-box entry subcircuit for sky130_fd_sc_hd__nand2b_1 abstract view
.subckt sky130_fd_sc_hd__nand2b_1 A_N B VGND VNB VPB VPWR Y
.ends

* Black-box entry subcircuit for sky130_fd_sc_hd__mux4_1 abstract view
.subckt sky130_fd_sc_hd__mux4_1 A0 A1 A2 A3 S0 S1 VGND VNB VPB VPWR X
.ends

* Black-box entry subcircuit for sky130_fd_sc_hd__dfxtp_1 abstract view
.subckt sky130_fd_sc_hd__dfxtp_1 CLK D VGND VNB VPB VPWR Q
.ends

* Black-box entry subcircuit for sky130_fd_sc_hd__fill_4 abstract view
.subckt sky130_fd_sc_hd__fill_4 VGND VNB VPB VPWR
.ends

* Black-box entry subcircuit for sky130_fd_sc_hd__decap_3 abstract view
.subckt sky130_fd_sc_hd__decap_3 VGND VNB VPB VPWR
.ends

* Black-box entry subcircuit for sky130_fd_sc_hd__a22o_1 abstract view
.subckt sky130_fd_sc_hd__a22o_1 A1 A2 B1 B2 VGND VNB VPB VPWR X
.ends

* Black-box entry subcircuit for sky130_fd_sc_hd__dlygate4sd3_1 abstract view
.subckt sky130_fd_sc_hd__dlygate4sd3_1 A VGND VNB VPB VPWR X
.ends

* Black-box entry subcircuit for sky130_fd_sc_hd__fill_2 abstract view
.subckt sky130_fd_sc_hd__fill_2 VGND VNB VPB VPWR
.ends

* Black-box entry subcircuit for sky130_fd_sc_hd__or2_1 abstract view
.subckt sky130_fd_sc_hd__or2_1 A B VGND VNB VPB VPWR X
.ends

* Black-box entry subcircuit for sky130_fd_sc_hd__a21oi_1 abstract view
.subckt sky130_fd_sc_hd__a21oi_1 A1 A2 B1 VGND VNB VPB VPWR Y
.ends

* Black-box entry subcircuit for sky130_fd_sc_hd__inv_2 abstract view
.subckt sky130_fd_sc_hd__inv_2 A VGND VNB VPB VPWR Y
.ends

* Black-box entry subcircuit for sky130_fd_sc_hd__buf_4 abstract view
.subckt sky130_fd_sc_hd__buf_4 A VGND VNB VPB VPWR X
.ends

* Black-box entry subcircuit for sky130_fd_sc_hd__clkbuf_4 abstract view
.subckt sky130_fd_sc_hd__clkbuf_4 A VGND VNB VPB VPWR X
.ends

* Black-box entry subcircuit for sky130_fd_sc_hd__clkbuf_8 abstract view
.subckt sky130_fd_sc_hd__clkbuf_8 A VGND VNB VPB VPWR X
.ends

* Black-box entry subcircuit for sky130_fd_sc_hd__or3_4 abstract view
.subckt sky130_fd_sc_hd__or3_4 A B C VGND VNB VPB VPWR X
.ends

* Black-box entry subcircuit for sky130_fd_sc_hd__or3b_4 abstract view
.subckt sky130_fd_sc_hd__or3b_4 A B C_N VGND VNB VPB VPWR X
.ends

* Black-box entry subcircuit for sky130_fd_sc_hd__o211a_1 abstract view
.subckt sky130_fd_sc_hd__o211a_1 A1 A2 B1 C1 VGND VNB VPB VPWR X
.ends

* Black-box entry subcircuit for sky130_fd_sc_hd__fill_8 abstract view
.subckt sky130_fd_sc_hd__fill_8 VGND VNB VPB VPWR
.ends

* Black-box entry subcircuit for sky130_fd_sc_hd__conb_1 abstract view
.subckt sky130_fd_sc_hd__conb_1 VGND VNB VPB VPWR HI LO
.ends

* Black-box entry subcircuit for sky130_fd_sc_hd__or2_4 abstract view
.subckt sky130_fd_sc_hd__or2_4 A B VGND VNB VPB VPWR X
.ends

* Black-box entry subcircuit for sky130_fd_sc_hd__o2bb2a_1 abstract view
.subckt sky130_fd_sc_hd__o2bb2a_1 A1_N A2_N B1 B2 VGND VNB VPB VPWR X
.ends

* Black-box entry subcircuit for sky130_fd_sc_hd__nor2_1 abstract view
.subckt sky130_fd_sc_hd__nor2_1 A B VGND VNB VPB VPWR Y
.ends

* Black-box entry subcircuit for sky130_fd_sc_hd__nand2_1 abstract view
.subckt sky130_fd_sc_hd__nand2_1 A B VGND VNB VPB VPWR Y
.ends

* Black-box entry subcircuit for sky130_fd_sc_hd__inv_12 abstract view
.subckt sky130_fd_sc_hd__inv_12 A VGND VNB VPB VPWR Y
.ends

* Black-box entry subcircuit for sky130_fd_sc_hd__o21a_1 abstract view
.subckt sky130_fd_sc_hd__o21a_1 A1 A2 B1 VGND VNB VPB VPWR X
.ends

* Black-box entry subcircuit for sky130_fd_sc_hd__o21ai_1 abstract view
.subckt sky130_fd_sc_hd__o21ai_1 A1 A2 B1 VGND VNB VPB VPWR Y
.ends

* Black-box entry subcircuit for sky130_fd_sc_hd__or3b_1 abstract view
.subckt sky130_fd_sc_hd__or3b_1 A B C_N VGND VNB VPB VPWR X
.ends

* Black-box entry subcircuit for sky130_fd_sc_hd__dfxtp_2 abstract view
.subckt sky130_fd_sc_hd__dfxtp_2 CLK D VGND VNB VPB VPWR Q
.ends

* Black-box entry subcircuit for sky130_fd_sc_hd__nor2_8 abstract view
.subckt sky130_fd_sc_hd__nor2_8 A B VGND VNB VPB VPWR Y
.ends

* Black-box entry subcircuit for sky130_fd_sc_hd__and2b_4 abstract view
.subckt sky130_fd_sc_hd__and2b_4 A_N B VGND VNB VPB VPWR X
.ends

* Black-box entry subcircuit for sky130_fd_sc_hd__or4_1 abstract view
.subckt sky130_fd_sc_hd__or4_1 A B C D VGND VNB VPB VPWR X
.ends

* Black-box entry subcircuit for sky130_fd_sc_hd__buf_2 abstract view
.subckt sky130_fd_sc_hd__buf_2 A VGND VNB VPB VPWR X
.ends

* Black-box entry subcircuit for sky130_fd_sc_hd__and2b_1 abstract view
.subckt sky130_fd_sc_hd__and2b_1 A_N B VGND VNB VPB VPWR X
.ends

* Black-box entry subcircuit for sky130_fd_sc_hd__and2_1 abstract view
.subckt sky130_fd_sc_hd__and2_1 A B VGND VNB VPB VPWR X
.ends

* Black-box entry subcircuit for sky130_fd_sc_hd__clkbuf_16 abstract view
.subckt sky130_fd_sc_hd__clkbuf_16 A VGND VNB VPB VPWR X
.ends

* Black-box entry subcircuit for sky130_fd_sc_hd__o311a_1 abstract view
.subckt sky130_fd_sc_hd__o311a_1 A1 A2 A3 B1 C1 VGND VNB VPB VPWR X
.ends

* Black-box entry subcircuit for sky130_fd_sc_hd__a21o_1 abstract view
.subckt sky130_fd_sc_hd__a21o_1 A1 A2 B1 VGND VNB VPB VPWR X
.ends

* Black-box entry subcircuit for sky130_fd_sc_hd__nor2_4 abstract view
.subckt sky130_fd_sc_hd__nor2_4 A B VGND VNB VPB VPWR Y
.ends

* Black-box entry subcircuit for sky130_fd_sc_hd__clkinvlp_4 abstract view
.subckt sky130_fd_sc_hd__clkinvlp_4 A VGND VNB VPB VPWR Y
.ends

* Black-box entry subcircuit for sky130_fd_sc_hd__clkinv_8 abstract view
.subckt sky130_fd_sc_hd__clkinv_8 A VGND VNB VPB VPWR Y
.ends

* Black-box entry subcircuit for sky130_fd_sc_hd__dfxtp_4 abstract view
.subckt sky130_fd_sc_hd__dfxtp_4 CLK D VGND VNB VPB VPWR Q
.ends

* Black-box entry subcircuit for sky130_fd_sc_hd__or3_1 abstract view
.subckt sky130_fd_sc_hd__or3_1 A B C VGND VNB VPB VPWR X
.ends

* Black-box entry subcircuit for sky130_fd_sc_hd__nand2b_4 abstract view
.subckt sky130_fd_sc_hd__nand2b_4 A_N B VGND VNB VPB VPWR Y
.ends

* Black-box entry subcircuit for sky130_fd_sc_hd__nor4b_2 abstract view
.subckt sky130_fd_sc_hd__nor4b_2 A B C D_N VGND VNB VPB VPWR Y
.ends

* Black-box entry subcircuit for sky130_fd_sc_hd__or3_2 abstract view
.subckt sky130_fd_sc_hd__or3_2 A B C VGND VNB VPB VPWR X
.ends

* Black-box entry subcircuit for sky130_fd_sc_hd__bufinv_16 abstract view
.subckt sky130_fd_sc_hd__bufinv_16 A VGND VNB VPB VPWR Y
.ends

* Black-box entry subcircuit for sky130_fd_sc_hd__nor2_2 abstract view
.subckt sky130_fd_sc_hd__nor2_2 A B VGND VNB VPB VPWR Y
.ends

* Black-box entry subcircuit for sky130_fd_sc_hd__a211o_1 abstract view
.subckt sky130_fd_sc_hd__a211o_1 A1 A2 B1 C1 VGND VNB VPB VPWR X
.ends

* Black-box entry subcircuit for sky130_fd_sc_hd__nand2_4 abstract view
.subckt sky130_fd_sc_hd__nand2_4 A B VGND VNB VPB VPWR Y
.ends

* Black-box entry subcircuit for sky130_fd_sc_hd__o21ba_1 abstract view
.subckt sky130_fd_sc_hd__o21ba_1 A1 A2 B1_N VGND VNB VPB VPWR X
.ends

* Black-box entry subcircuit for sky130_fd_sc_hd__or4b_4 abstract view
.subckt sky130_fd_sc_hd__or4b_4 A B C D_N VGND VNB VPB VPWR X
.ends

* Black-box entry subcircuit for sky130_fd_sc_hd__clkinv_2 abstract view
.subckt sky130_fd_sc_hd__clkinv_2 A VGND VNB VPB VPWR Y
.ends

* Black-box entry subcircuit for sky130_fd_sc_hd__inv_6 abstract view
.subckt sky130_fd_sc_hd__inv_6 A VGND VNB VPB VPWR Y
.ends

* Black-box entry subcircuit for sky130_fd_sc_hd__a41o_1 abstract view
.subckt sky130_fd_sc_hd__a41o_1 A1 A2 A3 A4 B1 VGND VNB VPB VPWR X
.ends

* Black-box entry subcircuit for sky130_fd_sc_hd__a21oi_2 abstract view
.subckt sky130_fd_sc_hd__a21oi_2 A1 A2 B1 VGND VNB VPB VPWR Y
.ends

* Black-box entry subcircuit for sky130_fd_sc_hd__o211ai_1 abstract view
.subckt sky130_fd_sc_hd__o211ai_1 A1 A2 B1 C1 VGND VNB VPB VPWR Y
.ends

* Black-box entry subcircuit for sky130_fd_sc_hd__and2_4 abstract view
.subckt sky130_fd_sc_hd__and2_4 A B VGND VNB VPB VPWR X
.ends

* Black-box entry subcircuit for sky130_fd_sc_hd__o31ai_1 abstract view
.subckt sky130_fd_sc_hd__o31ai_1 A1 A2 A3 B1 VGND VNB VPB VPWR Y
.ends

* Black-box entry subcircuit for sky130_fd_sc_hd__and4bb_4 abstract view
.subckt sky130_fd_sc_hd__and4bb_4 A_N B_N C D VGND VNB VPB VPWR X
.ends

* Black-box entry subcircuit for sky130_fd_sc_hd__or4bb_1 abstract view
.subckt sky130_fd_sc_hd__or4bb_1 A B C_N D_N VGND VNB VPB VPWR X
.ends

* Black-box entry subcircuit for sky130_fd_sc_hd__and2_2 abstract view
.subckt sky130_fd_sc_hd__and2_2 A B VGND VNB VPB VPWR X
.ends

* Black-box entry subcircuit for sky130_fd_sc_hd__and4b_1 abstract view
.subckt sky130_fd_sc_hd__and4b_1 A_N B C D VGND VNB VPB VPWR X
.ends

* Black-box entry subcircuit for sky130_fd_sc_hd__xor2_1 abstract view
.subckt sky130_fd_sc_hd__xor2_1 A B VGND VNB VPB VPWR X
.ends

* Black-box entry subcircuit for sky130_fd_sc_hd__a2bb2o_1 abstract view
.subckt sky130_fd_sc_hd__a2bb2o_1 A1_N A2_N B1 B2 VGND VNB VPB VPWR X
.ends

* Black-box entry subcircuit for sky130_fd_sc_hd__or3b_2 abstract view
.subckt sky130_fd_sc_hd__or3b_2 A B C_N VGND VNB VPB VPWR X
.ends

* Black-box entry subcircuit for sky130_fd_sc_hd__and3_1 abstract view
.subckt sky130_fd_sc_hd__and3_1 A B C VGND VNB VPB VPWR X
.ends

* Black-box entry subcircuit for sky130_fd_sc_hd__a211oi_4 abstract view
.subckt sky130_fd_sc_hd__a211oi_4 A1 A2 B1 C1 VGND VNB VPB VPWR Y
.ends

* Black-box entry subcircuit for sky130_fd_sc_hd__o21bai_1 abstract view
.subckt sky130_fd_sc_hd__o21bai_1 A1 A2 B1_N VGND VNB VPB VPWR Y
.ends

* Black-box entry subcircuit for sky130_fd_sc_hd__a221o_2 abstract view
.subckt sky130_fd_sc_hd__a221o_2 A1 A2 B1 B2 C1 VGND VNB VPB VPWR X
.ends

* Black-box entry subcircuit for sky130_fd_sc_hd__a221o_1 abstract view
.subckt sky130_fd_sc_hd__a221o_1 A1 A2 B1 B2 C1 VGND VNB VPB VPWR X
.ends

* Black-box entry subcircuit for sky130_fd_sc_hd__inv_8 abstract view
.subckt sky130_fd_sc_hd__inv_8 A VGND VNB VPB VPWR Y
.ends

* Black-box entry subcircuit for sky130_fd_sc_hd__a211oi_1 abstract view
.subckt sky130_fd_sc_hd__a211oi_1 A1 A2 B1 C1 VGND VNB VPB VPWR Y
.ends

* Black-box entry subcircuit for sky130_fd_sc_hd__o22a_1 abstract view
.subckt sky130_fd_sc_hd__o22a_1 A1 A2 B1 B2 VGND VNB VPB VPWR X
.ends

* Black-box entry subcircuit for sky130_fd_sc_hd__o221a_1 abstract view
.subckt sky130_fd_sc_hd__o221a_1 A1 A2 B1 B2 C1 VGND VNB VPB VPWR X
.ends

* Black-box entry subcircuit for sky130_fd_sc_hd__o21ai_2 abstract view
.subckt sky130_fd_sc_hd__o21ai_2 A1 A2 B1 VGND VNB VPB VPWR Y
.ends

* Black-box entry subcircuit for sky130_fd_sc_hd__a21bo_1 abstract view
.subckt sky130_fd_sc_hd__a21bo_1 A1 A2 B1_N VGND VNB VPB VPWR X
.ends

* Black-box entry subcircuit for sky130_fd_sc_hd__a31o_1 abstract view
.subckt sky130_fd_sc_hd__a31o_1 A1 A2 A3 B1 VGND VNB VPB VPWR X
.ends

* Black-box entry subcircuit for sky130_fd_sc_hd__and4_1 abstract view
.subckt sky130_fd_sc_hd__and4_1 A B C D VGND VNB VPB VPWR X
.ends

* Black-box entry subcircuit for sky130_fd_sc_hd__nand2_8 abstract view
.subckt sky130_fd_sc_hd__nand2_8 A B VGND VNB VPB VPWR Y
.ends

* Black-box entry subcircuit for sky130_fd_sc_hd__or4bb_2 abstract view
.subckt sky130_fd_sc_hd__or4bb_2 A B C_N D_N VGND VNB VPB VPWR X
.ends

* Black-box entry subcircuit for sky130_fd_sc_hd__a21oi_4 abstract view
.subckt sky130_fd_sc_hd__a21oi_4 A1 A2 B1 VGND VNB VPB VPWR Y
.ends

* Black-box entry subcircuit for sky130_fd_sc_hd__clkinv_4 abstract view
.subckt sky130_fd_sc_hd__clkinv_4 A VGND VNB VPB VPWR Y
.ends

* Black-box entry subcircuit for sky130_fd_sc_hd__nand3b_2 abstract view
.subckt sky130_fd_sc_hd__nand3b_2 A_N B C VGND VNB VPB VPWR Y
.ends

* Black-box entry subcircuit for sky130_fd_sc_hd__a2111oi_4 abstract view
.subckt sky130_fd_sc_hd__a2111oi_4 A1 A2 B1 C1 D1 VGND VNB VPB VPWR Y
.ends

* Black-box entry subcircuit for sky130_fd_sc_hd__or4_2 abstract view
.subckt sky130_fd_sc_hd__or4_2 A B C D VGND VNB VPB VPWR X
.ends

* Black-box entry subcircuit for sky130_fd_sc_hd__nand2_2 abstract view
.subckt sky130_fd_sc_hd__nand2_2 A B VGND VNB VPB VPWR Y
.ends

* Black-box entry subcircuit for sky130_fd_sc_hd__o32a_1 abstract view
.subckt sky130_fd_sc_hd__o32a_1 A1 A2 A3 B1 B2 VGND VNB VPB VPWR X
.ends

* Black-box entry subcircuit for sky130_fd_sc_hd__o41a_1 abstract view
.subckt sky130_fd_sc_hd__o41a_1 A1 A2 A3 A4 B1 VGND VNB VPB VPWR X
.ends

* Black-box entry subcircuit for sky130_fd_sc_hd__a21boi_1 abstract view
.subckt sky130_fd_sc_hd__a21boi_1 A1 A2 B1_N VGND VNB VPB VPWR Y
.ends

* Black-box entry subcircuit for sky130_fd_sc_hd__o22ai_1 abstract view
.subckt sky130_fd_sc_hd__o22ai_1 A1 A2 B1 B2 VGND VNB VPB VPWR Y
.ends

* Black-box entry subcircuit for sky130_fd_sc_hd__nor4_2 abstract view
.subckt sky130_fd_sc_hd__nor4_2 A B C D VGND VNB VPB VPWR Y
.ends

* Black-box entry subcircuit for sky130_fd_sc_hd__o21bai_2 abstract view
.subckt sky130_fd_sc_hd__o21bai_2 A1 A2 B1_N VGND VNB VPB VPWR Y
.ends

* Black-box entry subcircuit for sky130_fd_sc_hd__inv_16 abstract view
.subckt sky130_fd_sc_hd__inv_16 A VGND VNB VPB VPWR Y
.ends

* Black-box entry subcircuit for sky130_fd_sc_hd__o31a_1 abstract view
.subckt sky130_fd_sc_hd__o31a_1 A1 A2 A3 B1 VGND VNB VPB VPWR X
.ends

* Black-box entry subcircuit for sky130_fd_sc_hd__nor3_1 abstract view
.subckt sky130_fd_sc_hd__nor3_1 A B C VGND VNB VPB VPWR Y
.ends

* Black-box entry subcircuit for sky130_fd_sc_hd__buf_1 abstract view
.subckt sky130_fd_sc_hd__buf_1 A VGND VNB VPB VPWR X
.ends

* Black-box entry subcircuit for sky130_fd_sc_hd__or4b_1 abstract view
.subckt sky130_fd_sc_hd__or4b_1 A B C D_N VGND VNB VPB VPWR X
.ends

* Black-box entry subcircuit for sky130_fd_sc_hd__o221ai_1 abstract view
.subckt sky130_fd_sc_hd__o221ai_1 A1 A2 B1 B2 C1 VGND VNB VPB VPWR Y
.ends

* Black-box entry subcircuit for sky130_fd_sc_hd__nor3_4 abstract view
.subckt sky130_fd_sc_hd__nor3_4 A B C VGND VNB VPB VPWR Y
.ends

* Black-box entry subcircuit for sky130_fd_sc_hd__a2111o_1 abstract view
.subckt sky130_fd_sc_hd__a2111o_1 A1 A2 B1 C1 D1 VGND VNB VPB VPWR X
.ends

* Black-box entry subcircuit for sky130_fd_sc_hd__or2_2 abstract view
.subckt sky130_fd_sc_hd__or2_2 A B VGND VNB VPB VPWR X
.ends

* Black-box entry subcircuit for sky130_fd_sc_hd__nand4_1 abstract view
.subckt sky130_fd_sc_hd__nand4_1 A B C D VGND VNB VPB VPWR Y
.ends

* Black-box entry subcircuit for sky130_fd_sc_hd__inv_4 abstract view
.subckt sky130_fd_sc_hd__inv_4 A VGND VNB VPB VPWR Y
.ends

* Black-box entry subcircuit for sky130_fd_sc_hd__xnor2_1 abstract view
.subckt sky130_fd_sc_hd__xnor2_1 A B VGND VNB VPB VPWR Y
.ends

* Black-box entry subcircuit for sky130_fd_sc_hd__clkbuf_1 abstract view
.subckt sky130_fd_sc_hd__clkbuf_1 A VGND VNB VPB VPWR X
.ends

* Black-box entry subcircuit for sky130_fd_sc_hd__buf_8 abstract view
.subckt sky130_fd_sc_hd__buf_8 A VGND VNB VPB VPWR X
.ends

* Black-box entry subcircuit for sky130_fd_sc_hd__clkbuf_2 abstract view
.subckt sky130_fd_sc_hd__clkbuf_2 A VGND VNB VPB VPWR X
.ends

* Black-box entry subcircuit for sky130_fd_sc_hd__a31oi_2 abstract view
.subckt sky130_fd_sc_hd__a31oi_2 A1 A2 A3 B1 VGND VNB VPB VPWR Y
.ends

* Black-box entry subcircuit for sky130_fd_sc_hd__and3_2 abstract view
.subckt sky130_fd_sc_hd__and3_2 A B C VGND VNB VPB VPWR X
.ends

* Black-box entry subcircuit for sky130_fd_sc_hd__nand3_4 abstract view
.subckt sky130_fd_sc_hd__nand3_4 A B C VGND VNB VPB VPWR Y
.ends

* Black-box entry subcircuit for sky130_fd_sc_hd__and3b_1 abstract view
.subckt sky130_fd_sc_hd__and3b_1 A_N B C VGND VNB VPB VPWR X
.ends

* Black-box entry subcircuit for sky130_fd_sc_hd__nor4_1 abstract view
.subckt sky130_fd_sc_hd__nor4_1 A B C D VGND VNB VPB VPWR Y
.ends

* Black-box entry subcircuit for sky130_fd_sc_hd__buf_6 abstract view
.subckt sky130_fd_sc_hd__buf_6 A VGND VNB VPB VPWR X
.ends

* Black-box entry subcircuit for sky130_fd_sc_hd__a32oi_1 abstract view
.subckt sky130_fd_sc_hd__a32oi_1 A1 A2 A3 B1 B2 VGND VNB VPB VPWR Y
.ends

* Black-box entry subcircuit for sky130_fd_sc_hd__or4b_2 abstract view
.subckt sky130_fd_sc_hd__or4b_2 A B C D_N VGND VNB VPB VPWR X
.ends

* Black-box entry subcircuit for sky130_fd_sc_hd__a221o_4 abstract view
.subckt sky130_fd_sc_hd__a221o_4 A1 A2 B1 B2 C1 VGND VNB VPB VPWR X
.ends

* Black-box entry subcircuit for sky130_fd_sc_hd__o2111ai_1 abstract view
.subckt sky130_fd_sc_hd__o2111ai_1 A1 A2 B1 C1 D1 VGND VNB VPB VPWR Y
.ends

* Black-box entry subcircuit for sky130_fd_sc_hd__o31ai_2 abstract view
.subckt sky130_fd_sc_hd__o31ai_2 A1 A2 A3 B1 VGND VNB VPB VPWR Y
.ends

* Black-box entry subcircuit for sky130_fd_sc_hd__a22oi_2 abstract view
.subckt sky130_fd_sc_hd__a22oi_2 A1 A2 B1 B2 VGND VNB VPB VPWR Y
.ends

.subckt i2c_master_axil VGND VPWR clk i2c_scl_i i2c_scl_o i2c_scl_t i2c_sda_i i2c_sda_o
+ i2c_sda_t rst s_axil_araddr[0] s_axil_araddr[1] s_axil_araddr[2] s_axil_araddr[3]
+ s_axil_arprot[0] s_axil_arprot[1] s_axil_arprot[2] s_axil_arready s_axil_arvalid
+ s_axil_awaddr[0] s_axil_awaddr[1] s_axil_awaddr[2] s_axil_awaddr[3] s_axil_awprot[0]
+ s_axil_awprot[1] s_axil_awprot[2] s_axil_awready s_axil_awvalid s_axil_bready s_axil_bresp[0]
+ s_axil_bresp[1] s_axil_bvalid s_axil_rdata[0] s_axil_rdata[10] s_axil_rdata[11]
+ s_axil_rdata[12] s_axil_rdata[13] s_axil_rdata[14] s_axil_rdata[15] s_axil_rdata[16]
+ s_axil_rdata[17] s_axil_rdata[18] s_axil_rdata[19] s_axil_rdata[1] s_axil_rdata[20]
+ s_axil_rdata[21] s_axil_rdata[22] s_axil_rdata[23] s_axil_rdata[24] s_axil_rdata[25]
+ s_axil_rdata[26] s_axil_rdata[27] s_axil_rdata[28] s_axil_rdata[29] s_axil_rdata[2]
+ s_axil_rdata[30] s_axil_rdata[31] s_axil_rdata[3] s_axil_rdata[4] s_axil_rdata[5]
+ s_axil_rdata[6] s_axil_rdata[7] s_axil_rdata[8] s_axil_rdata[9] s_axil_rready s_axil_rresp[0]
+ s_axil_rresp[1] s_axil_rvalid s_axil_wdata[0] s_axil_wdata[10] s_axil_wdata[11]
+ s_axil_wdata[12] s_axil_wdata[13] s_axil_wdata[14] s_axil_wdata[15] s_axil_wdata[16]
+ s_axil_wdata[17] s_axil_wdata[18] s_axil_wdata[19] s_axil_wdata[1] s_axil_wdata[20]
+ s_axil_wdata[21] s_axil_wdata[22] s_axil_wdata[23] s_axil_wdata[24] s_axil_wdata[25]
+ s_axil_wdata[26] s_axil_wdata[27] s_axil_wdata[28] s_axil_wdata[29] s_axil_wdata[2]
+ s_axil_wdata[30] s_axil_wdata[31] s_axil_wdata[3] s_axil_wdata[4] s_axil_wdata[5]
+ s_axil_wdata[6] s_axil_wdata[7] s_axil_wdata[8] s_axil_wdata[9] s_axil_wready s_axil_wstrb[0]
+ s_axil_wstrb[1] s_axil_wstrb[2] s_axil_wstrb[3] s_axil_wvalid
XTAP_TAPCELL_ROW_87_1605 VGND VPWR sky130_fd_sc_hd__tapvpwrvgnd_1
X_3155_ _5066_/A0 hold6/X _3156_/S VGND VGND VPWR VPWR _3155_/X sky130_fd_sc_hd__mux2_1
XFILLER_67_586 VGND VGND VPWR VPWR sky130_fd_sc_hd__fill_1
XFILLER_55_704 VGND VGND VPWR VPWR sky130_fd_sc_hd__fill_1
XFILLER_27_417 VPWR VGND VPWR VGND sky130_ef_sc_hd__decap_40_12
XANTENNA__3140__B2 _5200_/A VGND VGND VPWR VPWR sky130_fd_sc_hd__diode_2
X_3086_ _6137_/Q _5560_/Q _3086_/S VGND VGND VPWR VPWR _3086_/X sky130_fd_sc_hd__mux2_1
XANTENNA_fanout162_A _4212_/A VGND VGND VPWR VPWR sky130_fd_sc_hd__diode_2
XTAP_TAPCELL_ROW_46_990 VGND VPWR sky130_fd_sc_hd__tapvpwrvgnd_1
X_3988_ _5915_/Q _3988_/B VGND VGND VPWR VPWR _5008_/B sky130_fd_sc_hd__nand2b_1
XANTENNA__4670__A _4809_/A VGND VGND VPWR VPWR sky130_fd_sc_hd__diode_2
X_2939_ _5421_/Q _5495_/Q _5351_/Q _5579_/Q _2963_/S _2962_/A VGND VGND VPWR VPWR
+ _2940_/B sky130_fd_sc_hd__mux4_1
X_5727_ _6294_/CLK _5727_/D VGND VGND VPWR VPWR _5727_/Q sky130_fd_sc_hd__dfxtp_1
XFILLER_136_525 VGND VGND VPWR VPWR sky130_fd_sc_hd__fill_4
XTAP_TAPCELL_ROW_98_1767 VGND VPWR sky130_fd_sc_hd__tapvpwrvgnd_1
X_5658_ _5898_/CLK _5658_/D VGND VGND VPWR VPWR _5658_/Q sky130_fd_sc_hd__dfxtp_1
XFILLER_136_569 VPWR VGND VPWR VGND sky130_ef_sc_hd__decap_40_12
XPHY_EDGE_ROW_107_Left_246 VGND VGND VPWR VPWR sky130_fd_sc_hd__decap_3
X_5589_ _6297_/CLK _5589_/D VGND VGND VPWR VPWR _5589_/Q sky130_fd_sc_hd__dfxtp_1
X_4609_ _4792_/A1 _4604_/X _4606_/X _4608_/X VGND VGND VPWR VPWR _4609_/X sky130_fd_sc_hd__a22o_1
Xhold351 _5357_/Q VGND VGND VPWR VPWR hold351/X sky130_fd_sc_hd__dlygate4sd3_1
XFILLER_117_783 VGND VGND VPWR VPWR sky130_fd_sc_hd__fill_1
XFILLER_89_111 VGND VGND VPWR VPWR sky130_fd_sc_hd__fill_1
Xhold340 _3740_/X VGND VGND VPWR VPWR _5754_/D sky130_fd_sc_hd__dlygate4sd3_1
Xhold362 _4482_/X VGND VGND VPWR VPWR _6089_/D sky130_fd_sc_hd__dlygate4sd3_1
XFILLER_132_753 VGND VGND VPWR VPWR sky130_fd_sc_hd__fill_2
Xhold395 _6222_/Q VGND VGND VPWR VPWR hold395/X sky130_fd_sc_hd__dlygate4sd3_1
Xhold384 _4534_/X VGND VGND VPWR VPWR _6136_/D sky130_fd_sc_hd__dlygate4sd3_1
Xhold373 _6156_/Q VGND VGND VPWR VPWR hold373/X sky130_fd_sc_hd__dlygate4sd3_1
XTAP_TAPCELL_ROW_129_2233 VGND VPWR sky130_fd_sc_hd__tapvpwrvgnd_1
XFILLER_58_531 VGND VGND VPWR VPWR sky130_fd_sc_hd__fill_1
Xhold1040 _6063_/Q VGND VGND VPWR VPWR _4447_/A1 sky130_fd_sc_hd__dlygate4sd3_1
Xhold1051 _3536_/X VGND VGND VPWR VPWR _5579_/D sky130_fd_sc_hd__dlygate4sd3_1
XTAP_TAPCELL_ROW_51_1063 VGND VPWR sky130_fd_sc_hd__tapvpwrvgnd_1
XTAP_TAPCELL_ROW_5_376 VGND VPWR sky130_fd_sc_hd__tapvpwrvgnd_1
XFILLER_18_417 VGND VGND VPWR VPWR sky130_fd_sc_hd__fill_2
Xhold1062 _5377_/Q VGND VGND VPWR VPWR _3217_/A1 sky130_fd_sc_hd__dlygate4sd3_1
XPHY_EDGE_ROW_116_Left_255 VGND VGND VPWR VPWR sky130_fd_sc_hd__decap_3
Xhold1073 _4543_/X VGND VGND VPWR VPWR _6145_/D sky130_fd_sc_hd__dlygate4sd3_1
XFILLER_93_47 VGND VGND VPWR VPWR sky130_fd_sc_hd__fill_1
XANTENNA__2636__Y _2636_/Y VGND VGND VPWR VPWR sky130_fd_sc_hd__diode_2
Xhold1084 _5661_/Q VGND VGND VPWR VPWR _3633_/A0 sky130_fd_sc_hd__dlygate4sd3_1
XANTENNA__4056__S _4257_/S VGND VGND VPWR VPWR sky130_fd_sc_hd__diode_2
Xhold1095 _3713_/X VGND VGND VPWR VPWR _5733_/D sky130_fd_sc_hd__dlygate4sd3_1
XFILLER_14_601 VPWR VGND VPWR VGND sky130_ef_sc_hd__decap_40_12
XANTENNA__3895__S _3899_/S VGND VGND VPWR VPWR sky130_fd_sc_hd__diode_2
XFILLER_14_645 VPWR VGND VPWR VGND sky130_ef_sc_hd__decap_40_12
XFILLER_41_431 VGND VGND VPWR VPWR sky130_fd_sc_hd__fill_2
XANTENNA__4919__C1 _5200_/A VGND VGND VPWR VPWR sky130_fd_sc_hd__diode_2
XTAP_TAPCELL_ROW_24_662 VGND VPWR sky130_fd_sc_hd__tapvpwrvgnd_1
XFILLER_41_453 VGND VGND VPWR VPWR sky130_fd_sc_hd__fill_1
XANTENNA__3198__A1 _5241_/A1 VGND VGND VPWR VPWR sky130_fd_sc_hd__diode_2
XFILLER_9_137 VGND VGND VPWR VPWR sky130_fd_sc_hd__fill_1
XANTENNA__4395__A0 _4983_/A1 VGND VGND VPWR VPWR sky130_fd_sc_hd__diode_2
XFILLER_13_188 VGND VGND VPWR VPWR sky130_fd_sc_hd__fill_2
XFILLER_127_503 VGND VGND VPWR VPWR sky130_fd_sc_hd__fill_1
XFILLER_6_811 VGND VGND VPWR VPWR sky130_fd_sc_hd__fill_1
XPHY_EDGE_ROW_125_Left_264 VGND VGND VPWR VPWR sky130_fd_sc_hd__decap_3
XFILLER_115_709 VPWR VGND VPWR VGND sky130_ef_sc_hd__decap_40_12
XANTENNA__4698__A1 _4811_/A1 VGND VGND VPWR VPWR sky130_fd_sc_hd__diode_2
XFILLER_123_753 VPWR VGND VPWR VGND sky130_ef_sc_hd__decap_40_12
XFILLER_69_818 VGND VGND VPWR VPWR sky130_fd_sc_hd__fill_2
XANTENNA__3370__A1 _5840_/Q VGND VGND VPWR VPWR sky130_fd_sc_hd__diode_2
XFILLER_123_797 VPWR VGND VPWR VGND sky130_ef_sc_hd__decap_40_12
XFILLER_96_637 VGND VGND VPWR VPWR sky130_fd_sc_hd__fill_4
XANTENNA__3122__A1 _5233_/A0 VGND VGND VPWR VPWR sky130_fd_sc_hd__diode_2
XPHY_EDGE_ROW_134_Left_273 VGND VGND VPWR VPWR sky130_fd_sc_hd__decap_3
XFILLER_95_169 VGND VGND VPWR VPWR sky130_fd_sc_hd__fill_4
XFILLER_67_92 VGND VGND VPWR VPWR sky130_fd_sc_hd__fill_2
XANTENNA__4870__A1 _4883_/A1 VGND VGND VPWR VPWR sky130_fd_sc_hd__diode_2
XTAP_TAPCELL_ROW_69_1335 VGND VPWR sky130_fd_sc_hd__tapvpwrvgnd_1
XTAP_TAPCELL_ROW_82_1524 VGND VPWR sky130_fd_sc_hd__tapvpwrvgnd_1
XANTENNA__4622__A1 _4791_/A1 VGND VGND VPWR VPWR sky130_fd_sc_hd__diode_2
X_4960_ _5212_/A1 _4960_/A1 _4964_/S VGND VGND VPWR VPWR _4960_/X sky130_fd_sc_hd__mux2_1
XFILLER_17_461 VPWR VGND VPWR VGND sky130_ef_sc_hd__decap_40_12
X_4891_ _4891_/A0 _4904_/A0 _4893_/S VGND VGND VPWR VPWR _4891_/X sky130_fd_sc_hd__mux2_1
XTAP_TAPCELL_ROW_82_1535 VGND VPWR sky130_fd_sc_hd__tapvpwrvgnd_1
XANTENNA__3658__X _3667_/S VGND VGND VPWR VPWR sky130_fd_sc_hd__diode_2
X_3911_ _3911_/A0 _5209_/A1 _3918_/S VGND VGND VPWR VPWR _3911_/X sky130_fd_sc_hd__mux2_1
X_3842_ _3842_/A _3852_/B VGND VGND VPWR VPWR _3842_/X sky130_fd_sc_hd__or2_1
XFILLER_60_773 VPWR VGND VPWR VGND sky130_ef_sc_hd__decap_40_12
XFILLER_32_475 VGND VGND VPWR VPWR sky130_fd_sc_hd__fill_1
XANTENNA__3189__A1 _5233_/A0 VGND VGND VPWR VPWR sky130_fd_sc_hd__diode_2
XFILLER_20_637 VGND VGND VPWR VPWR sky130_fd_sc_hd__fill_4
X_5512_ _6222_/CLK hold56/X VGND VGND VPWR VPWR hold55/A sky130_fd_sc_hd__dfxtp_1
XFILLER_9_671 VGND VGND VPWR VPWR sky130_fd_sc_hd__fill_1
X_3773_ _5044_/A1 _3773_/A1 _3776_/S VGND VGND VPWR VPWR _3773_/X sky130_fd_sc_hd__mux2_1
XFILLER_118_525 VGND VGND VPWR VPWR sky130_fd_sc_hd__fill_4
XTAP_TAPCELL_ROW_113_2001 VGND VPWR sky130_fd_sc_hd__tapvpwrvgnd_1
X_2724_ _3030_/S _2727_/C _5222_/A VGND VGND VPWR VPWR _2724_/Y sky130_fd_sc_hd__a21oi_1
XFILLER_8_181 VGND VGND VPWR VPWR sky130_fd_sc_hd__fill_4
XFILLER_133_517 VPWR VGND VPWR VGND sky130_ef_sc_hd__decap_40_12
XFILLER_118_569 VPWR VGND VPWR VGND sky130_ef_sc_hd__decap_40_12
X_2655_ _2655_/A VGND VGND VPWR VPWR _2655_/Y sky130_fd_sc_hd__inv_2
X_5443_ _5731_/CLK _5443_/D VGND VGND VPWR VPWR _5443_/Q sky130_fd_sc_hd__dfxtp_1
XANTENNA__4138__B1 _4252_/B1 VGND VGND VPWR VPWR sky130_fd_sc_hd__diode_2
X_5374_ _6366_/CLK _5374_/D VGND VGND VPWR VPWR _5374_/Q sky130_fd_sc_hd__dfxtp_1
XFILLER_114_753 VGND VGND VPWR VPWR sky130_fd_sc_hd__fill_2
X_4325_ hold97/X _5047_/A1 _4325_/S VGND VGND VPWR VPWR hold98/A sky130_fd_sc_hd__mux2_1
XANTENNA__3045__S _3072_/S VGND VGND VPWR VPWR sky130_fd_sc_hd__diode_2
XFILLER_113_263 VGND VGND VPWR VPWR sky130_fd_sc_hd__fill_1
XFILLER_101_403 VGND VGND VPWR VPWR sky130_fd_sc_hd__fill_4
XTAP_TAPCELL_ROW_93_1697 VGND VPWR sky130_fd_sc_hd__tapvpwrvgnd_1
XFILLER_87_615 VGND VGND VPWR VPWR sky130_fd_sc_hd__fill_1
Xfanout116 hold2232/X VGND VGND VPWR VPWR _5228_/A0 sky130_fd_sc_hd__buf_4
Xfanout127 _5814_/Q VGND VGND VPWR VPWR _4904_/A0 sky130_fd_sc_hd__clkbuf_4
Xfanout105 hold2228/X VGND VGND VPWR VPWR _5042_/A1 sky130_fd_sc_hd__buf_4
Xfanout138 _2628_/A VGND VGND VPWR VPWR _4663_/A sky130_fd_sc_hd__buf_4
XFILLER_101_425 VGND VGND VPWR VPWR sky130_fd_sc_hd__fill_2
Xfanout149 _4713_/S VGND VGND VPWR VPWR _4810_/S sky130_fd_sc_hd__clkbuf_8
X_4256_ _5777_/Q _6035_/Q _4257_/S VGND VGND VPWR VPWR _4256_/X sky130_fd_sc_hd__mux2_1
X_3207_ _3207_/A _3207_/B _3207_/C VGND VGND VPWR VPWR _5069_/B sky130_fd_sc_hd__or3_4
XANTENNA__2884__S _3030_/S VGND VGND VPWR VPWR sky130_fd_sc_hd__diode_2
XANTENNA__4665__A _4802_/A VGND VGND VPWR VPWR sky130_fd_sc_hd__diode_2
X_4187_ _4183_/X _4185_/X _4186_/X _4252_/B1 VGND VGND VPWR VPWR _4187_/X sky130_fd_sc_hd__a22o_1
XFILLER_83_821 VPWR VGND VPWR VGND sky130_ef_sc_hd__decap_40_12
XTAP_TAPCELL_ROW_2_335 VGND VPWR sky130_fd_sc_hd__tapvpwrvgnd_1
XTAP_TAPCELL_ROW_2_324 VGND VPWR sky130_fd_sc_hd__tapvpwrvgnd_1
XFILLER_27_225 VGND VGND VPWR VPWR sky130_fd_sc_hd__fill_1
X_3138_ _4924_/C _3138_/B _5323_/Q VGND VGND VPWR VPWR _3708_/B sky130_fd_sc_hd__or3b_4
XTAP_TAPCELL_ROW_124_2163 VGND VPWR sky130_fd_sc_hd__tapvpwrvgnd_1
X_3069_ _2735_/A _3054_/X _3068_/X _2925_/S VGND VGND VPWR VPWR _3069_/X sky130_fd_sc_hd__o211a_1
XANTENNA__4613__A1 _4791_/A1 VGND VGND VPWR VPWR sky130_fd_sc_hd__diode_2
XANTENNA_fanout165_X _4237_/S VGND VGND VPWR VPWR sky130_fd_sc_hd__diode_2
XFILLER_51_773 VGND VGND VPWR VPWR sky130_fd_sc_hd__fill_8
XFILLER_11_615 VGND VGND VPWR VPWR sky130_fd_sc_hd__fill_1
XTAP_TAPCELL_ROW_41_908 VGND VPWR sky130_fd_sc_hd__tapvpwrvgnd_1
XTAP_TAPCELL_ROW_41_919 VGND VPWR sky130_fd_sc_hd__tapvpwrvgnd_1
XTAP_TAPCELL_ROW_21_610 VGND VPWR sky130_fd_sc_hd__tapvpwrvgnd_1
XTAP_TAPCELL_ROW_21_621 VGND VPWR sky130_fd_sc_hd__tapvpwrvgnd_1
XFILLER_109_503 VGND VGND VPWR VPWR sky130_fd_sc_hd__fill_1
XANTENNA_clkbuf_leaf_93_clk_A clkload2/A VGND VGND VPWR VPWR sky130_fd_sc_hd__diode_2
XFILLER_109_525 VPWR VGND VPWR VGND sky130_ef_sc_hd__decap_40_12
XFILLER_128_87 VGND VGND VPWR VPWR sky130_fd_sc_hd__fill_2
XFILLER_88_25 VGND VGND VPWR VPWR sky130_fd_sc_hd__fill_2
XFILLER_105_753 VPWR VGND VPWR VGND sky130_ef_sc_hd__decap_40_12
Xhold170 _4283_/X VGND VGND VPWR VPWR _5935_/D sky130_fd_sc_hd__dlygate4sd3_1
XFILLER_120_701 VPWR VGND VPWR VGND sky130_ef_sc_hd__decap_40_12
Xhold192 _3291_/X VGND VGND VPWR VPWR _5410_/D sky130_fd_sc_hd__dlygate4sd3_1
XFILLER_105_797 VPWR VGND VPWR VGND sky130_ef_sc_hd__decap_40_12
XFILLER_104_241 VGND VGND VPWR VPWR sky130_fd_sc_hd__fill_2
Xhold181 _6231_/Q VGND VGND VPWR VPWR hold181/X sky130_fd_sc_hd__dlygate4sd3_1
XANTENNA_clkbuf_leaf_31_clk_A clkload3/A VGND VGND VPWR VPWR sky130_fd_sc_hd__diode_2
XANTENNA_fanout78_X _3926_/A1 VGND VGND VPWR VPWR sky130_fd_sc_hd__diode_2
XANTENNA__3104__A1 _5241_/A1 VGND VGND VPWR VPWR sky130_fd_sc_hd__diode_2
XFILLER_93_629 VPWR VGND VPWR VGND sky130_ef_sc_hd__decap_40_12
XFILLER_74_810 VGND VGND VPWR VPWR sky130_fd_sc_hd__fill_2
XTAP_TAPCELL_ROW_109_1936 VGND VPWR sky130_fd_sc_hd__tapvpwrvgnd_1
XANTENNA__2863__B1 _3076_/A1 VGND VGND VPWR VPWR sky130_fd_sc_hd__diode_2
XTAP_TAPCELL_ROW_29_732 VGND VPWR sky130_fd_sc_hd__tapvpwrvgnd_1
XANTENNA_clkbuf_leaf_46_clk_A clkload4/A VGND VGND VPWR VPWR sky130_fd_sc_hd__diode_2
XFILLER_34_718 VGND VGND VPWR VPWR sky130_fd_sc_hd__fill_1
XFILLER_61_559 VGND VGND VPWR VPWR sky130_fd_sc_hd__fill_1
XTAP_TAPCELL_ROW_64_1265 VGND VPWR sky130_fd_sc_hd__tapvpwrvgnd_1
XTAP_TAPCELL_ROW_64_1254 VGND VPWR sky130_fd_sc_hd__tapvpwrvgnd_1
XANTENNA__4368__A0 _5051_/A1 VGND VGND VPWR VPWR sky130_fd_sc_hd__diode_2
XFILLER_14_475 VGND VGND VPWR VPWR sky130_fd_sc_hd__fill_1
XFILLER_10_681 VPWR VGND VPWR VGND sky130_ef_sc_hd__decap_40_12
XANTENNA_clkbuf_leaf_104_clk_A clkload0/A VGND VGND VPWR VPWR sky130_fd_sc_hd__diode_2
XANTENNA__2969__S _3072_/S VGND VGND VPWR VPWR sky130_fd_sc_hd__diode_2
XANTENNA__3591__A1 _4488_/A0 VGND VGND VPWR VPWR sky130_fd_sc_hd__diode_2
XFILLER_6_641 VGND VGND VPWR VPWR sky130_fd_sc_hd__fill_2
XFILLER_115_517 VPWR VGND VPWR VGND sky130_ef_sc_hd__decap_40_12
XANTENNA__3373__B input5/X VGND VGND VPWR VPWR sky130_fd_sc_hd__diode_2
XFILLER_123_561 VPWR VGND VPWR VGND sky130_ef_sc_hd__decap_40_12
XANTENNA__2994__A1_N _3096_/A1 VGND VGND VPWR VPWR sky130_fd_sc_hd__diode_2
XFILLER_69_615 VGND VGND VPWR VPWR sky130_fd_sc_hd__fill_1
X_5090_ _5090_/A0 _5090_/A1 _5094_/S VGND VGND VPWR VPWR _5090_/X sky130_fd_sc_hd__mux2_1
X_4110_ _6302_/Q _6284_/Q _4258_/S VGND VGND VPWR VPWR _4111_/B sky130_fd_sc_hd__mux2_1
Xhold1809 _5765_/Q VGND VGND VPWR VPWR _3752_/A1 sky130_fd_sc_hd__dlygate4sd3_1
XFILLER_56_309 VGND VGND VPWR VPWR sky130_fd_sc_hd__fill_1
X_4041_ _6272_/Q _6263_/Q _4258_/S VGND VGND VPWR VPWR _4041_/X sky130_fd_sc_hd__mux2_1
XANTENNA__5080__S _5081_/S VGND VGND VPWR VPWR sky130_fd_sc_hd__diode_2
XFILLER_83_139 VGND VGND VPWR VPWR sky130_fd_sc_hd__fill_4
XFILLER_77_670 VGND VGND VPWR VPWR sky130_fd_sc_hd__fill_2
XFILLER_65_821 VGND VGND VPWR VPWR sky130_fd_sc_hd__fill_4
XFILLER_76_180 VGND VGND VPWR VPWR sky130_fd_sc_hd__fill_1
Xi2c_master_axil_209 VGND VGND VPWR VPWR i2c_master_axil_209/HI s_axil_bresp[1] sky130_fd_sc_hd__conb_1
XFILLER_37_567 VGND VGND VPWR VPWR sky130_fd_sc_hd__fill_1
XFILLER_80_813 VPWR VGND VPWR VGND sky130_ef_sc_hd__decap_40_12
XFILLER_52_504 VGND VGND VPWR VPWR sky130_fd_sc_hd__fill_1
X_5992_ _6421_/CLK _5992_/D VGND VGND VPWR VPWR _5992_/Q sky130_fd_sc_hd__dfxtp_1
XFILLER_18_781 VPWR VGND VPWR VGND sky130_ef_sc_hd__decap_40_12
XFILLER_25_729 VGND VGND VPWR VPWR sky130_fd_sc_hd__fill_2
X_4943_ _4983_/A1 _4943_/A1 _4944_/S VGND VGND VPWR VPWR _4943_/X sky130_fd_sc_hd__mux2_1
XANTENNA__2733__A _5222_/A VGND VGND VPWR VPWR sky130_fd_sc_hd__diode_2
X_4874_ hold882/X _4887_/A1 _4880_/S VGND VGND VPWR VPWR _4874_/X sky130_fd_sc_hd__mux2_1
XFILLER_20_401 VPWR VGND VPWR VGND sky130_ef_sc_hd__decap_40_12
XANTENNA__5817__Q _5817_/Q VGND VGND VPWR VPWR sky130_fd_sc_hd__diode_2
X_3825_ input19/X _5052_/A1 _3835_/S VGND VGND VPWR VPWR _5824_/D sky130_fd_sc_hd__mux2_1
XFILLER_20_445 VPWR VGND VPWR VGND sky130_ef_sc_hd__decap_40_12
XANTENNA__2909__B2 _3089_/C1 VGND VGND VPWR VPWR sky130_fd_sc_hd__diode_2
XANTENNA_fanout125_A _5815_/Q VGND VGND VPWR VPWR sky130_fd_sc_hd__diode_2
XFILLER_20_489 VPWR VGND VPWR VGND sky130_ef_sc_hd__decap_40_12
X_3756_ _5324_/Q _5323_/Q _5322_/Q VGND VGND VPWR VPWR _4975_/B sky130_fd_sc_hd__or3_4
XTAP_TAPCELL_ROW_95_1726 VGND VPWR sky130_fd_sc_hd__tapvpwrvgnd_1
XANTENNA__3582__A1 _5214_/A1 VGND VGND VPWR VPWR sky130_fd_sc_hd__diode_2
X_2707_ _5050_/A _4965_/A VGND VGND VPWR VPWR _2716_/S sky130_fd_sc_hd__or2_4
XFILLER_134_837 VGND VGND VPWR VPWR sky130_fd_sc_hd__fill_4
X_5426_ _5753_/CLK _5426_/D VGND VGND VPWR VPWR _5426_/Q sky130_fd_sc_hd__dfxtp_1
X_3687_ _4521_/A1 _3687_/A1 _3688_/S VGND VGND VPWR VPWR _5709_/D sky130_fd_sc_hd__mux2_1
XTAP_TAPCELL_ROW_7_405 VGND VPWR sky130_fd_sc_hd__tapvpwrvgnd_1
X_2638_ _2638_/A VGND VGND VPWR VPWR _4924_/C sky130_fd_sc_hd__inv_2
X_5357_ _6148_/CLK _5357_/D VGND VGND VPWR VPWR _5357_/Q sky130_fd_sc_hd__dfxtp_1
XFILLER_102_701 VPWR VGND VPWR VGND sky130_ef_sc_hd__decap_40_12
XFILLER_101_222 VGND VGND VPWR VPWR sky130_fd_sc_hd__fill_2
X_5288_ _6172_/CLK _5288_/D VGND VGND VPWR VPWR _5288_/Q sky130_fd_sc_hd__dfxtp_1
X_4308_ hold651/X _5040_/A1 _4315_/S VGND VGND VPWR VPWR _4308_/X sky130_fd_sc_hd__mux2_1
XFILLER_75_607 VGND VGND VPWR VPWR sky130_fd_sc_hd__fill_1
X_4239_ _4149_/A _4234_/X _4236_/Y _4238_/Y VGND VGND VPWR VPWR _4239_/X sky130_fd_sc_hd__o2bb2a_1
XANTENNA__3503__S _3503_/S VGND VGND VPWR VPWR sky130_fd_sc_hd__diode_2
XFILLER_28_512 VGND VGND VPWR VPWR sky130_fd_sc_hd__fill_4
XANTENNA__2845__B1 _3096_/A1 VGND VGND VPWR VPWR sky130_fd_sc_hd__diode_2
XFILLER_71_813 VGND VGND VPWR VPWR sky130_fd_sc_hd__fill_2
XFILLER_15_228 VGND VGND VPWR VPWR sky130_fd_sc_hd__fill_1
XANTENNA__2643__A _3072_/S VGND VGND VPWR VPWR sky130_fd_sc_hd__diode_2
XTAP_TAPCELL_ROW_104_1866 VGND VPWR sky130_fd_sc_hd__tapvpwrvgnd_1
XTAP_TAPCELL_ROW_104_1855 VGND VPWR sky130_fd_sc_hd__tapvpwrvgnd_1
XFILLER_70_356 VGND VGND VPWR VPWR sky130_fd_sc_hd__fill_8
XFILLER_129_609 VGND VGND VPWR VPWR sky130_fd_sc_hd__fill_4
XFILLER_51_570 VGND VGND VPWR VPWR sky130_fd_sc_hd__fill_4
XFILLER_135_3 VPWR VGND VPWR VGND sky130_ef_sc_hd__decap_40_12
XFILLER_7_405 VPWR VGND VPWR VGND sky130_ef_sc_hd__decap_40_12
XFILLER_11_445 VGND VGND VPWR VPWR sky130_fd_sc_hd__fill_2
XFILLER_23_53 VGND VGND VPWR VPWR sky130_fd_sc_hd__fill_2
XPHY_EDGE_ROW_137_Right_137 VGND VGND VPWR VPWR sky130_fd_sc_hd__decap_3
XTAP_TAPCELL_ROW_137_2354 VGND VPWR sky130_fd_sc_hd__tapvpwrvgnd_1
XANTENNA__3022__B1 _3094_/C1 VGND VGND VPWR VPWR sky130_fd_sc_hd__diode_2
XFILLER_109_300 VGND VGND VPWR VPWR sky130_fd_sc_hd__fill_4
XFILLER_7_449 VPWR VGND VPWR VGND sky130_ef_sc_hd__decap_40_12
XFILLER_137_653 VPWR VGND VPWR VGND sky130_ef_sc_hd__decap_40_12
XANTENNA__3573__A1 _4521_/A1 VGND VGND VPWR VPWR sky130_fd_sc_hd__diode_2
XFILLER_137_697 VPWR VGND VPWR VGND sky130_ef_sc_hd__decap_40_12
XFILLER_125_837 VGND VGND VPWR VPWR sky130_fd_sc_hd__fill_2
XFILLER_99_57 VGND VGND VPWR VPWR sky130_fd_sc_hd__fill_1
XANTENNA__4748__S1 _4802_/A VGND VGND VPWR VPWR sky130_fd_sc_hd__diode_2
XFILLER_105_561 VPWR VGND VPWR VGND sky130_ef_sc_hd__decap_40_12
XFILLER_38_309 VGND VGND VPWR VPWR sky130_fd_sc_hd__fill_2
XFILLER_47_821 VPWR VGND VPWR VGND sky130_ef_sc_hd__decap_40_12
XFILLER_19_501 VGND VGND VPWR VPWR sky130_fd_sc_hd__fill_2
XFILLER_62_813 VPWR VGND VPWR VGND sky130_ef_sc_hd__decap_40_12
XFILLER_0_57 VPWR VGND VPWR VGND sky130_ef_sc_hd__decap_40_12
XFILLER_61_334 VGND VGND VPWR VPWR sky130_fd_sc_hd__fill_2
XFILLER_21_209 VGND VGND VPWR VPWR sky130_fd_sc_hd__fill_2
XPHY_EDGE_ROW_104_Right_104 VGND VGND VPWR VPWR sky130_fd_sc_hd__decap_3
X_3610_ hold443/X _5210_/A1 _3616_/S VGND VGND VPWR VPWR _3610_/X sky130_fd_sc_hd__mux2_1
X_4590_ _4676_/A _4590_/B VGND VGND VPWR VPWR _4590_/Y sky130_fd_sc_hd__nor2_1
X_3541_ hold248/X _5237_/A0 _3541_/S VGND VGND VPWR VPWR _3541_/X sky130_fd_sc_hd__mux2_1
XTAP_TAPCELL_ROW_12_473 VGND VPWR sky130_fd_sc_hd__tapvpwrvgnd_1
XTAP_TAPCELL_ROW_12_484 VGND VPWR sky130_fd_sc_hd__tapvpwrvgnd_1
XANTENNA__5075__S _5081_/S VGND VGND VPWR VPWR sky130_fd_sc_hd__diode_2
XFILLER_128_697 VGND VGND VPWR VPWR sky130_fd_sc_hd__fill_2
XFILLER_116_837 VGND VGND VPWR VPWR sky130_fd_sc_hd__fill_4
Xhold906 _6186_/Q VGND VGND VPWR VPWR hold906/X sky130_fd_sc_hd__dlygate4sd3_1
XANTENNA__2772__C1 _3089_/C1 VGND VGND VPWR VPWR sky130_fd_sc_hd__diode_2
Xhold917 _3595_/X VGND VGND VPWR VPWR _5629_/D sky130_fd_sc_hd__dlygate4sd3_1
XTAP_TAPCELL_ROW_77_1456 VGND VPWR sky130_fd_sc_hd__tapvpwrvgnd_1
Xhold928 _5468_/Q VGND VGND VPWR VPWR hold928/X sky130_fd_sc_hd__dlygate4sd3_1
Xhold939 _4895_/X VGND VGND VPWR VPWR _6243_/D sky130_fd_sc_hd__dlygate4sd3_1
X_3472_ _4901_/A0 _3472_/A1 _3477_/S VGND VGND VPWR VPWR _3472_/X sky130_fd_sc_hd__mux2_1
X_6260_ _6404_/CLK _6260_/D VGND VGND VPWR VPWR _6260_/Q sky130_fd_sc_hd__dfxtp_1
XFILLER_50_3 VGND VGND VPWR VPWR sky130_fd_sc_hd__fill_1
XFILLER_88_209 VGND VGND VPWR VPWR sky130_fd_sc_hd__fill_1
X_6191_ _6239_/CLK _6191_/D VGND VGND VPWR VPWR _6191_/Q sky130_fd_sc_hd__dfxtp_1
X_5211_ _5211_/A0 _5211_/A1 _5213_/S VGND VGND VPWR VPWR _6413_/D sky130_fd_sc_hd__mux2_1
XFILLER_97_721 VGND VGND VPWR VPWR sky130_fd_sc_hd__fill_4
XTAP_TAPCELL_ROW_90_1656 VGND VPWR sky130_fd_sc_hd__tapvpwrvgnd_1
XTAP_TAPCELL_ROW_90_1645 VGND VPWR sky130_fd_sc_hd__tapvpwrvgnd_1
X_5142_ _5142_/A _5142_/B VGND VGND VPWR VPWR _5142_/Y sky130_fd_sc_hd__nand2_1
Xhold1617 _5403_/Q VGND VGND VPWR VPWR _3284_/A0 sky130_fd_sc_hd__dlygate4sd3_1
XFILLER_111_553 VGND VGND VPWR VPWR sky130_fd_sc_hd__fill_4
XFILLER_97_765 VPWR VGND VPWR VGND sky130_ef_sc_hd__decap_40_12
Xhold1606 _5634_/Q VGND VGND VPWR VPWR _3601_/A0 sky130_fd_sc_hd__dlygate4sd3_1
X_5073_ _5241_/A1 _5073_/A1 _5081_/S VGND VGND VPWR VPWR _6364_/D sky130_fd_sc_hd__mux2_1
XFILLER_111_597 VPWR VGND VPWR VGND sky130_ef_sc_hd__decap_40_12
XFILLER_96_297 VGND VGND VPWR VPWR sky130_fd_sc_hd__fill_1
XANTENNA__2728__A _5222_/A VGND VGND VPWR VPWR sky130_fd_sc_hd__diode_2
Xhold1628 _4964_/X VGND VGND VPWR VPWR _6298_/D sky130_fd_sc_hd__dlygate4sd3_1
Xhold1639 _3511_/X VGND VGND VPWR VPWR _5555_/D sky130_fd_sc_hd__dlygate4sd3_1
XFILLER_38_810 VGND VGND VPWR VPWR sky130_fd_sc_hd__fill_2
XFILLER_56_139 VGND VGND VPWR VPWR sky130_fd_sc_hd__fill_1
X_4024_ _3172_/B _4019_/X _4023_/X VGND VGND VPWR VPWR _4024_/Y sky130_fd_sc_hd__a21oi_1
XTAP_TAPCELL_ROW_121_2111 VGND VPWR sky130_fd_sc_hd__tapvpwrvgnd_1
XTAP_TAPCELL_ROW_121_2122 VGND VPWR sky130_fd_sc_hd__tapvpwrvgnd_1
XFILLER_25_537 VGND VGND VPWR VPWR sky130_fd_sc_hd__fill_1
XFILLER_25_559 VGND VGND VPWR VPWR sky130_fd_sc_hd__fill_1
XANTENNA__5241__A1 _5241_/A1 VGND VGND VPWR VPWR sky130_fd_sc_hd__diode_2
X_5975_ _6341_/CLK _5975_/D VGND VGND VPWR VPWR _5975_/Q sky130_fd_sc_hd__dfxtp_1
X_4926_ hold829/X _4976_/A1 _4934_/S VGND VGND VPWR VPWR _4926_/X sky130_fd_sc_hd__mux2_1
XFILLER_40_529 VGND VGND VPWR VPWR sky130_fd_sc_hd__fill_1
X_4857_ _4883_/A1 _4857_/A1 _4867_/S VGND VGND VPWR VPWR _6208_/D sky130_fd_sc_hd__mux2_1
XFILLER_21_765 VPWR VGND VPWR VGND sky130_ef_sc_hd__decap_40_12
X_3808_ input22/X _5235_/A0 _3810_/S VGND VGND VPWR VPWR _5814_/D sky130_fd_sc_hd__mux2_1
XTAP_TAPCELL_ROW_31_760 VGND VPWR sky130_fd_sc_hd__tapvpwrvgnd_1
XTAP_TAPCELL_ROW_31_771 VGND VPWR sky130_fd_sc_hd__tapvpwrvgnd_1
XFILLER_119_653 VPWR VGND VPWR VGND sky130_ef_sc_hd__decap_40_12
XTAP_TAPCELL_ROW_119_2084 VGND VPWR sky130_fd_sc_hd__tapvpwrvgnd_1
X_4788_ hold813/X _4964_/A1 _4790_/S VGND VGND VPWR VPWR _4789_/B sky130_fd_sc_hd__mux2_1
XANTENNA_fanout128_X _5234_/A0 VGND VGND VPWR VPWR sky130_fd_sc_hd__diode_2
XANTENNA__3565__Y _3574_/S VGND VGND VPWR VPWR sky130_fd_sc_hd__diode_2
XFILLER_134_601 VPWR VGND VPWR VGND sky130_ef_sc_hd__decap_40_12
XFILLER_119_697 VPWR VGND VPWR VGND sky130_ef_sc_hd__decap_40_12
XFILLER_107_837 VGND VGND VPWR VPWR sky130_fd_sc_hd__fill_2
X_3739_ _3739_/A0 _5075_/A0 _3745_/S VGND VGND VPWR VPWR _3739_/X sky130_fd_sc_hd__mux2_1
XFILLER_4_419 VGND VGND VPWR VPWR sky130_fd_sc_hd__fill_1
XFILLER_134_645 VPWR VGND VPWR VGND sky130_ef_sc_hd__decap_40_12
XFILLER_133_111 VGND VGND VPWR VPWR sky130_fd_sc_hd__fill_1
XTAP_TAPCELL_ROW_132_2273 VGND VPWR sky130_fd_sc_hd__tapvpwrvgnd_1
XTAP_TAPCELL_ROW_132_2284 VGND VPWR sky130_fd_sc_hd__tapvpwrvgnd_1
XFILLER_133_144 VGND VGND VPWR VPWR sky130_fd_sc_hd__fill_1
X_5409_ _6252_/CLK _5409_/D VGND VGND VPWR VPWR _5409_/Q sky130_fd_sc_hd__dfxtp_1
XANTENNA__3307__A1 _5080_/A0 VGND VGND VPWR VPWR sky130_fd_sc_hd__diode_2
Xclkload90 _6236_/CLK VGND VGND VPWR VPWR clkload90/Y sky130_fd_sc_hd__inv_12
X_6389_ _6405_/CLK _6389_/D VGND VGND VPWR VPWR _6389_/Q sky130_fd_sc_hd__dfxtp_1
XFILLER_102_531 VGND VGND VPWR VPWR sky130_fd_sc_hd__fill_1
XFILLER_125_66 VGND VGND VPWR VPWR sky130_fd_sc_hd__fill_4
XFILLER_48_618 VGND VGND VPWR VPWR sky130_fd_sc_hd__fill_8
XFILLER_0_669 VGND VGND VPWR VPWR sky130_fd_sc_hd__fill_2
XFILLER_47_117 VGND VGND VPWR VPWR sky130_fd_sc_hd__fill_1
XFILLER_29_821 VPWR VGND VPWR VGND sky130_ef_sc_hd__decap_40_12
XTAP_TAPCELL_ROW_48_1013 VGND VPWR sky130_fd_sc_hd__tapvpwrvgnd_1
XFILLER_44_813 VPWR VGND VPWR VGND sky130_ef_sc_hd__decap_40_12
XTAP_TAPCELL_ROW_48_1024 VGND VPWR sky130_fd_sc_hd__tapvpwrvgnd_1
XFILLER_28_397 VPWR VGND VPWR VGND sky130_ef_sc_hd__decap_40_12
XTAP_TAPCELL_ROW_39_882 VGND VPWR sky130_fd_sc_hd__tapvpwrvgnd_1
XFILLER_70_153 VGND VGND VPWR VPWR sky130_fd_sc_hd__fill_2
XTAP_TAPCELL_ROW_61_1213 VGND VPWR sky130_fd_sc_hd__tapvpwrvgnd_1
XANTENNA__4064__S _4262_/S VGND VGND VPWR VPWR sky130_fd_sc_hd__diode_2
XANTENNA__3794__A1 _4961_/A0 VGND VGND VPWR VPWR sky130_fd_sc_hd__diode_2
XFILLER_129_439 VGND VGND VPWR VPWR sky130_fd_sc_hd__fill_1
XFILLER_8_725 VPWR VGND VPWR VGND sky130_ef_sc_hd__decap_40_12
XFILLER_7_202 VGND VGND VPWR VPWR sky130_fd_sc_hd__fill_1
XANTENNA__3546__A1 _4958_/A0 VGND VGND VPWR VPWR sky130_fd_sc_hd__diode_2
XFILLER_8_769 VPWR VGND VPWR VGND sky130_ef_sc_hd__decap_40_12
XFILLER_137_461 VPWR VGND VPWR VGND sky130_ef_sc_hd__decap_40_12
XFILLER_50_62 VGND VGND VPWR VPWR sky130_fd_sc_hd__fill_4
XTAP_TAPCELL_ROW_59_1186 VGND VPWR sky130_fd_sc_hd__tapvpwrvgnd_1
XANTENNA__3491__X _3503_/S VGND VGND VPWR VPWR sky130_fd_sc_hd__diode_2
XFILLER_3_485 VPWR VGND VPWR VGND sky130_ef_sc_hd__decap_40_12
XFILLER_105_391 VGND VGND VPWR VPWR sky130_fd_sc_hd__fill_1
XTAP_TAPCELL_ROW_72_1386 VGND VPWR sky130_fd_sc_hd__tapvpwrvgnd_1
XTAP_TAPCELL_ROW_72_1375 VGND VPWR sky130_fd_sc_hd__tapvpwrvgnd_1
XFILLER_94_713 VPWR VGND VPWR VGND sky130_ef_sc_hd__decap_40_12
XFILLER_94_757 VPWR VGND VPWR VGND sky130_ef_sc_hd__decap_40_12
XFILLER_93_223 VGND VGND VPWR VPWR sky130_fd_sc_hd__fill_1
XFILLER_50_805 VGND VGND VPWR VPWR sky130_fd_sc_hd__fill_4
XTAP_TAPCELL_ROW_17_554 VGND VPWR sky130_fd_sc_hd__tapvpwrvgnd_1
X_2972_ _3052_/A1 _2971_/X _3075_/C1 VGND VGND VPWR VPWR _2972_/X sky130_fd_sc_hd__o21a_1
XFILLER_98_3 VPWR VGND VPWR VGND sky130_ef_sc_hd__decap_40_12
X_5760_ _6310_/CLK _5760_/D VGND VGND VPWR VPWR _5760_/Q sky130_fd_sc_hd__dfxtp_1
X_4711_ hold365/X _5689_/Q _4795_/S VGND VGND VPWR VPWR _4711_/X sky130_fd_sc_hd__mux2_1
X_5691_ _6097_/CLK _5691_/D VGND VGND VPWR VPWR _5691_/Q sky130_fd_sc_hd__dfxtp_1
XANTENNA__3785__A1 _5214_/A1 VGND VGND VPWR VPWR sky130_fd_sc_hd__diode_2
XANTENNA__4702__S _5401_/Q VGND VGND VPWR VPWR sky130_fd_sc_hd__diode_2
X_4642_ _4811_/A1 _4641_/X _4663_/A VGND VGND VPWR VPWR _4642_/Y sky130_fd_sc_hd__o21ai_1
XANTENNA__3537__A1 _5233_/A0 VGND VGND VPWR VPWR sky130_fd_sc_hd__diode_2
XFILLER_116_601 VPWR VGND VPWR VGND sky130_ef_sc_hd__decap_40_12
Xhold703 _3437_/X VGND VGND VPWR VPWR _5488_/D sky130_fd_sc_hd__dlygate4sd3_1
XANTENNA__4734__B1 _4791_/B1 VGND VGND VPWR VPWR sky130_fd_sc_hd__diode_2
X_4573_ _4791_/B1 _4572_/X _4569_/Y _4571_/Y VGND VGND VPWR VPWR _4574_/B sky130_fd_sc_hd__o2bb2a_1
X_3524_ _4901_/A0 _3524_/A1 _3529_/S VGND VGND VPWR VPWR _3524_/X sky130_fd_sc_hd__mux2_1
XFILLER_116_645 VPWR VGND VPWR VGND sky130_ef_sc_hd__decap_40_12
Xhold714 _5476_/Q VGND VGND VPWR VPWR hold714/X sky130_fd_sc_hd__dlygate4sd3_1
Xhold725 _3888_/X VGND VGND VPWR VPWR _5868_/D sky130_fd_sc_hd__dlygate4sd3_1
Xhold736 _4289_/X VGND VGND VPWR VPWR _5940_/D sky130_fd_sc_hd__dlygate4sd3_1
X_6312_ _6312_/CLK _6312_/D VGND VGND VPWR VPWR _6312_/Q sky130_fd_sc_hd__dfxtp_1
X_3455_ hold857/X _5241_/A1 _3463_/S VGND VGND VPWR VPWR _3455_/X sky130_fd_sc_hd__mux2_1
XFILLER_131_615 VGND VGND VPWR VPWR sky130_fd_sc_hd__fill_1
X_6243_ _6435_/CLK _6243_/D VGND VGND VPWR VPWR _6243_/Q sky130_fd_sc_hd__dfxtp_1
Xhold769 _6180_/Q VGND VGND VPWR VPWR hold769/X sky130_fd_sc_hd__dlygate4sd3_1
Xhold758 _3430_/X VGND VGND VPWR VPWR _5481_/D sky130_fd_sc_hd__dlygate4sd3_1
XFILLER_89_507 VGND VGND VPWR VPWR sky130_fd_sc_hd__fill_2
Xhold747 _6112_/Q VGND VGND VPWR VPWR hold747/X sky130_fd_sc_hd__dlygate4sd3_1
XANTENNA_clkbuf_3_0__f_clk_X clkload0/A VGND VGND VPWR VPWR sky130_fd_sc_hd__diode_2
XFILLER_39_19 VGND VGND VPWR VPWR sky130_fd_sc_hd__fill_2
Xhold2104 _2687_/X VGND VGND VPWR VPWR _5253_/D sky130_fd_sc_hd__dlygate4sd3_1
X_6174_ _6238_/CLK _6174_/D VGND VGND VPWR VPWR _6174_/Q sky130_fd_sc_hd__dfxtp_1
XFILLER_97_540 VPWR VGND VPWR VGND sky130_ef_sc_hd__decap_40_12
Xhold2115 _6256_/Q VGND VGND VPWR VPWR _5172_/A1 sky130_fd_sc_hd__dlygate4sd3_1
Xhold2126 _6399_/Q VGND VGND VPWR VPWR _5173_/A sky130_fd_sc_hd__dlygate4sd3_1
X_3386_ hold698/X _5043_/A1 _3390_/S VGND VGND VPWR VPWR _3386_/X sky130_fd_sc_hd__mux2_1
XANTENNA_fanout192_A _3016_/S VGND VGND VPWR VPWR sky130_fd_sc_hd__diode_2
XFILLER_97_573 VPWR VGND VPWR VGND sky130_ef_sc_hd__decap_40_12
Xhold1403 _5849_/Q VGND VGND VPWR VPWR _3867_/A1 sky130_fd_sc_hd__dlygate4sd3_1
X_5125_ _5126_/A1 _5124_/X _5160_/A VGND VGND VPWR VPWR _5125_/Y sky130_fd_sc_hd__o21ai_1
Xhold1425 _5640_/Q VGND VGND VPWR VPWR _3609_/A0 sky130_fd_sc_hd__dlygate4sd3_1
Xhold2159 _5115_/X VGND VGND VPWR VPWR _6388_/D sky130_fd_sc_hd__dlygate4sd3_1
XANTENNA__5830__Q _5830_/Q VGND VGND VPWR VPWR sky130_fd_sc_hd__diode_2
Xhold2148 _5831_/Q VGND VGND VPWR VPWR _3128_/B sky130_fd_sc_hd__dlygate4sd3_1
XFILLER_57_426 VGND VGND VPWR VPWR sky130_fd_sc_hd__fill_2
Xhold2137 _5032_/X VGND VGND VPWR VPWR _6331_/D sky130_fd_sc_hd__dlygate4sd3_1
Xhold1414 _3712_/X VGND VGND VPWR VPWR _5732_/D sky130_fd_sc_hd__dlygate4sd3_1
Xhold1458 _5543_/Q VGND VGND VPWR VPWR _3498_/A1 sky130_fd_sc_hd__dlygate4sd3_1
Xhold1436 _3500_/X VGND VGND VPWR VPWR _5545_/D sky130_fd_sc_hd__dlygate4sd3_1
XFILLER_57_437 VGND VGND VPWR VPWR sky130_fd_sc_hd__fill_4
Xhold1447 _6034_/Q VGND VGND VPWR VPWR _4395_/A1 sky130_fd_sc_hd__dlygate4sd3_1
X_5056_ hold240/X _5828_/Q _5059_/S VGND VGND VPWR VPWR _5056_/X sky130_fd_sc_hd__mux2_1
XANTENNA__3473__A0 _4889_/A1 VGND VGND VPWR VPWR sky130_fd_sc_hd__diode_2
XFILLER_72_418 VGND VGND VPWR VPWR sky130_fd_sc_hd__fill_2
XFILLER_72_407 VGND VGND VPWR VPWR sky130_fd_sc_hd__fill_1
X_4007_ _4007_/A _4007_/B _4006_/Y VGND VGND VPWR VPWR _4007_/X sky130_fd_sc_hd__or3b_1
XFILLER_26_813 VPWR VGND VPWR VGND sky130_ef_sc_hd__decap_40_12
Xhold1469 _5893_/Q VGND VGND VPWR VPWR _3915_/A0 sky130_fd_sc_hd__dlygate4sd3_1
XFILLER_38_695 VGND VGND VPWR VPWR sky130_fd_sc_hd__fill_2
XANTENNA__4648__S0 _4773_/S VGND VGND VPWR VPWR sky130_fd_sc_hd__diode_2
XANTENNA__5214__A1 _5214_/A1 VGND VGND VPWR VPWR sky130_fd_sc_hd__diode_2
XTAP_TAPCELL_ROW_36_841 VGND VPWR sky130_fd_sc_hd__tapvpwrvgnd_1
XTAP_TAPCELL_ROW_101_1814 VGND VPWR sky130_fd_sc_hd__tapvpwrvgnd_1
XFILLER_13_529 VPWR VGND VPWR VGND sky130_ef_sc_hd__decap_40_12
XFILLER_25_389 VGND VGND VPWR VPWR sky130_fd_sc_hd__fill_2
X_5958_ clkload8/A _5958_/D VGND VGND VPWR VPWR _5958_/Q sky130_fd_sc_hd__dfxtp_1
XFILLER_40_304 VGND VGND VPWR VPWR sky130_fd_sc_hd__fill_1
X_4909_ _4909_/A1 _4907_/Y _4908_/X _5176_/A VGND VGND VPWR VPWR _6255_/D sky130_fd_sc_hd__o211a_1
XANTENNA__4973__A0 _4983_/A1 VGND VGND VPWR VPWR sky130_fd_sc_hd__diode_2
XFILLER_138_225 VGND VGND VPWR VPWR sky130_fd_sc_hd__fill_1
XANTENNA__4612__S _4778_/S VGND VGND VPWR VPWR sky130_fd_sc_hd__diode_2
X_5889_ _6418_/CLK _5889_/D VGND VGND VPWR VPWR _5889_/Q sky130_fd_sc_hd__dfxtp_1
XFILLER_21_573 VPWR VGND VPWR VGND sky130_ef_sc_hd__decap_40_12
XTAP_TAPCELL_ROW_134_2313 VGND VPWR sky130_fd_sc_hd__tapvpwrvgnd_1
XFILLER_122_637 VGND VGND VPWR VPWR sky130_fd_sc_hd__fill_4
XFILLER_136_87 VGND VGND VPWR VPWR sky130_fd_sc_hd__fill_1
XFILLER_121_136 VGND VGND VPWR VPWR sky130_fd_sc_hd__fill_8
XTAP_TAPCELL_ROW_112_1987 VGND VPWR sky130_fd_sc_hd__tapvpwrvgnd_1
XTAP_TAPCELL_ROW_112_1976 VGND VPWR sky130_fd_sc_hd__tapvpwrvgnd_1
XFILLER_130_681 VPWR VGND VPWR VGND sky130_ef_sc_hd__decap_40_12
XFILLER_121_169 VGND VGND VPWR VPWR sky130_fd_sc_hd__fill_1
XFILLER_76_735 VGND VGND VPWR VPWR sky130_fd_sc_hd__fill_1
Xhold41 hold41/A VGND VGND VPWR VPWR hold41/X sky130_fd_sc_hd__dlygate4sd3_1
XFILLER_0_477 VPWR VGND VPWR VGND sky130_ef_sc_hd__decap_40_12
Xhold30 hold30/A VGND VGND VPWR VPWR hold30/X sky130_fd_sc_hd__dlygate4sd3_1
Xhold52 hold52/A VGND VGND VPWR VPWR hold52/X sky130_fd_sc_hd__dlygate4sd3_1
XFILLER_76_757 VGND VGND VPWR VPWR sky130_fd_sc_hd__fill_2
XFILLER_75_245 VGND VGND VPWR VPWR sky130_fd_sc_hd__fill_2
Xhold74 hold74/A VGND VGND VPWR VPWR hold74/X sky130_fd_sc_hd__dlygate4sd3_1
Xhold63 hold63/A VGND VGND VPWR VPWR hold63/X sky130_fd_sc_hd__dlygate4sd3_1
XFILLER_91_727 VGND VGND VPWR VPWR sky130_fd_sc_hd__fill_1
Xhold85 hold85/A VGND VGND VPWR VPWR hold85/X sky130_fd_sc_hd__dlygate4sd3_1
Xhold1970 _5332_/Q VGND VGND VPWR VPWR _5062_/A0 sky130_fd_sc_hd__dlygate4sd3_1
XFILLER_76_779 VPWR VGND VPWR VGND sky130_ef_sc_hd__decap_40_12
XANTENNA_input18_A s_axil_wdata[15] VGND VGND VPWR VPWR sky130_fd_sc_hd__diode_2
XANTENNA__3898__S _3899_/S VGND VGND VPWR VPWR sky130_fd_sc_hd__diode_2
Xhold96 hold96/A VGND VGND VPWR VPWR hold96/X sky130_fd_sc_hd__dlygate4sd3_1
XFILLER_29_673 VGND VGND VPWR VPWR sky130_fd_sc_hd__fill_4
Xhold1981 _4077_/X VGND VGND VPWR VPWR _5920_/D sky130_fd_sc_hd__dlygate4sd3_1
XANTENNA__4661__C1 _5401_/Q VGND VGND VPWR VPWR sky130_fd_sc_hd__diode_2
XFILLER_16_323 VGND VGND VPWR VPWR sky130_fd_sc_hd__fill_1
Xhold1992 _4047_/X VGND VGND VPWR VPWR _5919_/D sky130_fd_sc_hd__dlygate4sd3_1
XFILLER_44_643 VGND VGND VPWR VPWR sky130_fd_sc_hd__fill_1
XFILLER_32_805 VGND VGND VPWR VPWR sky130_fd_sc_hd__fill_4
XANTENNA__3216__A0 _5233_/A0 VGND VGND VPWR VPWR sky130_fd_sc_hd__diode_2
XFILLER_71_473 VGND VGND VPWR VPWR sky130_fd_sc_hd__fill_1
XTAP_TAPCELL_ROW_14_513 VGND VPWR sky130_fd_sc_hd__tapvpwrvgnd_1
XANTENNA__4964__A0 _4964_/A0 VGND VGND VPWR VPWR sky130_fd_sc_hd__diode_2
XFILLER_61_61 VGND VGND VPWR VPWR sky130_fd_sc_hd__fill_1
XFILLER_129_236 VGND VGND VPWR VPWR sky130_fd_sc_hd__fill_1
XFILLER_77_8 VGND VGND VPWR VPWR sky130_fd_sc_hd__fill_4
XFILLER_8_533 VPWR VGND VPWR VGND sky130_ef_sc_hd__decap_40_12
XTAP_TAPCELL_ROW_74_1404 VGND VPWR sky130_fd_sc_hd__tapvpwrvgnd_1
XFILLER_113_615 VGND VGND VPWR VPWR sky130_fd_sc_hd__fill_1
XTAP_TAPCELL_ROW_74_1415 VGND VPWR sky130_fd_sc_hd__tapvpwrvgnd_1
X_3240_ _3243_/C _3240_/B VGND VGND VPWR VPWR _3240_/Y sky130_fd_sc_hd__nor2_1
XFILLER_94_510 VPWR VGND VPWR VGND sky130_ef_sc_hd__decap_40_12
X_3171_ _3171_/A _3171_/B VGND VGND VPWR VPWR _5341_/D sky130_fd_sc_hd__nor2_1
XFILLER_13_3 VPWR VGND VPWR VGND sky130_ef_sc_hd__decap_40_12
XFILLER_94_587 VGND VGND VPWR VPWR sky130_fd_sc_hd__fill_1
XFILLER_67_779 VGND VGND VPWR VPWR sky130_fd_sc_hd__fill_4
XFILLER_66_267 VGND VGND VPWR VPWR sky130_fd_sc_hd__fill_1
XFILLER_62_451 VGND VGND VPWR VPWR sky130_fd_sc_hd__fill_1
XFILLER_90_793 VPWR VGND VPWR VGND sky130_ef_sc_hd__decap_40_12
XTAP_TAPCELL_ROW_85_1577 VGND VPWR sky130_fd_sc_hd__tapvpwrvgnd_1
X_5812_ _5841_/CLK _5812_/D VGND VGND VPWR VPWR _5812_/Q sky130_fd_sc_hd__dfxtp_2
XTAP_TAPCELL_ROW_33_800 VGND VPWR sky130_fd_sc_hd__tapvpwrvgnd_1
XFILLER_50_668 VGND VGND VPWR VPWR sky130_fd_sc_hd__fill_2
XANTENNA__3758__A1 _4976_/A1 VGND VGND VPWR VPWR sky130_fd_sc_hd__diode_2
XFILLER_22_359 VGND VGND VPWR VPWR sky130_fd_sc_hd__fill_4
X_5743_ clkload8/A _5743_/D VGND VGND VPWR VPWR _5743_/Q sky130_fd_sc_hd__dfxtp_1
X_2955_ _6238_/Q _6214_/Q _6157_/Q _6226_/Q _3091_/S _3005_/A VGND VGND VPWR VPWR
+ _2955_/X sky130_fd_sc_hd__mux4_1
X_2886_ hold203/X hold665/X _3030_/S VGND VGND VPWR VPWR _2886_/X sky130_fd_sc_hd__mux2_1
X_5674_ _5714_/CLK _5674_/D VGND VGND VPWR VPWR _5674_/Q sky130_fd_sc_hd__dfxtp_1
XFILLER_129_781 VGND VGND VPWR VPWR sky130_fd_sc_hd__fill_2
XTAP_TAPCELL_ROW_116_2043 VGND VPWR sky130_fd_sc_hd__tapvpwrvgnd_1
XANTENNA__4707__B1 _4791_/B1 VGND VGND VPWR VPWR sky130_fd_sc_hd__diode_2
X_4625_ _4794_/A _4625_/B VGND VGND VPWR VPWR _4625_/Y sky130_fd_sc_hd__nor2_1
XANTENNA__5825__Q _5825_/Q VGND VGND VPWR VPWR sky130_fd_sc_hd__diode_2
Xhold511 _5346_/Q VGND VGND VPWR VPWR hold511/X sky130_fd_sc_hd__dlygate4sd3_1
X_4556_ hold373/X _4901_/A0 _4561_/S VGND VGND VPWR VPWR _4556_/X sky130_fd_sc_hd__mux2_1
Xhold500 _3304_/X VGND VGND VPWR VPWR _5422_/D sky130_fd_sc_hd__dlygate4sd3_1
X_3507_ _5819_/Q _3507_/A1 _3516_/S VGND VGND VPWR VPWR _3507_/X sky130_fd_sc_hd__mux2_1
Xhold522 _6128_/Q VGND VGND VPWR VPWR hold522/X sky130_fd_sc_hd__dlygate4sd3_1
Xhold544 _5345_/Q VGND VGND VPWR VPWR hold544/X sky130_fd_sc_hd__dlygate4sd3_1
XANTENNA_fanout205_A _5222_/A VGND VGND VPWR VPWR sky130_fd_sc_hd__diode_2
Xhold533 _4991_/X VGND VGND VPWR VPWR _6323_/D sky130_fd_sc_hd__dlygate4sd3_1
Xhold577 _3116_/X VGND VGND VPWR VPWR _5309_/D sky130_fd_sc_hd__dlygate4sd3_1
XFILLER_104_637 VGND VGND VPWR VPWR sky130_fd_sc_hd__fill_4
X_4487_ _6413_/Q _4487_/A1 _4492_/S VGND VGND VPWR VPWR _4487_/X sky130_fd_sc_hd__mux2_1
Xhold566 _5999_/Q VGND VGND VPWR VPWR hold566/X sky130_fd_sc_hd__dlygate4sd3_1
Xhold588 _6105_/Q VGND VGND VPWR VPWR hold588/X sky130_fd_sc_hd__dlygate4sd3_1
Xhold555 _4497_/X VGND VGND VPWR VPWR _6102_/D sky130_fd_sc_hd__dlygate4sd3_1
X_3438_ _3438_/A _5069_/B VGND VGND VPWR VPWR _3450_/S sky130_fd_sc_hd__nor2_8
X_6226_ _6238_/CLK _6226_/D VGND VGND VPWR VPWR _6226_/Q sky130_fd_sc_hd__dfxtp_1
Xhold599 _2742_/X VGND VGND VPWR VPWR _5272_/D sky130_fd_sc_hd__dlygate4sd3_1
XFILLER_131_489 VPWR VGND VPWR VGND sky130_ef_sc_hd__decap_40_12
XFILLER_112_681 VPWR VGND VPWR VGND sky130_ef_sc_hd__decap_40_12
X_6157_ _6232_/CLK _6157_/D VGND VGND VPWR VPWR _6157_/Q sky130_fd_sc_hd__dfxtp_1
X_3369_ input4/X input5/X VGND VGND VPWR VPWR _4994_/B sky130_fd_sc_hd__and2b_4
Xhold1200 _5767_/Q VGND VGND VPWR VPWR _3754_/A1 sky130_fd_sc_hd__dlygate4sd3_1
Xhold1233 _5372_/Q VGND VGND VPWR VPWR _3212_/A1 sky130_fd_sc_hd__dlygate4sd3_1
Xhold1222 _3492_/X VGND VGND VPWR VPWR _5537_/D sky130_fd_sc_hd__dlygate4sd3_1
Xhold1211 _6197_/Q VGND VGND VPWR VPWR _4845_/A1 sky130_fd_sc_hd__dlygate4sd3_1
XANTENNA_fanout195_X _3062_/S VGND VGND VPWR VPWR sky130_fd_sc_hd__diode_2
X_5108_ _5108_/A _5110_/B _5108_/C _5108_/D VGND VGND VPWR VPWR _5108_/X sky130_fd_sc_hd__or4_1
XFILLER_58_768 VPWR VGND VPWR VGND sky130_ef_sc_hd__decap_40_12
Xhold1244 _5556_/Q VGND VGND VPWR VPWR _3512_/A1 sky130_fd_sc_hd__dlygate4sd3_1
Xhold1266 _3620_/X VGND VGND VPWR VPWR _5649_/D sky130_fd_sc_hd__dlygate4sd3_1
X_6088_ _6414_/CLK _6088_/D VGND VGND VPWR VPWR _6088_/Q sky130_fd_sc_hd__dfxtp_1
Xhold1255 _5921_/Q VGND VGND VPWR VPWR _4103_/A0 sky130_fd_sc_hd__dlygate4sd3_1
Xhold1299 _5513_/Q VGND VGND VPWR VPWR _3466_/A1 sky130_fd_sc_hd__dlygate4sd3_1
XANTENNA__3511__S _3516_/S VGND VGND VPWR VPWR sky130_fd_sc_hd__diode_2
XANTENNA__4607__S _4778_/S VGND VGND VPWR VPWR sky130_fd_sc_hd__diode_2
X_5039_ _5039_/A0 _5051_/A1 _5047_/S VGND VGND VPWR VPWR _5039_/X sky130_fd_sc_hd__mux2_1
Xhold1277 _5456_/Q VGND VGND VPWR VPWR _4190_/A2 sky130_fd_sc_hd__dlygate4sd3_1
Xhold1288 _4967_/X VGND VGND VPWR VPWR _6300_/D sky130_fd_sc_hd__dlygate4sd3_1
XFILLER_82_27 VGND VGND VPWR VPWR sky130_fd_sc_hd__fill_1
XFILLER_14_805 VGND VGND VPWR VPWR sky130_fd_sc_hd__fill_4
XFILLER_26_643 VGND VGND VPWR VPWR sky130_fd_sc_hd__fill_1
XFILLER_81_771 VPWR VGND VPWR VGND sky130_ef_sc_hd__decap_40_12
XTAP_TAPCELL_ROW_0_285 VGND VPWR sky130_fd_sc_hd__tapvpwrvgnd_1
XTAP_TAPCELL_ROW_0_296 VGND VPWR sky130_fd_sc_hd__tapvpwrvgnd_1
XANTENNA__4946__A0 _4976_/A1 VGND VGND VPWR VPWR sky130_fd_sc_hd__diode_2
XFILLER_40_112 VGND VGND VPWR VPWR sky130_fd_sc_hd__fill_4
XFILLER_15_87 VGND VGND VPWR VPWR sky130_fd_sc_hd__fill_1
XFILLER_127_729 VPWR VGND VPWR VGND sky130_ef_sc_hd__decap_40_12
XFILLER_5_503 VGND VGND VPWR VPWR sky130_fd_sc_hd__fill_1
XANTENNA__4174__A1 _4264_/A1 VGND VGND VPWR VPWR sky130_fd_sc_hd__diode_2
XANTENNA__3921__A1 _6411_/Q VGND VGND VPWR VPWR sky130_fd_sc_hd__diode_2
Xoutput42 _6066_/Q VGND VGND VPWR VPWR s_axil_rdata[13] sky130_fd_sc_hd__buf_2
XTAP_TAPCELL_ROW_56_1145 VGND VPWR sky130_fd_sc_hd__tapvpwrvgnd_1
XTAP_TAPCELL_ROW_56_1134 VGND VPWR sky130_fd_sc_hd__tapvpwrvgnd_1
Xoutput31 _6459_/A VGND VGND VPWR VPWR i2c_scl_o sky130_fd_sc_hd__buf_2
Xoutput53 _6062_/Q VGND VGND VPWR VPWR s_axil_rdata[9] sky130_fd_sc_hd__buf_2
XFILLER_1_753 VPWR VGND VPWR VGND sky130_ef_sc_hd__decap_40_12
XFILLER_49_702 VGND VGND VPWR VPWR sky130_fd_sc_hd__fill_2
XFILLER_0_263 VGND VGND VPWR VPWR sky130_fd_sc_hd__fill_8
XANTENNA__3685__A0 _5213_/A1 VGND VGND VPWR VPWR sky130_fd_sc_hd__diode_2
XFILLER_1_797 VPWR VGND VPWR VGND sky130_ef_sc_hd__decap_40_12
XFILLER_102_191 VGND VGND VPWR VPWR sky130_fd_sc_hd__fill_4
XFILLER_76_576 VGND VGND VPWR VPWR sky130_fd_sc_hd__fill_4
XFILLER_49_779 VGND VGND VPWR VPWR sky130_fd_sc_hd__fill_4
XANTENNA__2826__A _3085_/A VGND VGND VPWR VPWR sky130_fd_sc_hd__diode_2
XFILLER_64_738 VGND VGND VPWR VPWR sky130_fd_sc_hd__fill_8
XFILLER_63_215 VGND VGND VPWR VPWR sky130_fd_sc_hd__fill_8
XFILLER_36_429 VGND VGND VPWR VPWR sky130_fd_sc_hd__fill_1
XFILLER_17_665 VGND VGND VPWR VPWR sky130_fd_sc_hd__fill_4
XFILLER_71_281 VGND VGND VPWR VPWR sky130_fd_sc_hd__fill_1
XANTENNA__4088__S1 _3172_/B VGND VGND VPWR VPWR sky130_fd_sc_hd__diode_2
XANTENNA__4937__A0 _5052_/A1 VGND VGND VPWR VPWR sky130_fd_sc_hd__diode_2
X_2740_ _4548_/A _3113_/B _3113_/C VGND VGND VPWR VPWR _4523_/B sky130_fd_sc_hd__or3_4
XTAP_TAPCELL_ROW_80_1496 VGND VPWR sky130_fd_sc_hd__tapvpwrvgnd_1
Xclkbuf_leaf_105_clk clkload0/A VGND VGND VPWR VPWR _6314_/CLK sky130_fd_sc_hd__clkbuf_8
X_2671_ _2671_/A0 _4901_/A0 _5241_/S VGND VGND VPWR VPWR _2671_/X sky130_fd_sc_hd__mux2_1
XANTENNA__3376__B input5/X VGND VGND VPWR VPWR sky130_fd_sc_hd__diode_2
X_4410_ _5053_/A1 _4410_/A1 _4416_/S VGND VGND VPWR VPWR _4410_/X sky130_fd_sc_hd__mux2_1
XANTENNA_hold2072_A _6417_/Q VGND VGND VPWR VPWR sky130_fd_sc_hd__diode_2
X_5390_ _6420_/CLK _5390_/D VGND VGND VPWR VPWR _5390_/Q sky130_fd_sc_hd__dfxtp_1
XFILLER_99_613 VGND VGND VPWR VPWR sky130_fd_sc_hd__fill_2
XFILLER_98_101 VGND VGND VPWR VPWR sky130_fd_sc_hd__fill_1
XANTENNA__3912__A1 _5210_/A1 VGND VGND VPWR VPWR sky130_fd_sc_hd__diode_2
X_4341_ hold183/X _5043_/A1 _4345_/S VGND VGND VPWR VPWR _4341_/X sky130_fd_sc_hd__mux2_1
X_4272_ _4271_/X _4266_/X _4272_/S VGND VGND VPWR VPWR _4272_/X sky130_fd_sc_hd__mux2_1
XFILLER_101_629 VPWR VGND VPWR VGND sky130_ef_sc_hd__decap_40_12
XFILLER_86_318 VGND VGND VPWR VPWR sky130_fd_sc_hd__fill_1
X_3223_ _4813_/S _3223_/B VGND VGND VPWR VPWR _3223_/X sky130_fd_sc_hd__and2b_1
X_6011_ _6347_/CLK _6011_/D VGND VGND VPWR VPWR _6011_/Q sky130_fd_sc_hd__dfxtp_1
XANTENNA__3676__A0 _3926_/A1 VGND VGND VPWR VPWR sky130_fd_sc_hd__diode_2
XFILLER_100_128 VGND VGND VPWR VPWR sky130_fd_sc_hd__fill_2
XFILLER_95_841 VGND VGND VPWR VPWR sky130_fd_sc_hd__fill_1
XTAP_TAPCELL_ROW_87_1606 VGND VPWR sky130_fd_sc_hd__tapvpwrvgnd_1
X_3154_ _5065_/A0 _3154_/A1 _3156_/S VGND VGND VPWR VPWR _3154_/X sky130_fd_sc_hd__mux2_1
X_3085_ _3085_/A _3085_/B VGND VGND VPWR VPWR _3085_/X sky130_fd_sc_hd__and2_1
XANTENNA__2736__A _5222_/A VGND VGND VPWR VPWR sky130_fd_sc_hd__diode_2
XFILLER_27_429 VPWR VGND VPWR VGND sky130_ef_sc_hd__decap_40_12
XFILLER_50_421 VGND VGND VPWR VPWR sky130_fd_sc_hd__fill_4
XTAP_TAPCELL_ROW_46_991 VGND VPWR sky130_fd_sc_hd__tapvpwrvgnd_1
XFILLER_22_101 VPWR VGND VPWR VGND sky130_ef_sc_hd__decap_40_12
XANTENNA_fanout155_A _4260_/S VGND VGND VPWR VPWR sky130_fd_sc_hd__diode_2
X_3987_ _4013_/B _3987_/B VGND VGND VPWR VPWR _5082_/A sky130_fd_sc_hd__and2_1
X_2938_ _2931_/X _2937_/X _3083_/S VGND VGND VPWR VPWR _2938_/X sky130_fd_sc_hd__mux2_1
X_5726_ _6290_/CLK _5726_/D VGND VGND VPWR VPWR _5726_/Q sky130_fd_sc_hd__dfxtp_1
XFILLER_109_729 VPWR VGND VPWR VGND sky130_ef_sc_hd__decap_40_12
X_2869_ _5300_/Q _5373_/Q _5361_/Q _6142_/Q _2984_/S _2985_/A VGND VGND VPWR VPWR
+ _2869_/X sky130_fd_sc_hd__mux4_1
XTAP_TAPCELL_ROW_98_1768 VGND VPWR sky130_fd_sc_hd__tapvpwrvgnd_1
XANTENNA_fanout110_X _5051_/A1 VGND VGND VPWR VPWR sky130_fd_sc_hd__diode_2
X_5657_ _5681_/CLK _5657_/D VGND VGND VPWR VPWR _5657_/Q sky130_fd_sc_hd__dfxtp_1
X_5588_ _6298_/CLK _5588_/D VGND VGND VPWR VPWR _5588_/Q sky130_fd_sc_hd__dfxtp_1
X_4608_ _4791_/A1 _4607_/X _4791_/B1 VGND VGND VPWR VPWR _4608_/X sky130_fd_sc_hd__o21a_1
X_4539_ hold234/X _5241_/A1 _4547_/S VGND VGND VPWR VPWR _4539_/X sky130_fd_sc_hd__mux2_1
Xhold352 _3195_/X VGND VGND VPWR VPWR _5357_/D sky130_fd_sc_hd__dlygate4sd3_1
Xhold330 _3123_/X VGND VGND VPWR VPWR _5316_/D sky130_fd_sc_hd__dlygate4sd3_1
XANTENNA__3506__S _3516_/S VGND VGND VPWR VPWR sky130_fd_sc_hd__diode_2
Xhold341 _5627_/Q VGND VGND VPWR VPWR hold341/X sky130_fd_sc_hd__dlygate4sd3_1
XANTENNA__3903__A1 _5211_/A1 VGND VGND VPWR VPWR sky130_fd_sc_hd__diode_2
Xhold396 _4872_/X VGND VGND VPWR VPWR _6222_/D sky130_fd_sc_hd__dlygate4sd3_1
Xhold374 _4556_/X VGND VGND VPWR VPWR _6156_/D sky130_fd_sc_hd__dlygate4sd3_1
Xhold363 _6237_/Q VGND VGND VPWR VPWR hold363/X sky130_fd_sc_hd__dlygate4sd3_1
Xhold385 _5683_/Q VGND VGND VPWR VPWR hold385/X sky130_fd_sc_hd__dlygate4sd3_1
X_6209_ _6233_/CLK _6209_/D VGND VGND VPWR VPWR _6209_/Q sky130_fd_sc_hd__dfxtp_1
XFILLER_104_467 VGND VGND VPWR VPWR sky130_fd_sc_hd__fill_8
XFILLER_89_167 VGND VGND VPWR VPWR sky130_fd_sc_hd__fill_1
XANTENNA__3667__A0 _4964_/A0 VGND VGND VPWR VPWR sky130_fd_sc_hd__diode_2
XFILLER_77_318 VGND VGND VPWR VPWR sky130_fd_sc_hd__fill_1
XANTENNA__4459__A2 _4457_/S VGND VGND VPWR VPWR sky130_fd_sc_hd__diode_2
XTAP_TAPCELL_ROW_129_2234 VGND VPWR sky130_fd_sc_hd__tapvpwrvgnd_1
XFILLER_86_841 VGND VGND VPWR VPWR sky130_fd_sc_hd__fill_1
Xhold1041 _4447_/X VGND VGND VPWR VPWR _6063_/D sky130_fd_sc_hd__dlygate4sd3_1
XFILLER_93_15 VPWR VGND VPWR VGND sky130_ef_sc_hd__decap_40_12
XTAP_TAPCELL_ROW_51_1064 VGND VPWR sky130_fd_sc_hd__tapvpwrvgnd_1
XANTENNA_fanout68_A _2636_/Y VGND VGND VPWR VPWR sky130_fd_sc_hd__diode_2
XTAP_TAPCELL_ROW_5_377 VGND VPWR sky130_fd_sc_hd__tapvpwrvgnd_1
Xhold1030 _5801_/Q VGND VGND VPWR VPWR _3794_/A0 sky130_fd_sc_hd__dlygate4sd3_1
Xhold1063 _3217_/X VGND VGND VPWR VPWR _5377_/D sky130_fd_sc_hd__dlygate4sd3_1
XFILLER_73_535 VGND VGND VPWR VPWR sky130_fd_sc_hd__fill_1
Xhold1074 _6036_/Q VGND VGND VPWR VPWR _4398_/A1 sky130_fd_sc_hd__dlygate4sd3_1
Xhold1085 _3633_/X VGND VGND VPWR VPWR _5661_/D sky130_fd_sc_hd__dlygate4sd3_1
Xhold1052 _5887_/Q VGND VGND VPWR VPWR _3908_/A0 sky130_fd_sc_hd__dlygate4sd3_1
Xhold1096 _5521_/Q VGND VGND VPWR VPWR _3474_/A1 sky130_fd_sc_hd__dlygate4sd3_1
XFILLER_93_59 VGND VGND VPWR VPWR sky130_fd_sc_hd__fill_2
XFILLER_73_557 VGND VGND VPWR VPWR sky130_fd_sc_hd__fill_1
XFILLER_26_42 VGND VGND VPWR VPWR sky130_fd_sc_hd__fill_1
Xclkbuf_3_6__f_clk clkbuf_0_clk/X VGND VGND VPWR VPWR clkload5/A sky130_fd_sc_hd__clkbuf_16
XFILLER_14_613 VPWR VGND VPWR VGND sky130_ef_sc_hd__decap_40_12
XFILLER_26_75 VGND VGND VPWR VPWR sky130_fd_sc_hd__fill_1
XFILLER_26_473 VGND VGND VPWR VPWR sky130_fd_sc_hd__fill_2
XFILLER_14_657 VPWR VGND VPWR VGND sky130_ef_sc_hd__decap_40_12
XTAP_TAPCELL_ROW_24_663 VGND VPWR sky130_fd_sc_hd__tapvpwrvgnd_1
XFILLER_42_85 VGND VGND VPWR VPWR sky130_fd_sc_hd__fill_2
XFILLER_10_841 VGND VGND VPWR VPWR sky130_fd_sc_hd__fill_1
XANTENNA_clkbuf_leaf_5_clk_A clkbuf_leaf_9_clk/A VGND VGND VPWR VPWR sky130_fd_sc_hd__diode_2
XANTENNA__4147__A1 _4260_/S VGND VGND VPWR VPWR sky130_fd_sc_hd__diode_2
XFILLER_127_559 VGND VGND VPWR VPWR sky130_fd_sc_hd__fill_1
XFILLER_5_333 VGND VGND VPWR VPWR sky130_fd_sc_hd__fill_2
XFILLER_123_721 VGND VGND VPWR VPWR sky130_fd_sc_hd__fill_4
XFILLER_123_765 VPWR VGND VPWR VGND sky130_ef_sc_hd__decap_40_12
XFILLER_107_283 VGND VGND VPWR VPWR sky130_fd_sc_hd__fill_2
XANTENNA__3370__A2 _3366_/X VGND VGND VPWR VPWR sky130_fd_sc_hd__diode_2
XFILLER_110_404 VGND VGND VPWR VPWR sky130_fd_sc_hd__fill_1
XFILLER_68_329 VGND VGND VPWR VPWR sky130_fd_sc_hd__fill_2
XFILLER_1_561 VPWR VGND VPWR VGND sky130_ef_sc_hd__decap_40_12
XFILLER_77_841 VGND VGND VPWR VPWR sky130_fd_sc_hd__fill_1
XFILLER_3_57 VPWR VGND VPWR VGND sky130_ef_sc_hd__decap_40_12
XFILLER_92_811 VGND VGND VPWR VPWR sky130_fd_sc_hd__fill_1
XFILLER_76_362 VGND VGND VPWR VPWR sky130_fd_sc_hd__fill_2
XTAP_TAPCELL_ROW_69_1336 VGND VPWR sky130_fd_sc_hd__tapvpwrvgnd_1
XFILLER_37_727 VGND VGND VPWR VPWR sky130_fd_sc_hd__fill_1
XFILLER_37_738 VGND VGND VPWR VPWR sky130_fd_sc_hd__fill_4
XFILLER_45_782 VGND VGND VPWR VPWR sky130_fd_sc_hd__fill_2
XFILLER_17_473 VPWR VGND VPWR VGND sky130_ef_sc_hd__decap_40_12
X_4890_ hold389/X _4903_/A0 _4893_/S VGND VGND VPWR VPWR _4890_/X sky130_fd_sc_hd__mux2_1
XTAP_TAPCELL_ROW_82_1536 VGND VPWR sky130_fd_sc_hd__tapvpwrvgnd_1
XTAP_TAPCELL_ROW_82_1525 VGND VPWR sky130_fd_sc_hd__tapvpwrvgnd_1
X_3910_ hold107/X _5208_/A1 _3918_/S VGND VGND VPWR VPWR _3910_/X sky130_fd_sc_hd__mux2_1
XANTENNA__5078__S _5081_/S VGND VGND VPWR VPWR sky130_fd_sc_hd__diode_2
X_3841_ input19/X _3837_/A _4922_/C _3840_/X _5200_/A VGND VGND VPWR VPWR _5834_/D
+ sky130_fd_sc_hd__o311a_1
XFILLER_60_752 VGND VGND VPWR VPWR sky130_fd_sc_hd__fill_1
XANTENNA__5032__C1 _3801_/A VGND VGND VPWR VPWR sky130_fd_sc_hd__diode_2
XTAP_TAPCELL_ROW_43_950 VGND VPWR sky130_fd_sc_hd__tapvpwrvgnd_1
XFILLER_60_785 VPWR VGND VPWR VGND sky130_ef_sc_hd__decap_40_12
XANTENNA__4386__A1 _5047_/A1 VGND VGND VPWR VPWR sky130_fd_sc_hd__diode_2
X_3772_ _5043_/A1 _4135_/A0 _3776_/S VGND VGND VPWR VPWR _3772_/X sky130_fd_sc_hd__mux2_1
X_5511_ _6435_/CLK _5511_/D VGND VGND VPWR VPWR _5511_/Q sky130_fd_sc_hd__dfxtp_1
X_2723_ _3011_/A _2723_/B VGND VGND VPWR VPWR _2727_/C sky130_fd_sc_hd__nor2_1
XANTENNA__4138__A1 _4252_/A1 VGND VGND VPWR VPWR sky130_fd_sc_hd__diode_2
XTAP_TAPCELL_ROW_113_2002 VGND VPWR sky130_fd_sc_hd__tapvpwrvgnd_1
X_2654_ _3128_/B VGND VGND VPWR VPWR _2654_/Y sky130_fd_sc_hd__inv_2
X_5442_ _5731_/CLK _5442_/D VGND VGND VPWR VPWR _5442_/Q sky130_fd_sc_hd__dfxtp_1
X_5373_ _6143_/CLK _5373_/D VGND VGND VPWR VPWR _5373_/Q sky130_fd_sc_hd__dfxtp_1
XFILLER_133_529 VPWR VGND VPWR VGND sky130_ef_sc_hd__decap_40_12
XFILLER_126_581 VGND VGND VPWR VPWR sky130_fd_sc_hd__fill_4
X_4324_ hold686/X _5046_/A1 _4325_/S VGND VGND VPWR VPWR _4324_/X sky130_fd_sc_hd__mux2_1
XTAP_TAPCELL_ROW_93_1698 VGND VPWR sky130_fd_sc_hd__tapvpwrvgnd_1
Xfanout117 _5819_/Q VGND VGND VPWR VPWR _4445_/A sky130_fd_sc_hd__clkbuf_4
Xfanout128 _4903_/A0 VGND VGND VPWR VPWR _5234_/A0 sky130_fd_sc_hd__buf_4
Xfanout106 hold2225/X VGND VGND VPWR VPWR _5053_/A1 sky130_fd_sc_hd__clkbuf_4
XFILLER_86_137 VGND VGND VPWR VPWR sky130_fd_sc_hd__fill_2
Xfanout139 _2628_/A VGND VGND VPWR VPWR _4792_/A1 sky130_fd_sc_hd__buf_4
X_4255_ _5945_/Q _6316_/Q _4258_/S VGND VGND VPWR VPWR _4255_/X sky130_fd_sc_hd__mux2_1
X_3206_ hold894/X _5237_/A0 _3206_/S VGND VGND VPWR VPWR _3206_/X sky130_fd_sc_hd__mux2_1
X_4186_ _5774_/Q _6032_/Q _5942_/Q hold409/X _4257_/S _4241_/A VGND VGND VPWR VPWR
+ _4186_/X sky130_fd_sc_hd__mux4_1
XANTENNA__4310__A1 _4929_/A1 VGND VGND VPWR VPWR sky130_fd_sc_hd__diode_2
XFILLER_95_671 VGND VGND VPWR VPWR sky130_fd_sc_hd__fill_1
XFILLER_83_833 VGND VGND VPWR VPWR sky130_fd_sc_hd__fill_4
XFILLER_55_535 VGND VGND VPWR VPWR sky130_fd_sc_hd__fill_1
XTAP_TAPCELL_ROW_2_336 VGND VPWR sky130_fd_sc_hd__tapvpwrvgnd_1
XTAP_TAPCELL_ROW_2_325 VGND VPWR sky130_fd_sc_hd__tapvpwrvgnd_1
X_3137_ _2701_/B _3135_/A _3136_/Y VGND VGND VPWR VPWR _3137_/X sky130_fd_sc_hd__o21a_1
XTAP_TAPCELL_ROW_124_2153 VGND VPWR sky130_fd_sc_hd__tapvpwrvgnd_1
XTAP_TAPCELL_ROW_124_2164 VGND VPWR sky130_fd_sc_hd__tapvpwrvgnd_1
XPHY_EDGE_ROW_118_Right_118 VGND VGND VPWR VPWR sky130_fd_sc_hd__decap_3
X_3068_ _2967_/S _3060_/X _3067_/Y VGND VGND VPWR VPWR _3068_/X sky130_fd_sc_hd__a21o_1
XFILLER_82_365 VGND VGND VPWR VPWR sky130_fd_sc_hd__fill_4
XANTENNA_fanout158_X _3172_/B VGND VGND VPWR VPWR sky130_fd_sc_hd__diode_2
XTAP_TAPCELL_ROW_41_909 VGND VPWR sky130_fd_sc_hd__tapvpwrvgnd_1
XFILLER_51_785 VPWR VGND VPWR VGND sky130_ef_sc_hd__decap_40_12
XFILLER_50_262 VGND VGND VPWR VPWR sky130_fd_sc_hd__fill_1
XTAP_TAPCELL_ROW_21_611 VGND VPWR sky130_fd_sc_hd__tapvpwrvgnd_1
XFILLER_7_609 VGND VGND VPWR VPWR sky130_fd_sc_hd__fill_4
XTAP_TAPCELL_ROW_21_622 VGND VPWR sky130_fd_sc_hd__tapvpwrvgnd_1
XFILLER_109_537 VPWR VGND VPWR VGND sky130_ef_sc_hd__decap_40_12
X_5709_ _6122_/CLK _5709_/D VGND VGND VPWR VPWR _5709_/Q sky130_fd_sc_hd__dfxtp_1
XFILLER_109_559 VGND VGND VPWR VPWR sky130_fd_sc_hd__fill_1
XFILLER_124_529 VGND VGND VPWR VPWR sky130_fd_sc_hd__fill_2
XFILLER_105_721 VGND VGND VPWR VPWR sky130_fd_sc_hd__fill_4
XFILLER_3_837 VGND VGND VPWR VPWR sky130_fd_sc_hd__fill_2
Xhold160 _4533_/X VGND VGND VPWR VPWR _6135_/D sky130_fd_sc_hd__dlygate4sd3_1
Xhold171 _5954_/Q VGND VGND VPWR VPWR hold171/X sky130_fd_sc_hd__dlygate4sd3_1
XANTENNA__3352__A2 _5035_/C VGND VGND VPWR VPWR sky130_fd_sc_hd__diode_2
XFILLER_120_713 VPWR VGND VPWR VGND sky130_ef_sc_hd__decap_40_12
XFILLER_105_765 VPWR VGND VPWR VGND sky130_ef_sc_hd__decap_40_12
Xhold182 _4882_/X VGND VGND VPWR VPWR _6231_/D sky130_fd_sc_hd__dlygate4sd3_1
XFILLER_77_104 VGND VGND VPWR VPWR sky130_fd_sc_hd__fill_1
Xhold193 _6337_/Q VGND VGND VPWR VPWR hold193/X sky130_fd_sc_hd__dlygate4sd3_1
XFILLER_120_757 VPWR VGND VPWR VGND sky130_ef_sc_hd__decap_40_12
XFILLER_59_841 VGND VGND VPWR VPWR sky130_fd_sc_hd__fill_1
XANTENNA__4301__A1 _5044_/A1 VGND VGND VPWR VPWR sky130_fd_sc_hd__diode_2
XTAP_TAPCELL_ROW_109_1937 VGND VPWR sky130_fd_sc_hd__tapvpwrvgnd_1
XFILLER_19_727 VGND VGND VPWR VPWR sky130_fd_sc_hd__fill_1
XANTENNA__2863__A1 _3031_/A1 VGND VGND VPWR VPWR sky130_fd_sc_hd__diode_2
XFILLER_46_535 VGND VGND VPWR VPWR sky130_fd_sc_hd__fill_4
XTAP_TAPCELL_ROW_29_733 VGND VPWR sky130_fd_sc_hd__tapvpwrvgnd_1
XFILLER_73_365 VGND VGND VPWR VPWR sky130_fd_sc_hd__fill_2
XFILLER_14_421 VPWR VGND VPWR VGND sky130_ef_sc_hd__decap_40_12
XFILLER_27_782 VGND VGND VPWR VPWR sky130_fd_sc_hd__fill_2
XANTENNA__3478__Y _3490_/S VGND VGND VPWR VPWR sky130_fd_sc_hd__diode_2
XTAP_TAPCELL_ROW_64_1266 VGND VPWR sky130_fd_sc_hd__tapvpwrvgnd_1
XTAP_TAPCELL_ROW_64_1255 VGND VPWR sky130_fd_sc_hd__tapvpwrvgnd_1
XFILLER_42_752 VGND VGND VPWR VPWR sky130_fd_sc_hd__fill_1
XFILLER_128_813 VPWR VGND VPWR VGND sky130_ef_sc_hd__decap_40_12
XANTENNA__4530__S _4535_/S VGND VGND VPWR VPWR sky130_fd_sc_hd__diode_2
XFILLER_10_693 VGND VGND VPWR VPWR sky130_fd_sc_hd__fill_4
XFILLER_5_130 VGND VGND VPWR VPWR sky130_fd_sc_hd__fill_1
XFILLER_115_529 VPWR VGND VPWR VGND sky130_ef_sc_hd__decap_40_12
XANTENNA__3879__A0 _4964_/A0 VGND VGND VPWR VPWR sky130_fd_sc_hd__diode_2
XANTENNA__4215__S1 _4212_/A VGND VGND VPWR VPWR sky130_fd_sc_hd__diode_2
XFILLER_6_697 VGND VGND VPWR VPWR sky130_fd_sc_hd__fill_2
XANTENNA__4540__A1 _4899_/A0 VGND VGND VPWR VPWR sky130_fd_sc_hd__diode_2
XFILLER_108_581 VGND VGND VPWR VPWR sky130_fd_sc_hd__fill_4
XANTENNA__3373__C input4/X VGND VGND VPWR VPWR sky130_fd_sc_hd__diode_2
XFILLER_123_573 VPWR VGND VPWR VGND sky130_ef_sc_hd__decap_40_12
XFILLER_96_435 VGND VGND VPWR VPWR sky130_fd_sc_hd__fill_1
XFILLER_49_351 VGND VGND VPWR VPWR sky130_fd_sc_hd__fill_2
X_4040_ _4241_/A _4040_/B VGND VGND VPWR VPWR _4040_/Y sky130_fd_sc_hd__nor2_1
XFILLER_92_641 VGND VGND VPWR VPWR sky130_fd_sc_hd__fill_2
XFILLER_37_535 VGND VGND VPWR VPWR sky130_fd_sc_hd__fill_1
XFILLER_80_825 VPWR VGND VPWR VGND sky130_ef_sc_hd__decap_40_12
XFILLER_64_365 VGND VGND VPWR VPWR sky130_fd_sc_hd__fill_2
X_5991_ _6349_/CLK _5991_/D VGND VGND VPWR VPWR _5991_/Q sky130_fd_sc_hd__dfxtp_1
XFILLER_91_173 VGND VGND VPWR VPWR sky130_fd_sc_hd__fill_2
XFILLER_18_793 VPWR VGND VPWR VGND sky130_ef_sc_hd__decap_40_12
X_4942_ _5045_/A1 _4942_/A1 _4944_/S VGND VGND VPWR VPWR _4942_/X sky130_fd_sc_hd__mux2_1
X_4873_ hold783/X _4886_/A1 _4880_/S VGND VGND VPWR VPWR _4873_/X sky130_fd_sc_hd__mux2_1
XANTENNA__4359__A1 _5052_/A1 VGND VGND VPWR VPWR sky130_fd_sc_hd__diode_2
XFILLER_20_413 VGND VGND VPWR VPWR sky130_fd_sc_hd__fill_4
XFILLER_33_785 VPWR VGND VPWR VGND sky130_ef_sc_hd__decap_40_12
X_3824_ input12/X _5051_/A1 _3835_/S VGND VGND VPWR VPWR _5823_/D sky130_fd_sc_hd__mux2_1
XFILLER_20_457 VPWR VGND VPWR VGND sky130_ef_sc_hd__decap_40_12
XANTENNA__3031__A1 _3031_/A1 VGND VGND VPWR VPWR sky130_fd_sc_hd__diode_2
X_3755_ _4984_/A1 _3755_/A1 _3755_/S VGND VGND VPWR VPWR _3755_/X sky130_fd_sc_hd__mux2_1
XFILLER_134_805 VGND VGND VPWR VPWR sky130_fd_sc_hd__fill_4
XTAP_TAPCELL_ROW_95_1727 VGND VPWR sky130_fd_sc_hd__tapvpwrvgnd_1
X_3686_ _3926_/A1 _3686_/A1 _3688_/S VGND VGND VPWR VPWR _3686_/X sky130_fd_sc_hd__mux2_1
X_2706_ _5321_/Q _2706_/B _3391_/B VGND VGND VPWR VPWR _4965_/A sky130_fd_sc_hd__or3_4
XANTENNA_fanout118_A _4846_/A0 VGND VGND VPWR VPWR sky130_fd_sc_hd__diode_2
XFILLER_106_529 VGND VGND VPWR VPWR sky130_fd_sc_hd__fill_2
X_5425_ _5583_/CLK _5425_/D VGND VGND VPWR VPWR _5425_/Q sky130_fd_sc_hd__dfxtp_1
XPHY_EDGE_ROW_12_Right_12 VGND VGND VPWR VPWR sky130_fd_sc_hd__decap_3
X_2637_ _3138_/B VGND VGND VPWR VPWR _4346_/A sky130_fd_sc_hd__inv_2
XANTENNA__3056__S _3086_/S VGND VGND VPWR VPWR sky130_fd_sc_hd__diode_2
XANTENNA__4531__A1 _5233_/A0 VGND VGND VPWR VPWR sky130_fd_sc_hd__diode_2
XTAP_TAPCELL_ROW_7_406 VGND VPWR sky130_fd_sc_hd__tapvpwrvgnd_1
XFILLER_102_713 VPWR VGND VPWR VGND sky130_ef_sc_hd__decap_40_12
X_5356_ _5583_/CLK _5356_/D VGND VGND VPWR VPWR _5356_/Q sky130_fd_sc_hd__dfxtp_1
XFILLER_0_818 VGND VGND VPWR VPWR sky130_fd_sc_hd__fill_4
XFILLER_87_424 VGND VGND VPWR VPWR sky130_fd_sc_hd__fill_2
X_5287_ _6394_/CLK _5287_/D VGND VGND VPWR VPWR _5287_/Q sky130_fd_sc_hd__dfxtp_1
X_4307_ hold65/X _5051_/A1 _4315_/S VGND VGND VPWR VPWR hold66/A sky130_fd_sc_hd__mux2_1
XFILLER_102_757 VPWR VGND VPWR VGND sky130_ef_sc_hd__decap_40_12
X_4238_ _4252_/A1 _4237_/X _4252_/B1 VGND VGND VPWR VPWR _4238_/Y sky130_fd_sc_hd__o21ai_1
XFILLER_101_289 VGND VGND VPWR VPWR sky130_fd_sc_hd__fill_1
XFILLER_56_811 VGND VGND VPWR VPWR sky130_fd_sc_hd__fill_1
XFILLER_55_310 VGND VGND VPWR VPWR sky130_fd_sc_hd__fill_4
XANTENNA__2845__A1 _3036_/A1 VGND VGND VPWR VPWR sky130_fd_sc_hd__diode_2
Xclkbuf_leaf_94_clk clkbuf_leaf_9_clk/A VGND VGND VPWR VPWR _6422_/CLK sky130_fd_sc_hd__clkbuf_8
X_4169_ _4165_/X _4167_/X _4168_/X _4271_/S1 VGND VGND VPWR VPWR _4169_/X sky130_fd_sc_hd__a22o_1
XPHY_EDGE_ROW_21_Right_21 VGND VGND VPWR VPWR sky130_fd_sc_hd__decap_3
XTAP_TAPCELL_ROW_104_1867 VGND VPWR sky130_fd_sc_hd__tapvpwrvgnd_1
XTAP_TAPCELL_ROW_104_1856 VGND VPWR sky130_fd_sc_hd__tapvpwrvgnd_1
XFILLER_130_89 VGND VGND VPWR VPWR sky130_fd_sc_hd__fill_1
XTAP_TAPCELL_ROW_137_2355 VGND VPWR sky130_fd_sc_hd__tapvpwrvgnd_1
XFILLER_128_3 VPWR VGND VPWR VGND sky130_ef_sc_hd__decap_40_12
XANTENNA__3022__A1 _3036_/A1 VGND VGND VPWR VPWR sky130_fd_sc_hd__diode_2
XFILLER_7_417 VPWR VGND VPWR VGND sky130_ef_sc_hd__decap_40_12
XFILLER_23_65 VGND VGND VPWR VPWR sky130_fd_sc_hd__fill_2
XFILLER_137_665 VGND VGND VPWR VPWR sky130_fd_sc_hd__fill_4
XFILLER_109_356 VGND VGND VPWR VPWR sky130_fd_sc_hd__fill_1
XANTENNA__4350__S _4356_/S VGND VGND VPWR VPWR sky130_fd_sc_hd__diode_2
XANTENNA__4770__A1 _4663_/A VGND VGND VPWR VPWR sky130_fd_sc_hd__diode_2
XPHY_EDGE_ROW_30_Right_30 VGND VGND VPWR VPWR sky130_fd_sc_hd__decap_3
XFILLER_109_389 VGND VGND VPWR VPWR sky130_fd_sc_hd__fill_1
XANTENNA_fanout90_X _4484_/A0 VGND VGND VPWR VPWR sky130_fd_sc_hd__diode_2
XANTENNA__4522__A1 _5202_/A1 VGND VGND VPWR VPWR sky130_fd_sc_hd__diode_2
XFILLER_105_573 VPWR VGND VPWR VGND sky130_ef_sc_hd__decap_40_12
XFILLER_120_587 VGND VGND VPWR VPWR sky130_fd_sc_hd__fill_1
XFILLER_65_118 VGND VGND VPWR VPWR sky130_fd_sc_hd__fill_2
XFILLER_47_833 VGND VGND VPWR VPWR sky130_fd_sc_hd__fill_4
XFILLER_93_449 VGND VGND VPWR VPWR sky130_fd_sc_hd__fill_2
XFILLER_74_641 VGND VGND VPWR VPWR sky130_fd_sc_hd__fill_2
XFILLER_19_557 VGND VGND VPWR VPWR sky130_fd_sc_hd__fill_2
Xclkbuf_leaf_85_clk clkload1/A VGND VGND VPWR VPWR _5803_/CLK sky130_fd_sc_hd__clkbuf_8
XFILLER_73_151 VGND VGND VPWR VPWR sky130_fd_sc_hd__fill_1
XFILLER_62_825 VPWR VGND VPWR VGND sky130_ef_sc_hd__decap_40_12
XFILLER_0_69 VPWR VGND VPWR VGND sky130_ef_sc_hd__decap_40_12
XFILLER_64_50 VGND VGND VPWR VPWR sky130_fd_sc_hd__fill_4
XFILLER_34_527 VGND VGND VPWR VPWR sky130_fd_sc_hd__fill_1
XFILLER_15_741 VPWR VGND VPWR VGND sky130_ef_sc_hd__decap_40_12
XFILLER_15_785 VPWR VGND VPWR VGND sky130_ef_sc_hd__decap_40_12
XANTENNA__4210__B1 _4272_/S VGND VGND VPWR VPWR sky130_fd_sc_hd__diode_2
XFILLER_128_643 VGND VGND VPWR VPWR sky130_fd_sc_hd__fill_1
XFILLER_127_131 VGND VGND VPWR VPWR sky130_fd_sc_hd__fill_1
XFILLER_116_805 VGND VGND VPWR VPWR sky130_fd_sc_hd__fill_4
X_3540_ hold625/X _5080_/A0 _3541_/S VGND VGND VPWR VPWR _3540_/X sky130_fd_sc_hd__mux2_1
XTAP_TAPCELL_ROW_12_474 VGND VPWR sky130_fd_sc_hd__tapvpwrvgnd_1
XTAP_TAPCELL_ROW_12_485 VGND VPWR sky130_fd_sc_hd__tapvpwrvgnd_1
XANTENNA__4260__S _4260_/S VGND VGND VPWR VPWR sky130_fd_sc_hd__diode_2
Xhold907 _4833_/X VGND VGND VPWR VPWR _6186_/D sky130_fd_sc_hd__dlygate4sd3_1
XTAP_TAPCELL_ROW_77_1457 VGND VPWR sky130_fd_sc_hd__tapvpwrvgnd_1
Xhold918 _5626_/Q VGND VGND VPWR VPWR hold918/X sky130_fd_sc_hd__dlygate4sd3_1
X_3471_ _4887_/A1 hold896/X _3477_/S VGND VGND VPWR VPWR _3471_/X sky130_fd_sc_hd__mux2_1
Xhold929 _3415_/X VGND VGND VPWR VPWR _5468_/D sky130_fd_sc_hd__dlygate4sd3_1
X_5210_ _5210_/A0 _5210_/A1 _5213_/S VGND VGND VPWR VPWR _5210_/X sky130_fd_sc_hd__mux2_1
XFILLER_130_318 VGND VGND VPWR VPWR sky130_fd_sc_hd__fill_1
X_6190_ _6239_/CLK _6190_/D VGND VGND VPWR VPWR _6190_/Q sky130_fd_sc_hd__dfxtp_1
XTAP_TAPCELL_ROW_90_1657 VGND VPWR sky130_fd_sc_hd__tapvpwrvgnd_1
XTAP_TAPCELL_ROW_90_1646 VGND VPWR sky130_fd_sc_hd__tapvpwrvgnd_1
X_5141_ _5137_/A _5160_/A _5140_/Y _5200_/A VGND VGND VPWR VPWR _5141_/X sky130_fd_sc_hd__o211a_1
X_5072_ _5228_/A0 _5072_/A1 _5081_/S VGND VGND VPWR VPWR _5072_/X sky130_fd_sc_hd__mux2_1
XFILLER_97_777 VGND VGND VPWR VPWR sky130_fd_sc_hd__fill_4
Xhold1607 _3601_/X VGND VGND VPWR VPWR _5634_/D sky130_fd_sc_hd__dlygate4sd3_1
Xhold1618 _3284_/X VGND VGND VPWR VPWR _5403_/D sky130_fd_sc_hd__dlygate4sd3_1
XFILLER_96_265 VPWR VGND VPWR VGND sky130_ef_sc_hd__decap_40_12
XFILLER_84_427 VGND VGND VPWR VPWR sky130_fd_sc_hd__fill_1
X_4023_ _4264_/A1 _4022_/X _4021_/X _4271_/S1 VGND VGND VPWR VPWR _4023_/X sky130_fd_sc_hd__o211a_1
Xhold1629 _6050_/Q VGND VGND VPWR VPWR _4413_/A1 sky130_fd_sc_hd__dlygate4sd3_1
Xclkbuf_leaf_76_clk clkload2/A VGND VGND VPWR VPWR _6094_/CLK sky130_fd_sc_hd__clkbuf_8
XANTENNA_clkbuf_leaf_92_clk_A clkload2/A VGND VGND VPWR VPWR sky130_fd_sc_hd__diode_2
XFILLER_37_332 VGND VGND VPWR VPWR sky130_fd_sc_hd__fill_4
XFILLER_80_600 VPWR VGND VPWR VGND sky130_ef_sc_hd__decap_40_12
XFILLER_25_505 VGND VGND VPWR VPWR sky130_fd_sc_hd__fill_4
XTAP_TAPCELL_ROW_121_2112 VGND VPWR sky130_fd_sc_hd__tapvpwrvgnd_1
XFILLER_64_195 VGND VGND VPWR VPWR sky130_fd_sc_hd__fill_1
X_5974_ _5990_/CLK _5974_/D VGND VGND VPWR VPWR _5974_/Q sky130_fd_sc_hd__dfxtp_1
XFILLER_100_15 VPWR VGND VPWR VGND sky130_ef_sc_hd__decap_40_12
XFILLER_80_699 VGND VGND VPWR VPWR sky130_fd_sc_hd__fill_1
XANTENNA__5828__Q _5828_/Q VGND VGND VPWR VPWR sky130_fd_sc_hd__diode_2
X_4925_ _5050_/B _4965_/B VGND VGND VPWR VPWR _4934_/S sky130_fd_sc_hd__nor2_4
X_4856_ _4882_/A1 _4856_/A1 _4867_/S VGND VGND VPWR VPWR _6207_/D sky130_fd_sc_hd__mux2_1
XFILLER_60_19 VGND VGND VPWR VPWR sky130_fd_sc_hd__fill_1
XFILLER_138_429 VGND VGND VPWR VPWR sky130_fd_sc_hd__fill_1
XANTENNA_clkbuf_leaf_30_clk_A clkload3/A VGND VGND VPWR VPWR sky130_fd_sc_hd__diode_2
X_3807_ _2625_/A _5234_/A0 _3810_/S VGND VGND VPWR VPWR _5813_/D sky130_fd_sc_hd__mux2_1
XFILLER_21_777 VGND VGND VPWR VPWR sky130_fd_sc_hd__fill_4
XTAP_TAPCELL_ROW_31_761 VGND VPWR sky130_fd_sc_hd__tapvpwrvgnd_1
XFILLER_119_665 VGND VGND VPWR VPWR sky130_fd_sc_hd__fill_4
XTAP_TAPCELL_ROW_119_2085 VGND VPWR sky130_fd_sc_hd__tapvpwrvgnd_1
X_4787_ hold714/X hold710/X hold720/X _4787_/A3 _4773_/S _4794_/A VGND VGND VPWR VPWR
+ _4787_/X sky130_fd_sc_hd__mux4_1
XTAP_TAPCELL_ROW_31_772 VGND VPWR sky130_fd_sc_hd__tapvpwrvgnd_1
XFILLER_134_613 VPWR VGND VPWR VGND sky130_ef_sc_hd__decap_40_12
XANTENNA__2763__B1 _3027_/A VGND VGND VPWR VPWR sky130_fd_sc_hd__diode_2
X_3738_ hold203/X _4886_/A1 _3745_/S VGND VGND VPWR VPWR _3738_/X sky130_fd_sc_hd__mux2_1
XFILLER_134_657 VPWR VGND VPWR VGND sky130_ef_sc_hd__decap_40_12
XTAP_TAPCELL_ROW_132_2274 VGND VPWR sky130_fd_sc_hd__tapvpwrvgnd_1
Xclkload80 _6428_/CLK VGND VGND VPWR VPWR clkload80/Y sky130_fd_sc_hd__clkinvlp_4
XFILLER_109_68 VGND VGND VPWR VPWR sky130_fd_sc_hd__fill_2
XFILLER_109_57 VGND VGND VPWR VPWR sky130_fd_sc_hd__fill_2
XFILLER_69_17 VPWR VGND VPWR VGND sky130_ef_sc_hd__decap_40_12
X_3669_ _4513_/A _3919_/B VGND VGND VPWR VPWR _3678_/S sky130_fd_sc_hd__or2_4
XANTENNA_clkbuf_leaf_45_clk_A clkload4/A VGND VGND VPWR VPWR sky130_fd_sc_hd__diode_2
XTAP_TAPCELL_ROW_132_2285 VGND VPWR sky130_fd_sc_hd__tapvpwrvgnd_1
X_5408_ _6252_/CLK _5408_/D VGND VGND VPWR VPWR _5408_/Q sky130_fd_sc_hd__dfxtp_1
Xclkload91 _5849_/CLK VGND VGND VPWR VPWR clkload91/Y sky130_fd_sc_hd__clkinv_8
X_6388_ _6388_/CLK _6388_/D VGND VGND VPWR VPWR _6388_/Q sky130_fd_sc_hd__dfxtp_4
XANTENNA__4504__A1 _5208_/A1 VGND VGND VPWR VPWR sky130_fd_sc_hd__diode_2
XFILLER_87_221 VGND VGND VPWR VPWR sky130_fd_sc_hd__fill_1
XFILLER_87_210 VGND VGND VPWR VPWR sky130_fd_sc_hd__fill_1
XFILLER_0_615 VGND VGND VPWR VPWR sky130_fd_sc_hd__fill_1
X_5339_ clkload9/A _5339_/D VGND VGND VPWR VPWR _5339_/Q sky130_fd_sc_hd__dfxtp_1
XFILLER_130_841 VGND VGND VPWR VPWR sky130_fd_sc_hd__fill_1
XANTENNA__3514__S _3516_/S VGND VGND VPWR VPWR sky130_fd_sc_hd__diode_2
XFILLER_88_755 VGND VGND VPWR VPWR sky130_fd_sc_hd__fill_1
XFILLER_102_587 VGND VGND VPWR VPWR sky130_fd_sc_hd__fill_1
Xclkbuf_leaf_67_clk clkload5/A VGND VGND VPWR VPWR _6298_/CLK sky130_fd_sc_hd__clkbuf_8
XFILLER_29_833 VGND VGND VPWR VPWR sky130_fd_sc_hd__fill_4
XFILLER_55_140 VGND VGND VPWR VPWR sky130_fd_sc_hd__fill_4
XFILLER_44_825 VPWR VGND VPWR VGND sky130_ef_sc_hd__decap_40_12
XANTENNA_clkbuf_leaf_103_clk_A clkload0/A VGND VGND VPWR VPWR sky130_fd_sc_hd__diode_2
XFILLER_18_54 VGND VGND VPWR VPWR sky130_fd_sc_hd__fill_1
XTAP_TAPCELL_ROW_48_1025 VGND VPWR sky130_fd_sc_hd__tapvpwrvgnd_1
XTAP_TAPCELL_ROW_48_1014 VGND VPWR sky130_fd_sc_hd__tapvpwrvgnd_1
XTAP_TAPCELL_ROW_39_883 VGND VPWR sky130_fd_sc_hd__tapvpwrvgnd_1
XFILLER_34_31 VGND VGND VPWR VPWR sky130_fd_sc_hd__fill_1
XANTENNA__4440__B1 _4445_/B VGND VGND VPWR VPWR sky130_fd_sc_hd__diode_2
XTAP_TAPCELL_ROW_61_1214 VGND VPWR sky130_fd_sc_hd__tapvpwrvgnd_1
XFILLER_34_53 VGND VGND VPWR VPWR sky130_fd_sc_hd__fill_1
XANTENNA__4991__A1 _5045_/A1 VGND VGND VPWR VPWR sky130_fd_sc_hd__diode_2
XFILLER_12_755 VGND VGND VPWR VPWR sky130_fd_sc_hd__fill_1
XFILLER_8_737 VPWR VGND VPWR VGND sky130_ef_sc_hd__decap_40_12
XFILLER_137_473 VPWR VGND VPWR VGND sky130_ef_sc_hd__decap_40_12
XFILLER_125_613 VGND VGND VPWR VPWR sky130_fd_sc_hd__fill_2
XFILLER_124_112 VGND VGND VPWR VPWR sky130_fd_sc_hd__fill_4
XTAP_TAPCELL_ROW_59_1187 VGND VPWR sky130_fd_sc_hd__tapvpwrvgnd_1
XFILLER_3_497 VGND VGND VPWR VPWR sky130_fd_sc_hd__fill_4
XFILLER_121_841 VGND VGND VPWR VPWR sky130_fd_sc_hd__fill_1
XTAP_TAPCELL_ROW_72_1387 VGND VPWR sky130_fd_sc_hd__tapvpwrvgnd_1
XTAP_TAPCELL_ROW_72_1376 VGND VPWR sky130_fd_sc_hd__tapvpwrvgnd_1
XFILLER_120_362 VGND VGND VPWR VPWR sky130_fd_sc_hd__fill_2
XFILLER_94_725 VPWR VGND VPWR VGND sky130_ef_sc_hd__decap_40_12
XFILLER_78_265 VGND VGND VPWR VPWR sky130_fd_sc_hd__fill_2
XFILLER_39_619 VGND VGND VPWR VPWR sky130_fd_sc_hd__fill_1
Xclkbuf_leaf_58_clk clkload6/A VGND VGND VPWR VPWR _6233_/CLK sky130_fd_sc_hd__clkbuf_8
XFILLER_94_769 VPWR VGND VPWR VGND sky130_ef_sc_hd__decap_40_12
XFILLER_93_279 VGND VGND VPWR VPWR sky130_fd_sc_hd__fill_1
XFILLER_75_82 VGND VGND VPWR VPWR sky130_fd_sc_hd__fill_2
XANTENNA__3482__A1 _5818_/Q VGND VGND VPWR VPWR sky130_fd_sc_hd__diode_2
XANTENNA_output31_A _6459_/A VGND VGND VPWR VPWR sky130_fd_sc_hd__diode_2
XANTENNA__3379__B input5/X VGND VGND VPWR VPWR sky130_fd_sc_hd__diode_2
XTAP_TAPCELL_ROW_17_555 VGND VPWR sky130_fd_sc_hd__tapvpwrvgnd_1
X_2971_ _6430_/Q _5315_/Q _3072_/S VGND VGND VPWR VPWR _2971_/X sky130_fd_sc_hd__mux2_1
XFILLER_62_699 VGND VGND VPWR VPWR sky130_fd_sc_hd__fill_1
X_5690_ _6098_/CLK _5690_/D VGND VGND VPWR VPWR _5690_/Q sky130_fd_sc_hd__dfxtp_1
X_4710_ _6095_/Q _5875_/Q _4795_/S VGND VGND VPWR VPWR _4710_/X sky130_fd_sc_hd__mux2_1
XANTENNA__4982__A1 _4982_/A1 VGND VGND VPWR VPWR sky130_fd_sc_hd__diode_2
X_4641_ hold25/A _5668_/Q _4810_/S VGND VGND VPWR VPWR _4641_/X sky130_fd_sc_hd__mux2_1
XANTENNA__4734__A1 _4791_/A1 VGND VGND VPWR VPWR sky130_fd_sc_hd__diode_2
XFILLER_116_613 VPWR VGND VPWR VGND sky130_ef_sc_hd__decap_40_12
X_4572_ _5603_/Q _5684_/Q _6090_/Q hold143/X _4795_/S _4794_/A VGND VGND VPWR VPWR
+ _4572_/X sky130_fd_sc_hd__mux4_1
X_3523_ _4887_/A1 _3523_/A1 _3529_/S VGND VGND VPWR VPWR _3523_/X sky130_fd_sc_hd__mux2_1
XFILLER_116_657 VPWR VGND VPWR VGND sky130_ef_sc_hd__decap_40_12
Xhold704 _5278_/Q VGND VGND VPWR VPWR hold704/X sky130_fd_sc_hd__dlygate4sd3_1
Xhold715 _3423_/X VGND VGND VPWR VPWR _5476_/D sky130_fd_sc_hd__dlygate4sd3_1
XFILLER_7_781 VGND VGND VPWR VPWR sky130_fd_sc_hd__fill_2
X_6311_ _6316_/CLK _6311_/D VGND VGND VPWR VPWR _6311_/Q sky130_fd_sc_hd__dfxtp_1
Xhold737 _6267_/Q VGND VGND VPWR VPWR hold737/X sky130_fd_sc_hd__dlygate4sd3_1
Xhold726 _6084_/Q VGND VGND VPWR VPWR hold726/X sky130_fd_sc_hd__dlygate4sd3_1
Xhold759 _6245_/Q VGND VGND VPWR VPWR hold759/X sky130_fd_sc_hd__dlygate4sd3_1
X_3454_ hold505/X _4445_/A _3463_/S VGND VGND VPWR VPWR _3454_/X sky130_fd_sc_hd__mux2_1
X_6242_ _6242_/CLK _6242_/D VGND VGND VPWR VPWR _6242_/Q sky130_fd_sc_hd__dfxtp_1
XFILLER_89_519 VGND VGND VPWR VPWR sky130_fd_sc_hd__fill_1
Xhold748 _4508_/X VGND VGND VPWR VPWR _6112_/D sky130_fd_sc_hd__dlygate4sd3_1
XFILLER_112_841 VGND VGND VPWR VPWR sky130_fd_sc_hd__fill_1
X_6173_ _6233_/CLK _6173_/D VGND VGND VPWR VPWR _6173_/Q sky130_fd_sc_hd__dfxtp_1
XFILLER_97_552 VGND VGND VPWR VPWR sky130_fd_sc_hd__fill_8
Xhold2105 _6393_/Q VGND VGND VPWR VPWR _5142_/A sky130_fd_sc_hd__dlygate4sd3_1
XFILLER_69_221 VGND VGND VPWR VPWR sky130_fd_sc_hd__fill_2
Xhold2116 _6401_/Q VGND VGND VPWR VPWR _3952_/B sky130_fd_sc_hd__dlygate4sd3_1
Xhold2127 _6388_/Q VGND VGND VPWR VPWR _3975_/A sky130_fd_sc_hd__dlygate4sd3_1
X_3385_ hold212/X _4929_/A1 _3390_/S VGND VGND VPWR VPWR _3385_/X sky130_fd_sc_hd__mux2_1
XANTENNA__3170__B1 _5034_/B VGND VGND VPWR VPWR sky130_fd_sc_hd__diode_2
XFILLER_97_585 VPWR VGND VPWR VGND sky130_ef_sc_hd__decap_40_12
Xhold1404 _6189_/Q VGND VGND VPWR VPWR _4836_/A1 sky130_fd_sc_hd__dlygate4sd3_1
Xhold2138 _6400_/Q VGND VGND VPWR VPWR _3952_/C sky130_fd_sc_hd__dlygate4sd3_1
X_5124_ _2626_/Y _5194_/S _3956_/Y VGND VGND VPWR VPWR _5124_/X sky130_fd_sc_hd__o21a_1
Xhold2149 _3832_/X VGND VGND VPWR VPWR _3833_/B sky130_fd_sc_hd__dlygate4sd3_1
XFILLER_57_405 VPWR VGND VPWR VGND sky130_ef_sc_hd__decap_40_12
Xhold1415 _6013_/Q VGND VGND VPWR VPWR _4372_/A1 sky130_fd_sc_hd__dlygate4sd3_1
Xhold1459 _3498_/X VGND VGND VPWR VPWR _5543_/D sky130_fd_sc_hd__dlygate4sd3_1
Xclkbuf_leaf_49_clk clkload4/A VGND VGND VPWR VPWR _6222_/CLK sky130_fd_sc_hd__clkbuf_8
XANTENNA_fanout185_A _3020_/A VGND VGND VPWR VPWR sky130_fd_sc_hd__diode_2
X_5055_ hold16/X _5827_/Q _5059_/S VGND VGND VPWR VPWR hold17/A sky130_fd_sc_hd__mux2_1
Xhold1426 _3609_/X VGND VGND VPWR VPWR _5640_/D sky130_fd_sc_hd__dlygate4sd3_1
Xhold1437 _5586_/Q VGND VGND VPWR VPWR _3545_/A0 sky130_fd_sc_hd__dlygate4sd3_1
Xhold1448 _4395_/X VGND VGND VPWR VPWR _6034_/D sky130_fd_sc_hd__dlygate4sd3_1
X_4006_ _5110_/A _3983_/Y _3959_/A VGND VGND VPWR VPWR _4006_/Y sky130_fd_sc_hd__a21oi_1
XFILLER_26_825 VPWR VGND VPWR VGND sky130_ef_sc_hd__decap_40_12
XTAP_TAPCELL_ROW_36_842 VGND VPWR sky130_fd_sc_hd__tapvpwrvgnd_1
XTAP_TAPCELL_ROW_101_1815 VGND VPWR sky130_fd_sc_hd__tapvpwrvgnd_1
XANTENNA__4648__S1 _4789_/A VGND VGND VPWR VPWR sky130_fd_sc_hd__diode_2
XFILLER_71_29 VGND VGND VPWR VPWR sky130_fd_sc_hd__fill_2
XANTENNA__3225__B2 _4802_/A VGND VGND VPWR VPWR sky130_fd_sc_hd__diode_2
X_5957_ _5990_/CLK _5957_/D VGND VGND VPWR VPWR _5957_/Q sky130_fd_sc_hd__dfxtp_1
XFILLER_40_316 VGND VGND VPWR VPWR sky130_fd_sc_hd__fill_4
XFILLER_41_839 VGND VGND VPWR VPWR sky130_fd_sc_hd__fill_1
X_4908_ _4908_/A _4922_/B _4922_/C VGND VGND VPWR VPWR _4908_/X sky130_fd_sc_hd__or3_1
XANTENNA_fanout140_X _2628_/A VGND VGND VPWR VPWR sky130_fd_sc_hd__diode_2
XFILLER_21_541 VGND VGND VPWR VPWR sky130_fd_sc_hd__fill_8
X_5888_ _6417_/CLK _5888_/D VGND VGND VPWR VPWR _5888_/Q sky130_fd_sc_hd__dfxtp_1
XTAP_TAPCELL_ROW_134_2314 VGND VPWR sky130_fd_sc_hd__tapvpwrvgnd_1
XTAP_TAPCELL_ROW_134_2303 VGND VPWR sky130_fd_sc_hd__tapvpwrvgnd_1
XANTENNA__3509__S _3516_/S VGND VGND VPWR VPWR sky130_fd_sc_hd__diode_2
X_4839_ _4904_/A0 _4839_/A1 _4841_/S VGND VGND VPWR VPWR _4839_/X sky130_fd_sc_hd__mux2_1
XFILLER_21_585 VGND VGND VPWR VPWR sky130_fd_sc_hd__fill_8
XFILLER_107_613 VGND VGND VPWR VPWR sky130_fd_sc_hd__fill_2
XANTENNA__3084__S0 _2963_/S VGND VGND VPWR VPWR sky130_fd_sc_hd__diode_2
XFILLER_5_729 VPWR VGND VPWR VGND sky130_ef_sc_hd__decap_40_12
XFILLER_134_421 VGND VGND VPWR VPWR sky130_fd_sc_hd__fill_1
XANTENNA__4489__A0 _4961_/A0 VGND VGND VPWR VPWR sky130_fd_sc_hd__diode_2
XFILLER_96_15 VPWR VGND VPWR VGND sky130_ef_sc_hd__decap_40_12
XANTENNA_fanout98_A _5045_/A1 VGND VGND VPWR VPWR sky130_fd_sc_hd__diode_2
XFILLER_121_126 VGND VGND VPWR VPWR sky130_fd_sc_hd__fill_2
XTAP_TAPCELL_ROW_112_1977 VGND VPWR sky130_fd_sc_hd__tapvpwrvgnd_1
XFILLER_103_841 VGND VGND VPWR VPWR sky130_fd_sc_hd__fill_1
XFILLER_0_434 VGND VGND VPWR VPWR sky130_fd_sc_hd__fill_2
XFILLER_0_445 VGND VGND VPWR VPWR sky130_fd_sc_hd__fill_2
Xhold20 hold20/A VGND VGND VPWR VPWR hold20/X sky130_fd_sc_hd__dlygate4sd3_1
Xhold31 hold31/A VGND VGND VPWR VPWR hold31/X sky130_fd_sc_hd__dlygate4sd3_1
XFILLER_0_489 VPWR VGND VPWR VGND sky130_ef_sc_hd__decap_40_12
XFILLER_130_693 VGND VGND VPWR VPWR sky130_fd_sc_hd__fill_4
XFILLER_76_747 VGND VGND VPWR VPWR sky130_fd_sc_hd__fill_8
XFILLER_75_213 VGND VGND VPWR VPWR sky130_fd_sc_hd__fill_8
Xhold42 hold42/A VGND VGND VPWR VPWR hold42/X sky130_fd_sc_hd__dlygate4sd3_1
Xhold53 hold53/A VGND VGND VPWR VPWR hold53/X sky130_fd_sc_hd__dlygate4sd3_1
Xhold64 hold64/A VGND VGND VPWR VPWR hold64/X sky130_fd_sc_hd__dlygate4sd3_1
XFILLER_90_205 VGND VGND VPWR VPWR sky130_fd_sc_hd__fill_1
Xhold86 hold86/A VGND VGND VPWR VPWR hold86/X sky130_fd_sc_hd__dlygate4sd3_1
Xhold1971 _3151_/X VGND VGND VPWR VPWR _5332_/D sky130_fd_sc_hd__dlygate4sd3_1
XFILLER_75_279 VGND VGND VPWR VPWR sky130_fd_sc_hd__fill_1
Xhold1960 _5337_/Q VGND VGND VPWR VPWR _5067_/A0 sky130_fd_sc_hd__dlygate4sd3_1
XFILLER_63_419 VGND VGND VPWR VPWR sky130_fd_sc_hd__fill_1
Xhold75 hold75/A VGND VGND VPWR VPWR hold75/X sky130_fd_sc_hd__dlygate4sd3_1
Xhold97 hold97/A VGND VGND VPWR VPWR hold97/X sky130_fd_sc_hd__dlygate4sd3_1
XANTENNA__2898__S0 _3062_/S VGND VGND VPWR VPWR sky130_fd_sc_hd__diode_2
Xhold1993 _5807_/Q VGND VGND VPWR VPWR _3800_/A2 sky130_fd_sc_hd__dlygate4sd3_1
Xhold1982 _5925_/Q VGND VGND VPWR VPWR _4219_/A1 sky130_fd_sc_hd__dlygate4sd3_1
XFILLER_90_249 VGND VGND VPWR VPWR sky130_fd_sc_hd__fill_1
XFILLER_43_132 VGND VGND VPWR VPWR sky130_fd_sc_hd__fill_4
XFILLER_45_85 VGND VGND VPWR VPWR sky130_fd_sc_hd__fill_1
XTAP_TAPCELL_ROW_14_503 VGND VPWR sky130_fd_sc_hd__tapvpwrvgnd_1
XANTENNA__4413__A0 _4981_/A1 VGND VGND VPWR VPWR sky130_fd_sc_hd__diode_2
XTAP_TAPCELL_ROW_14_514 VGND VPWR sky130_fd_sc_hd__tapvpwrvgnd_1
XANTENNA__4803__S _4803_/S VGND VGND VPWR VPWR sky130_fd_sc_hd__diode_2
XFILLER_8_501 VPWR VGND VPWR VGND sky130_ef_sc_hd__decap_40_12
XFILLER_129_248 VGND VGND VPWR VPWR sky130_fd_sc_hd__fill_1
XFILLER_8_545 VPWR VGND VPWR VGND sky130_ef_sc_hd__decap_40_12
XFILLER_12_585 VGND VGND VPWR VPWR sky130_fd_sc_hd__fill_2
XFILLER_8_589 VPWR VGND VPWR VGND sky130_ef_sc_hd__decap_40_12
XFILLER_6_57 VGND VGND VPWR VPWR sky130_fd_sc_hd__fill_2
XANTENNA__2822__S0 _3077_/S VGND VGND VPWR VPWR sky130_fd_sc_hd__diode_2
XTAP_TAPCELL_ROW_74_1416 VGND VPWR sky130_fd_sc_hd__tapvpwrvgnd_1
XTAP_TAPCELL_ROW_74_1405 VGND VPWR sky130_fd_sc_hd__tapvpwrvgnd_1
XFILLER_99_839 VGND VGND VPWR VPWR sky130_fd_sc_hd__fill_1
XFILLER_112_137 VGND VGND VPWR VPWR sky130_fd_sc_hd__fill_1
XFILLER_121_671 VGND VGND VPWR VPWR sky130_fd_sc_hd__fill_1
X_3170_ _3172_/B _3172_/C _5034_/B VGND VGND VPWR VPWR _3171_/B sky130_fd_sc_hd__o21ai_1
XFILLER_94_533 VPWR VGND VPWR VGND sky130_ef_sc_hd__decap_40_12
XFILLER_94_522 VGND VGND VPWR VPWR sky130_fd_sc_hd__fill_8
XANTENNA__4774__A _4789_/A VGND VGND VPWR VPWR sky130_fd_sc_hd__diode_2
XANTENNA__3455__A1 _5241_/A1 VGND VGND VPWR VPWR sky130_fd_sc_hd__diode_2
XANTENNA__4652__B1 _4791_/B1 VGND VGND VPWR VPWR sky130_fd_sc_hd__diode_2
XTAP_TAPCELL_ROW_85_1578 VGND VPWR sky130_fd_sc_hd__tapvpwrvgnd_1
X_5811_ _6065_/CLK _5811_/D VGND VGND VPWR VPWR _5811_/Q sky130_fd_sc_hd__dfxtp_4
XANTENNA__4404__A0 _5045_/A1 VGND VGND VPWR VPWR sky130_fd_sc_hd__diode_2
XFILLER_23_839 VGND VGND VPWR VPWR sky130_fd_sc_hd__fill_1
XTAP_TAPCELL_ROW_33_801 VGND VPWR sky130_fd_sc_hd__tapvpwrvgnd_1
XANTENNA__4713__S _4713_/S VGND VGND VPWR VPWR sky130_fd_sc_hd__diode_2
X_5742_ _6307_/CLK _5742_/D VGND VGND VPWR VPWR _5742_/Q sky130_fd_sc_hd__dfxtp_1
X_2954_ hold455/X _3011_/A _2953_/X VGND VGND VPWR VPWR _2954_/X sky130_fd_sc_hd__a21o_1
X_2885_ _3029_/A _2885_/B VGND VGND VPWR VPWR _2885_/X sky130_fd_sc_hd__or2_1
X_5673_ _5902_/CLK _5673_/D VGND VGND VPWR VPWR _5673_/Q sky130_fd_sc_hd__dfxtp_1
XTAP_TAPCELL_ROW_116_2044 VGND VPWR sky130_fd_sc_hd__tapvpwrvgnd_1
XTAP_TAPCELL_ROW_116_2033 VGND VPWR sky130_fd_sc_hd__tapvpwrvgnd_1
XANTENNA__4707__A1 _4791_/A1 VGND VGND VPWR VPWR sky130_fd_sc_hd__diode_2
X_4624_ _5863_/Q _5854_/Q _4778_/S VGND VGND VPWR VPWR _4625_/B sky130_fd_sc_hd__mux2_1
XPHY_EDGE_ROW_6_Right_6 VGND VGND VPWR VPWR sky130_fd_sc_hd__decap_3
Xhold501 _5299_/Q VGND VGND VPWR VPWR hold501/X sky130_fd_sc_hd__dlygate4sd3_1
X_4555_ _4555_/A0 _4887_/A1 _4561_/S VGND VGND VPWR VPWR _4555_/X sky130_fd_sc_hd__mux2_1
Xhold523 _4526_/X VGND VGND VPWR VPWR _6128_/D sky130_fd_sc_hd__dlygate4sd3_1
X_3506_ _4883_/A1 _3506_/A1 _3516_/S VGND VGND VPWR VPWR _5550_/D sky130_fd_sc_hd__mux2_1
Xhold512 _6324_/Q VGND VGND VPWR VPWR hold512/X sky130_fd_sc_hd__dlygate4sd3_1
Xhold545 _6022_/Q VGND VGND VPWR VPWR hold545/X sky130_fd_sc_hd__dlygate4sd3_1
XANTENNA_fanout100_A _5828_/Q VGND VGND VPWR VPWR sky130_fd_sc_hd__diode_2
Xhold534 _5985_/Q VGND VGND VPWR VPWR hold534/X sky130_fd_sc_hd__dlygate4sd3_1
Xhold556 _6075_/Q VGND VGND VPWR VPWR hold556/X sky130_fd_sc_hd__dlygate4sd3_1
X_4486_ _4958_/A0 _4486_/A1 _4488_/S VGND VGND VPWR VPWR _6092_/D sky130_fd_sc_hd__mux2_1
Xhold567 _4356_/X VGND VGND VPWR VPWR _5999_/D sky130_fd_sc_hd__dlygate4sd3_1
Xhold578 _6319_/Q VGND VGND VPWR VPWR hold578/X sky130_fd_sc_hd__dlygate4sd3_1
X_3437_ hold702/X _4906_/A0 _3437_/S VGND VGND VPWR VPWR _3437_/X sky130_fd_sc_hd__mux2_1
X_6225_ _6237_/CLK _6225_/D VGND VGND VPWR VPWR _6225_/Q sky130_fd_sc_hd__dfxtp_1
Xhold589 _4500_/X VGND VGND VPWR VPWR _6105_/D sky130_fd_sc_hd__dlygate4sd3_1
XFILLER_106_58 VGND VGND VPWR VPWR sky130_fd_sc_hd__fill_2
XFILLER_100_811 VGND VGND VPWR VPWR sky130_fd_sc_hd__fill_1
X_6156_ _6237_/CLK _6156_/D VGND VGND VPWR VPWR _6156_/Q sky130_fd_sc_hd__dfxtp_1
X_3368_ _3802_/A2 input6/X VGND VGND VPWR VPWR _3801_/B sky130_fd_sc_hd__nand2b_4
XFILLER_58_703 VGND VGND VPWR VPWR sky130_fd_sc_hd__fill_1
XANTENNA__3694__A1 _4488_/A0 VGND VGND VPWR VPWR sky130_fd_sc_hd__diode_2
XANTENNA__3143__B1 _5085_/A VGND VGND VPWR VPWR sky130_fd_sc_hd__diode_2
XFILLER_112_693 VGND VGND VPWR VPWR sky130_fd_sc_hd__fill_4
Xhold1212 _4845_/X VGND VGND VPWR VPWR _6197_/D sky130_fd_sc_hd__dlygate4sd3_1
Xhold1234 _5635_/Q VGND VGND VPWR VPWR _3602_/A0 sky130_fd_sc_hd__dlygate4sd3_1
X_5107_ _6408_/Q _5101_/Y _4010_/Y VGND VGND VPWR VPWR _5108_/D sky130_fd_sc_hd__a21o_1
Xhold1201 _3754_/X VGND VGND VPWR VPWR _5767_/D sky130_fd_sc_hd__dlygate4sd3_1
Xhold1223 _5461_/Q VGND VGND VPWR VPWR _3406_/A1 sky130_fd_sc_hd__dlygate4sd3_1
Xhold1267 _5517_/Q VGND VGND VPWR VPWR _3470_/A1 sky130_fd_sc_hd__dlygate4sd3_1
X_3299_ hold821/X _5228_/A0 _3308_/S VGND VGND VPWR VPWR _3299_/X sky130_fd_sc_hd__mux2_1
XANTENNA_fanout188_X _3020_/A VGND VGND VPWR VPWR sky130_fd_sc_hd__diode_2
Xhold1245 _3512_/X VGND VGND VPWR VPWR _5556_/D sky130_fd_sc_hd__dlygate4sd3_1
X_6087_ _6114_/CLK _6087_/D VGND VGND VPWR VPWR _6087_/Q sky130_fd_sc_hd__dfxtp_1
Xhold1256 _3253_/X VGND VGND VPWR VPWR _5389_/D sky130_fd_sc_hd__dlygate4sd3_1
XANTENNA__3446__A1 _5233_/A0 VGND VGND VPWR VPWR sky130_fd_sc_hd__diode_2
Xhold1289 _5637_/Q VGND VGND VPWR VPWR _3604_/A0 sky130_fd_sc_hd__dlygate4sd3_1
XFILLER_45_419 VGND VGND VPWR VPWR sky130_fd_sc_hd__fill_2
Xhold1278 _3399_/X VGND VGND VPWR VPWR _5456_/D sky130_fd_sc_hd__dlygate4sd3_1
X_5038_ _5038_/A _5038_/B VGND VGND VPWR VPWR _5047_/S sky130_fd_sc_hd__nor2_4
XFILLER_81_783 VGND VGND VPWR VPWR sky130_fd_sc_hd__fill_1
XTAP_TAPCELL_ROW_0_286 VGND VPWR sky130_fd_sc_hd__tapvpwrvgnd_1
XTAP_TAPCELL_ROW_0_297 VGND VPWR sky130_fd_sc_hd__tapvpwrvgnd_1
XFILLER_26_699 VGND VGND VPWR VPWR sky130_fd_sc_hd__fill_1
XFILLER_15_44 VGND VGND VPWR VPWR sky130_fd_sc_hd__fill_1
XFILLER_126_207 VGND VGND VPWR VPWR sky130_fd_sc_hd__fill_2
XANTENNA__2709__A0 _5052_/A1 VGND VGND VPWR VPWR sky130_fd_sc_hd__diode_2
XFILLER_21_393 VPWR VGND VPWR VGND sky130_ef_sc_hd__decap_40_12
XFILLER_110_3 VPWR VGND VPWR VGND sky130_ef_sc_hd__decap_40_12
XFILLER_135_741 VPWR VGND VPWR VGND sky130_ef_sc_hd__decap_40_12
XFILLER_5_559 VGND VGND VPWR VPWR sky130_fd_sc_hd__fill_1
XFILLER_135_785 VPWR VGND VPWR VGND sky130_ef_sc_hd__decap_40_12
Xoutput43 _6067_/Q VGND VGND VPWR VPWR s_axil_rdata[14] sky130_fd_sc_hd__buf_2
XTAP_TAPCELL_ROW_56_1146 VGND VPWR sky130_fd_sc_hd__tapvpwrvgnd_1
XTAP_TAPCELL_ROW_56_1135 VGND VPWR sky130_fd_sc_hd__tapvpwrvgnd_1
Xoutput32 _6459_/X VGND VGND VPWR VPWR i2c_scl_t sky130_fd_sc_hd__buf_2
XFILLER_96_809 VGND VGND VPWR VPWR sky130_fd_sc_hd__fill_2
Xoutput54 _5809_/Q VGND VGND VPWR VPWR s_axil_rvalid sky130_fd_sc_hd__buf_2
XFILLER_1_721 VGND VGND VPWR VPWR sky130_fd_sc_hd__fill_4
XFILLER_103_671 VGND VGND VPWR VPWR sky130_fd_sc_hd__fill_1
XFILLER_49_725 VGND VGND VPWR VPWR sky130_fd_sc_hd__fill_2
XFILLER_1_765 VPWR VGND VPWR VGND sky130_ef_sc_hd__decap_40_12
XANTENNA__3134__B1 _5085_/A VGND VGND VPWR VPWR sky130_fd_sc_hd__diode_2
XANTENNA_input30_A s_axil_wvalid VGND VGND VPWR VPWR sky130_fd_sc_hd__diode_2
XFILLER_76_544 VGND VGND VPWR VPWR sky130_fd_sc_hd__fill_4
XANTENNA__3702__S _3707_/S VGND VGND VPWR VPWR sky130_fd_sc_hd__diode_2
XANTENNA__3437__A1 _4906_/A0 VGND VGND VPWR VPWR sky130_fd_sc_hd__diode_2
Xhold1790 _6287_/Q VGND VGND VPWR VPWR _4952_/A1 sky130_fd_sc_hd__dlygate4sd3_1
XANTENNA__4533__S _4535_/S VGND VGND VPWR VPWR sky130_fd_sc_hd__diode_2
XFILLER_44_485 VGND VGND VPWR VPWR sky130_fd_sc_hd__fill_8
XFILLER_31_124 VGND VGND VPWR VPWR sky130_fd_sc_hd__fill_4
XFILLER_20_809 VGND VGND VPWR VPWR sky130_fd_sc_hd__fill_2
XTAP_TAPCELL_ROW_80_1497 VGND VPWR sky130_fd_sc_hd__tapvpwrvgnd_1
XPHY_EDGE_ROW_59_Right_59 VGND VGND VPWR VPWR sky130_fd_sc_hd__decap_3
XFILLER_9_821 VPWR VGND VPWR VGND sky130_ef_sc_hd__decap_40_12
X_2670_ _2670_/A0 _4887_/A1 _5241_/S VGND VGND VPWR VPWR _2670_/X sky130_fd_sc_hd__mux2_1
XANTENNA__3048__S0 _3077_/S VGND VGND VPWR VPWR sky130_fd_sc_hd__diode_2
XANTENNA__3376__C input4/X VGND VGND VPWR VPWR sky130_fd_sc_hd__diode_2
X_4340_ hold534/X _4929_/A1 _4345_/S VGND VGND VPWR VPWR _4340_/X sky130_fd_sc_hd__mux2_1
XFILLER_99_669 VGND VGND VPWR VPWR sky130_fd_sc_hd__fill_2
XFILLER_87_809 VPWR VGND VPWR VGND sky130_ef_sc_hd__decap_40_12
X_4271_ _4267_/X _4268_/X _4270_/X _4269_/X _4212_/A _4271_/S1 VGND VGND VPWR VPWR
+ _4271_/X sky130_fd_sc_hd__mux4_1
XFILLER_4_581 VGND VGND VPWR VPWR sky130_fd_sc_hd__fill_4
XANTENNA_hold2232_A _5819_/Q VGND VGND VPWR VPWR sky130_fd_sc_hd__diode_2
X_3222_ _4773_/S _3222_/B VGND VGND VPWR VPWR _3222_/X sky130_fd_sc_hd__and2b_1
X_6010_ _6345_/CLK _6010_/D VGND VGND VPWR VPWR _6010_/Q sky130_fd_sc_hd__dfxtp_1
XFILLER_79_393 VGND VGND VPWR VPWR sky130_fd_sc_hd__fill_4
X_3153_ _2650_/A _3153_/A1 _3156_/S VGND VGND VPWR VPWR _3153_/X sky130_fd_sc_hd__mux2_1
XPHY_EDGE_ROW_68_Right_68 VGND VGND VPWR VPWR sky130_fd_sc_hd__decap_3
XTAP_TAPCELL_ROW_87_1607 VGND VPWR sky130_fd_sc_hd__tapvpwrvgnd_1
XANTENNA__3428__A1 _4445_/A VGND VGND VPWR VPWR sky130_fd_sc_hd__diode_2
X_3084_ _5426_/Q hold10/A _5356_/Q _5584_/Q _2963_/S _2962_/A VGND VGND VPWR VPWR
+ _3085_/B sky130_fd_sc_hd__mux4_1
XFILLER_35_441 VGND VGND VPWR VPWR sky130_fd_sc_hd__fill_1
XFILLER_63_783 VGND VGND VPWR VPWR sky130_fd_sc_hd__fill_1
XFILLER_62_282 VGND VGND VPWR VPWR sky130_fd_sc_hd__fill_1
XFILLER_50_411 VGND VGND VPWR VPWR sky130_fd_sc_hd__fill_1
XTAP_TAPCELL_ROW_46_992 VGND VPWR sky130_fd_sc_hd__tapvpwrvgnd_1
XFILLER_22_113 VGND VGND VPWR VPWR sky130_fd_sc_hd__fill_2
XPHY_EDGE_ROW_77_Right_77 VGND VGND VPWR VPWR sky130_fd_sc_hd__decap_3
X_3986_ _5117_/A _3958_/Y _3985_/Y _5034_/B VGND VGND VPWR VPWR _5915_/D sky130_fd_sc_hd__o211a_1
XANTENNA__4928__A1 _4978_/A1 VGND VGND VPWR VPWR sky130_fd_sc_hd__diode_2
XFILLER_11_809 VPWR VGND VPWR VGND sky130_ef_sc_hd__decap_40_12
XFILLER_23_669 VGND VGND VPWR VPWR sky130_fd_sc_hd__fill_2
XANTENNA_fanout148_A _4810_/S VGND VGND VPWR VPWR sky130_fd_sc_hd__diode_2
X_2937_ _2933_/X _2935_/X _2936_/X _3096_/A1 VGND VGND VPWR VPWR _2937_/X sky130_fd_sc_hd__a22o_1
XANTENNA__3600__A1 _5211_/A1 VGND VGND VPWR VPWR sky130_fd_sc_hd__diode_2
X_5725_ _6290_/CLK _5725_/D VGND VGND VPWR VPWR _5725_/Q sky130_fd_sc_hd__dfxtp_1
X_5656_ _5714_/CLK _5656_/D VGND VGND VPWR VPWR _5656_/Q sky130_fd_sc_hd__dfxtp_1
XTAP_TAPCELL_ROW_98_1769 VGND VPWR sky130_fd_sc_hd__tapvpwrvgnd_1
X_2868_ _3148_/A1 _2867_/X _2982_/S VGND VGND VPWR VPWR _2868_/X sky130_fd_sc_hd__mux2_1
X_4607_ _5595_/Q _5586_/Q _4778_/S VGND VGND VPWR VPWR _4607_/X sky130_fd_sc_hd__mux2_1
Xhold320 _3110_/X VGND VGND VPWR VPWR _5305_/D sky130_fd_sc_hd__dlygate4sd3_1
XFILLER_117_741 VPWR VGND VPWR VGND sky130_ef_sc_hd__decap_40_12
X_2799_ _3029_/A _2799_/B VGND VGND VPWR VPWR _2799_/X sky130_fd_sc_hd__or2_1
XANTENNA__4787__S0 _4773_/S VGND VGND VPWR VPWR sky130_fd_sc_hd__diode_2
X_5587_ _6094_/CLK _5587_/D VGND VGND VPWR VPWR _5587_/Q sky130_fd_sc_hd__dfxtp_1
XANTENNA__3364__B1 _5201_/B VGND VGND VPWR VPWR sky130_fd_sc_hd__diode_2
X_4538_ hold250/X _5228_/A0 _4547_/S VGND VGND VPWR VPWR _4538_/X sky130_fd_sc_hd__mux2_1
XFILLER_117_785 VPWR VGND VPWR VGND sky130_ef_sc_hd__decap_40_12
Xhold353 _6146_/Q VGND VGND VPWR VPWR hold353/X sky130_fd_sc_hd__dlygate4sd3_1
XFILLER_89_113 VGND VGND VPWR VPWR sky130_fd_sc_hd__fill_2
Xhold342 _3593_/X VGND VGND VPWR VPWR _5627_/D sky130_fd_sc_hd__dlygate4sd3_1
XANTENNA_fanout103_X _4980_/A1 VGND VGND VPWR VPWR sky130_fd_sc_hd__diode_2
XFILLER_2_529 VGND VGND VPWR VPWR sky130_fd_sc_hd__fill_2
Xhold331 _6086_/Q VGND VGND VPWR VPWR hold331/X sky130_fd_sc_hd__dlygate4sd3_1
XFILLER_132_755 VGND VGND VPWR VPWR sky130_fd_sc_hd__fill_1
XFILLER_117_79 VGND VGND VPWR VPWR sky130_fd_sc_hd__fill_1
X_4469_ _5234_/A0 hold685/X _4472_/S VGND VGND VPWR VPWR _6077_/D sky130_fd_sc_hd__mux2_1
Xhold364 _4888_/X VGND VGND VPWR VPWR _6237_/D sky130_fd_sc_hd__dlygate4sd3_1
XFILLER_89_124 VGND VGND VPWR VPWR sky130_fd_sc_hd__fill_2
XFILLER_78_809 VGND VGND VPWR VPWR sky130_fd_sc_hd__fill_2
Xhold375 _5453_/Q VGND VGND VPWR VPWR hold375/X sky130_fd_sc_hd__dlygate4sd3_1
Xhold386 _3657_/X VGND VGND VPWR VPWR _5683_/D sky130_fd_sc_hd__dlygate4sd3_1
X_6208_ _6232_/CLK _6208_/D VGND VGND VPWR VPWR _6208_/Q sky130_fd_sc_hd__dfxtp_1
XPHY_EDGE_ROW_86_Right_86 VGND VGND VPWR VPWR sky130_fd_sc_hd__decap_3
Xhold397 _6067_/Q VGND VGND VPWR VPWR hold397/X sky130_fd_sc_hd__dlygate4sd3_1
XTAP_TAPCELL_ROW_129_2235 VGND VPWR sky130_fd_sc_hd__tapvpwrvgnd_1
XANTENNA__4864__A0 _4903_/A0 VGND VGND VPWR VPWR sky130_fd_sc_hd__diode_2
XANTENNA__3522__S _3529_/S VGND VGND VPWR VPWR sky130_fd_sc_hd__diode_2
X_6139_ _6143_/CLK _6139_/D VGND VGND VPWR VPWR _6139_/Q sky130_fd_sc_hd__dfxtp_1
Xhold1042 _6249_/Q VGND VGND VPWR VPWR _4901_/A1 sky130_fd_sc_hd__dlygate4sd3_1
XFILLER_100_641 VGND VGND VPWR VPWR sky130_fd_sc_hd__fill_2
XTAP_TAPCELL_ROW_51_1065 VGND VPWR sky130_fd_sc_hd__tapvpwrvgnd_1
XTAP_TAPCELL_ROW_5_378 VGND VPWR sky130_fd_sc_hd__tapvpwrvgnd_1
Xhold1020 _5441_/Q VGND VGND VPWR VPWR _3382_/A0 sky130_fd_sc_hd__dlygate4sd3_1
Xhold1031 _3794_/X VGND VGND VPWR VPWR _5801_/D sky130_fd_sc_hd__dlygate4sd3_1
XFILLER_93_27 VPWR VGND VPWR VGND sky130_ef_sc_hd__decap_40_12
XFILLER_85_363 VGND VGND VPWR VPWR sky130_fd_sc_hd__fill_1
XFILLER_73_503 VGND VGND VPWR VPWR sky130_fd_sc_hd__fill_1
XANTENNA__3419__A1 _5212_/A1 VGND VGND VPWR VPWR sky130_fd_sc_hd__diode_2
XFILLER_58_599 VGND VGND VPWR VPWR sky130_fd_sc_hd__fill_1
Xhold1075 _4398_/X VGND VGND VPWR VPWR _6036_/D sky130_fd_sc_hd__dlygate4sd3_1
XFILLER_18_419 VGND VGND VPWR VPWR sky130_fd_sc_hd__fill_1
Xhold1064 _5792_/Q VGND VGND VPWR VPWR _3784_/A0 sky130_fd_sc_hd__dlygate4sd3_1
Xhold1053 _3908_/X VGND VGND VPWR VPWR _5887_/D sky130_fd_sc_hd__dlygate4sd3_1
XFILLER_39_780 VGND VGND VPWR VPWR sky130_fd_sc_hd__fill_4
Xhold1097 _3474_/X VGND VGND VPWR VPWR _5521_/D sky130_fd_sc_hd__dlygate4sd3_1
Xhold1086 _5952_/Q VGND VGND VPWR VPWR _4302_/A0 sky130_fd_sc_hd__dlygate4sd3_1
XTAP_TAPCELL_ROW_107_1898 VGND VPWR sky130_fd_sc_hd__tapvpwrvgnd_1
XPHY_EDGE_ROW_95_Right_95 VGND VGND VPWR VPWR sky130_fd_sc_hd__decap_3
XFILLER_13_102 VGND VGND VPWR VPWR sky130_fd_sc_hd__fill_4
XFILLER_14_625 VPWR VGND VPWR VGND sky130_ef_sc_hd__decap_40_12
XFILLER_41_433 VGND VGND VPWR VPWR sky130_fd_sc_hd__fill_1
XFILLER_14_669 VPWR VGND VPWR VGND sky130_ef_sc_hd__decap_40_12
XTAP_TAPCELL_ROW_24_653 VGND VPWR sky130_fd_sc_hd__tapvpwrvgnd_1
XANTENNA__4353__S _4356_/S VGND VGND VPWR VPWR sky130_fd_sc_hd__diode_2
XTAP_TAPCELL_ROW_24_664 VGND VPWR sky130_fd_sc_hd__tapvpwrvgnd_1
XFILLER_127_505 VPWR VGND VPWR VGND sky130_ef_sc_hd__decap_40_12
XFILLER_6_813 VPWR VGND VPWR VGND sky130_ef_sc_hd__decap_40_12
XFILLER_5_389 VGND VGND VPWR VPWR sky130_fd_sc_hd__fill_2
XPHY_EDGE_ROW_2_Left_141 VGND VGND VPWR VPWR sky130_fd_sc_hd__decap_3
XPHY_EDGE_ROW_39_Left_178 VGND VGND VPWR VPWR sky130_fd_sc_hd__decap_3
XFILLER_107_295 VGND VGND VPWR VPWR sky130_fd_sc_hd__fill_4
XFILLER_123_777 VGND VGND VPWR VPWR sky130_fd_sc_hd__fill_4
XFILLER_110_449 VGND VGND VPWR VPWR sky130_fd_sc_hd__fill_1
XFILLER_3_69 VPWR VGND VPWR VGND sky130_ef_sc_hd__decap_40_12
XFILLER_1_573 VPWR VGND VPWR VGND sky130_ef_sc_hd__decap_40_12
XANTENNA__3432__S _3437_/S VGND VGND VPWR VPWR sky130_fd_sc_hd__diode_2
XFILLER_67_72 VGND VGND VPWR VPWR sky130_fd_sc_hd__fill_1
XFILLER_91_311 VGND VGND VPWR VPWR sky130_fd_sc_hd__fill_1
XTAP_TAPCELL_ROW_69_1337 VGND VPWR sky130_fd_sc_hd__tapvpwrvgnd_1
XPHY_EDGE_ROW_48_Left_187 VGND VGND VPWR VPWR sky130_fd_sc_hd__decap_3
XANTENNA__4083__B2 _4149_/A VGND VGND VPWR VPWR sky130_fd_sc_hd__diode_2
XFILLER_17_441 VGND VGND VPWR VPWR sky130_fd_sc_hd__fill_4
XTAP_TAPCELL_ROW_82_1537 VGND VPWR sky130_fd_sc_hd__tapvpwrvgnd_1
XTAP_TAPCELL_ROW_82_1526 VGND VPWR sky130_fd_sc_hd__tapvpwrvgnd_1
XANTENNA__3830__A1 _5045_/A1 VGND VGND VPWR VPWR sky130_fd_sc_hd__diode_2
XFILLER_17_485 VPWR VGND VPWR VGND sky130_ef_sc_hd__decap_40_12
X_3840_ _3840_/A _3852_/B VGND VGND VPWR VPWR _3840_/X sky130_fd_sc_hd__or2_1
XTAP_TAPCELL_ROW_43_951 VGND VPWR sky130_fd_sc_hd__tapvpwrvgnd_1
XTAP_TAPCELL_ROW_43_940 VGND VPWR sky130_fd_sc_hd__tapvpwrvgnd_1
XFILLER_60_797 VPWR VGND VPWR VGND sky130_ef_sc_hd__decap_40_12
X_3771_ _4929_/A1 _4105_/A0 _3776_/S VGND VGND VPWR VPWR _3771_/X sky130_fd_sc_hd__mux2_1
X_5510_ _6252_/CLK _5510_/D VGND VGND VPWR VPWR _5510_/Q sky130_fd_sc_hd__dfxtp_1
X_2722_ _2722_/A _2722_/B _2722_/C _2664_/D VGND VGND VPWR VPWR _2723_/B sky130_fd_sc_hd__nor4b_2
XANTENNA__3955__X _3959_/A VGND VGND VPWR VPWR sky130_fd_sc_hd__diode_2
XFILLER_73_3 VPWR VGND VPWR VGND sky130_ef_sc_hd__decap_40_12
XFILLER_9_673 VPWR VGND VPWR VGND sky130_ef_sc_hd__decap_40_12
XPHY_EDGE_ROW_57_Left_196 VGND VGND VPWR VPWR sky130_fd_sc_hd__decap_3
X_2653_ hold1/X VGND VGND VPWR VPWR _2653_/Y sky130_fd_sc_hd__inv_2
X_5441_ _5908_/CLK _5441_/D VGND VGND VPWR VPWR _5441_/Q sky130_fd_sc_hd__dfxtp_1
X_5372_ _6143_/CLK _5372_/D VGND VGND VPWR VPWR _5372_/Q sky130_fd_sc_hd__dfxtp_1
XANTENNA__3897__A1 _6416_/Q VGND VGND VPWR VPWR sky130_fd_sc_hd__diode_2
XFILLER_114_755 VGND VGND VPWR VPWR sky130_fd_sc_hd__fill_1
X_4323_ hold123/X _5045_/A1 _4325_/S VGND VGND VPWR VPWR _4323_/X sky130_fd_sc_hd__mux2_1
Xfanout118 _4846_/A0 VGND VGND VPWR VPWR _5241_/A1 sky130_fd_sc_hd__clkbuf_4
XTAP_TAPCELL_ROW_93_1699 VGND VPWR sky130_fd_sc_hd__tapvpwrvgnd_1
XTAP_TAPCELL_ROW_93_1688 VGND VPWR sky130_fd_sc_hd__tapvpwrvgnd_1
XFILLER_87_617 VGND VGND VPWR VPWR sky130_fd_sc_hd__fill_2
Xfanout129 _5813_/Q VGND VGND VPWR VPWR _4903_/A0 sky130_fd_sc_hd__buf_4
Xfanout107 _5825_/Q VGND VGND VPWR VPWR _4978_/A1 sky130_fd_sc_hd__clkbuf_4
XANTENNA__4846__A0 _4846_/A0 VGND VGND VPWR VPWR sky130_fd_sc_hd__diode_2
X_4254_ _4251_/X _4252_/X _4253_/X _4149_/A VGND VGND VPWR VPWR _4254_/X sky130_fd_sc_hd__a22o_1
XANTENNA__3649__A1 _4484_/A0 VGND VGND VPWR VPWR sky130_fd_sc_hd__diode_2
X_3205_ hold996/X _5080_/A0 _3206_/S VGND VGND VPWR VPWR _3205_/X sky130_fd_sc_hd__mux2_1
X_4185_ _4252_/A1 _4184_/X _3172_/B VGND VGND VPWR VPWR _4185_/X sky130_fd_sc_hd__o21a_1
XFILLER_103_15 VPWR VGND VPWR VGND sky130_ef_sc_hd__decap_40_12
XTAP_TAPCELL_ROW_2_337 VGND VPWR sky130_fd_sc_hd__tapvpwrvgnd_1
XTAP_TAPCELL_ROW_2_326 VGND VPWR sky130_fd_sc_hd__tapvpwrvgnd_1
X_3136_ _2701_/B _3135_/A _5085_/A VGND VGND VPWR VPWR _3136_/Y sky130_fd_sc_hd__a21oi_1
XTAP_TAPCELL_ROW_124_2154 VGND VPWR sky130_fd_sc_hd__tapvpwrvgnd_1
X_3067_ _2967_/S _3066_/X _2735_/A VGND VGND VPWR VPWR _3067_/Y sky130_fd_sc_hd__o21ai_1
XTAP_TAPCELL_ROW_124_2165 VGND VPWR sky130_fd_sc_hd__tapvpwrvgnd_1
XFILLER_63_580 VGND VGND VPWR VPWR sky130_fd_sc_hd__fill_1
XANTENNA__4173__S _4262_/S VGND VGND VPWR VPWR sky130_fd_sc_hd__diode_2
XFILLER_51_797 VPWR VGND VPWR VGND sky130_ef_sc_hd__decap_40_12
XFILLER_11_617 VPWR VGND VPWR VGND sky130_ef_sc_hd__decap_40_12
XTAP_TAPCELL_ROW_21_612 VGND VPWR sky130_fd_sc_hd__tapvpwrvgnd_1
XANTENNA__4901__S _4906_/S VGND VGND VPWR VPWR sky130_fd_sc_hd__diode_2
X_3969_ _3975_/C _6385_/Q _3975_/A VGND VGND VPWR VPWR _3969_/X sky130_fd_sc_hd__or3b_1
X_5708_ _6123_/CLK _5708_/D VGND VGND VPWR VPWR _5708_/Q sky130_fd_sc_hd__dfxtp_1
XFILLER_109_549 VGND VGND VPWR VPWR sky130_fd_sc_hd__fill_8
X_5639_ _6290_/CLK _5639_/D VGND VGND VPWR VPWR _5639_/Q sky130_fd_sc_hd__dfxtp_1
XFILLER_88_27 VGND VGND VPWR VPWR sky130_fd_sc_hd__fill_1
XANTENNA__3888__A1 _6417_/Q VGND VGND VPWR VPWR sky130_fd_sc_hd__diode_2
XANTENNA__4202__A _4260_/S VGND VGND VPWR VPWR sky130_fd_sc_hd__diode_2
Xhold161 _6002_/Q VGND VGND VPWR VPWR hold161/X sky130_fd_sc_hd__dlygate4sd3_1
Xhold150 _4384_/X VGND VGND VPWR VPWR _6024_/D sky130_fd_sc_hd__dlygate4sd3_1
XFILLER_105_777 VGND VGND VPWR VPWR sky130_fd_sc_hd__fill_4
Xhold172 _4304_/X VGND VGND VPWR VPWR _5954_/D sky130_fd_sc_hd__dlygate4sd3_1
Xhold194 _5042_/X VGND VGND VPWR VPWR _6337_/D sky130_fd_sc_hd__dlygate4sd3_1
Xhold183 _5986_/Q VGND VGND VPWR VPWR hold183/X sky130_fd_sc_hd__dlygate4sd3_1
XFILLER_132_585 VGND VGND VPWR VPWR sky130_fd_sc_hd__fill_2
XFILLER_120_725 VPWR VGND VPWR VGND sky130_ef_sc_hd__decap_40_12
XANTENNA__4837__A0 _4889_/A1 VGND VGND VPWR VPWR sky130_fd_sc_hd__diode_2
XANTENNA_fanout80_A _4961_/A0 VGND VGND VPWR VPWR sky130_fd_sc_hd__diode_2
XFILLER_120_769 VPWR VGND VPWR VGND sky130_ef_sc_hd__decap_40_12
XFILLER_93_609 VGND VGND VPWR VPWR sky130_fd_sc_hd__fill_4
XANTENNA__4348__S _4356_/S VGND VGND VPWR VPWR sky130_fd_sc_hd__diode_2
XTAP_TAPCELL_ROW_109_1938 VGND VPWR sky130_fd_sc_hd__tapvpwrvgnd_1
XFILLER_100_471 VGND VGND VPWR VPWR sky130_fd_sc_hd__fill_4
XTAP_TAPCELL_ROW_29_734 VGND VPWR sky130_fd_sc_hd__tapvpwrvgnd_1
XTAP_TAPCELL_ROW_64_1267 VGND VPWR sky130_fd_sc_hd__tapvpwrvgnd_1
XTAP_TAPCELL_ROW_64_1256 VGND VPWR sky130_fd_sc_hd__tapvpwrvgnd_1
XFILLER_14_433 VPWR VGND VPWR VGND sky130_ef_sc_hd__decap_40_12
XFILLER_14_477 VPWR VGND VPWR VGND sky130_ef_sc_hd__decap_40_12
XFILLER_41_285 VGND VGND VPWR VPWR sky130_fd_sc_hd__fill_2
XFILLER_128_825 VPWR VGND VPWR VGND sky130_ef_sc_hd__decap_40_12
XFILLER_127_335 VGND VGND VPWR VPWR sky130_fd_sc_hd__fill_1
XANTENNA__3427__S _3437_/S VGND VGND VPWR VPWR sky130_fd_sc_hd__diode_2
XFILLER_6_643 VGND VGND VPWR VPWR sky130_fd_sc_hd__fill_1
XFILLER_123_541 VPWR VGND VPWR VGND sky130_ef_sc_hd__decap_40_12
XFILLER_123_585 VPWR VGND VPWR VGND sky130_ef_sc_hd__decap_40_12
XFILLER_111_725 VGND VGND VPWR VPWR sky130_fd_sc_hd__fill_2
XANTENNA__4828__A0 _4906_/A0 VGND VGND VPWR VPWR sky130_fd_sc_hd__diode_2
XFILLER_68_105 VGND VGND VPWR VPWR sky130_fd_sc_hd__fill_2
XANTENNA__4160__A1_N _4271_/S1 VGND VGND VPWR VPWR sky130_fd_sc_hd__diode_2
XANTENNA__3500__A0 _4903_/A0 VGND VGND VPWR VPWR sky130_fd_sc_hd__diode_2
XFILLER_49_374 VGND VGND VPWR VPWR sky130_fd_sc_hd__fill_2
XFILLER_37_503 VGND VGND VPWR VPWR sky130_fd_sc_hd__fill_1
XFILLER_64_377 VGND VGND VPWR VPWR sky130_fd_sc_hd__fill_2
X_5990_ _5990_/CLK _5990_/D VGND VGND VPWR VPWR _5990_/Q sky130_fd_sc_hd__dfxtp_1
XFILLER_92_697 VGND VGND VPWR VPWR sky130_fd_sc_hd__fill_2
XFILLER_80_837 VGND VGND VPWR VPWR sky130_fd_sc_hd__fill_2
X_4941_ _4981_/A1 _4941_/A1 _4944_/S VGND VGND VPWR VPWR _4941_/X sky130_fd_sc_hd__mux2_1
X_4872_ hold395/X _5241_/A1 _4880_/S VGND VGND VPWR VPWR _4872_/X sky130_fd_sc_hd__mux2_1
XFILLER_33_753 VPWR VGND VPWR VGND sky130_ef_sc_hd__decap_40_12
X_3823_ _3837_/A input7/X input8/X VGND VGND VPWR VPWR _3835_/S sky130_fd_sc_hd__or3b_4
XFILLER_33_797 VPWR VGND VPWR VGND sky130_ef_sc_hd__decap_40_12
XPHY_EDGE_ROW_65_Left_204 VGND VGND VPWR VPWR sky130_fd_sc_hd__decap_3
X_3754_ _4983_/A1 _3754_/A1 _3755_/S VGND VGND VPWR VPWR _3754_/X sky130_fd_sc_hd__mux2_1
XFILLER_20_469 VGND VGND VPWR VPWR sky130_fd_sc_hd__fill_4
XTAP_TAPCELL_ROW_95_1728 VGND VPWR sky130_fd_sc_hd__tapvpwrvgnd_1
X_3685_ _5213_/A1 _3685_/A1 _3688_/S VGND VGND VPWR VPWR _5707_/D sky130_fd_sc_hd__mux2_1
X_2705_ _5831_/Q _4451_/A VGND VGND VPWR VPWR _3391_/B sky130_fd_sc_hd__nand2_1
X_5424_ _5583_/CLK _5424_/D VGND VGND VPWR VPWR _5424_/Q sky130_fd_sc_hd__dfxtp_1
X_2636_ _4241_/A VGND VGND VPWR VPWR _2636_/Y sky130_fd_sc_hd__inv_2
XFILLER_126_390 VGND VGND VPWR VPWR sky130_fd_sc_hd__fill_1
X_5355_ _5583_/CLK _5355_/D VGND VGND VPWR VPWR _5355_/Q sky130_fd_sc_hd__dfxtp_1
XTAP_TAPCELL_ROW_7_407 VGND VPWR sky130_fd_sc_hd__tapvpwrvgnd_1
XFILLER_114_585 VGND VGND VPWR VPWR sky130_fd_sc_hd__fill_2
XANTENNA__4819__A0 _4445_/A VGND VGND VPWR VPWR sky130_fd_sc_hd__diode_2
XFILLER_102_725 VPWR VGND VPWR VGND sky130_ef_sc_hd__decap_40_12
X_5286_ _6409_/CLK hold9/X VGND VGND VPWR VPWR hold8/A sky130_fd_sc_hd__dfxtp_1
X_4306_ _5050_/B _4336_/B VGND VGND VPWR VPWR _4315_/S sky130_fd_sc_hd__nor2_4
XANTENNA__3072__S _3072_/S VGND VGND VPWR VPWR sky130_fd_sc_hd__diode_2
XFILLER_102_769 VPWR VGND VPWR VGND sky130_ef_sc_hd__decap_40_12
XFILLER_87_447 VGND VGND VPWR VPWR sky130_fd_sc_hd__fill_1
X_4237_ _5767_/Q _5745_/Q _4237_/S VGND VGND VPWR VPWR _4237_/X sky130_fd_sc_hd__mux2_1
XFILLER_101_279 VGND VGND VPWR VPWR sky130_fd_sc_hd__fill_1
XPHY_EDGE_ROW_74_Left_213 VGND VGND VPWR VPWR sky130_fd_sc_hd__decap_3
XFILLER_56_801 VGND VGND VPWR VPWR sky130_fd_sc_hd__fill_8
XFILLER_83_642 VGND VGND VPWR VPWR sky130_fd_sc_hd__fill_2
XFILLER_74_29 VPWR VGND VPWR VGND sky130_ef_sc_hd__decap_40_12
XANTENNA_clkbuf_leaf_4_clk_A clkbuf_leaf_9_clk/A VGND VGND VPWR VPWR sky130_fd_sc_hd__diode_2
X_4168_ _5261_/Q _6050_/Q _6041_/Q hold240/X _4213_/S _4212_/A VGND VGND VPWR VPWR
+ _4168_/X sky130_fd_sc_hd__mux4_1
X_3119_ hold437/X _4899_/A0 _3126_/S VGND VGND VPWR VPWR _3119_/X sky130_fd_sc_hd__mux2_1
XFILLER_71_815 VGND VGND VPWR VPWR sky130_fd_sc_hd__fill_1
X_4099_ hold83/A _6011_/Q _6002_/Q _5993_/Q _4213_/S _4212_/A VGND VGND VPWR VPWR
+ _4099_/X sky130_fd_sc_hd__mux4_1
XANTENNA_fanout170_X _4228_/S VGND VGND VPWR VPWR sky130_fd_sc_hd__diode_2
XFILLER_70_336 VGND VGND VPWR VPWR sky130_fd_sc_hd__fill_4
XTAP_TAPCELL_ROW_104_1857 VGND VPWR sky130_fd_sc_hd__tapvpwrvgnd_1
XANTENNA__3558__A0 _4517_/A1 VGND VGND VPWR VPWR sky130_fd_sc_hd__diode_2
XPHY_EDGE_ROW_83_Left_222 VGND VGND VPWR VPWR sky130_fd_sc_hd__decap_3
XFILLER_51_594 VGND VGND VPWR VPWR sky130_fd_sc_hd__fill_2
XFILLER_11_447 VGND VGND VPWR VPWR sky130_fd_sc_hd__fill_1
XFILLER_23_55 VGND VGND VPWR VPWR sky130_fd_sc_hd__fill_1
XTAP_TAPCELL_ROW_137_2356 VGND VPWR sky130_fd_sc_hd__tapvpwrvgnd_1
XANTENNA__2940__A _3085_/A VGND VGND VPWR VPWR sky130_fd_sc_hd__diode_2
XFILLER_7_429 VPWR VGND VPWR VGND sky130_ef_sc_hd__decap_40_12
XFILLER_99_15 VPWR VGND VPWR VGND sky130_ef_sc_hd__decap_40_12
XFILLER_136_143 VGND VGND VPWR VPWR sky130_fd_sc_hd__fill_1
XFILLER_125_839 VGND VGND VPWR VPWR sky130_fd_sc_hd__fill_1
XFILLER_3_613 VGND VGND VPWR VPWR sky130_fd_sc_hd__fill_2
XFILLER_3_3 VPWR VGND VPWR VGND sky130_ef_sc_hd__decap_40_12
XFILLER_105_585 VPWR VGND VPWR VGND sky130_ef_sc_hd__decap_40_12
XPHY_EDGE_ROW_92_Left_231 VGND VGND VPWR VPWR sky130_fd_sc_hd__decap_3
XANTENNA_fanout83_X _5212_/A1 VGND VGND VPWR VPWR sky130_fd_sc_hd__diode_2
XFILLER_120_533 VPWR VGND VPWR VGND sky130_ef_sc_hd__decap_40_12
XANTENNA__4078__S _4237_/S VGND VGND VPWR VPWR sky130_fd_sc_hd__diode_2
XFILLER_48_85 VGND VGND VPWR VPWR sky130_fd_sc_hd__fill_2
XANTENNA__4286__A1 _4976_/A1 VGND VGND VPWR VPWR sky130_fd_sc_hd__diode_2
XFILLER_19_503 VGND VGND VPWR VPWR sky130_fd_sc_hd__fill_1
XFILLER_46_322 VGND VGND VPWR VPWR sky130_fd_sc_hd__fill_2
XFILLER_0_15 VPWR VGND VPWR VGND sky130_ef_sc_hd__decap_40_12
XANTENNA__5235__A0 _5235_/A0 VGND VGND VPWR VPWR sky130_fd_sc_hd__diode_2
XFILLER_62_837 VGND VGND VPWR VPWR sky130_fd_sc_hd__fill_4
XFILLER_15_753 VPWR VGND VPWR VGND sky130_ef_sc_hd__decap_40_12
XFILLER_42_561 VGND VGND VPWR VPWR sky130_fd_sc_hd__fill_1
XFILLER_15_797 VPWR VGND VPWR VGND sky130_ef_sc_hd__decap_40_12
XFILLER_30_701 VGND VGND VPWR VPWR sky130_fd_sc_hd__fill_2
XANTENNA__4541__S _4547_/S VGND VGND VPWR VPWR sky130_fd_sc_hd__diode_2
XTAP_TAPCELL_ROW_12_475 VGND VPWR sky130_fd_sc_hd__tapvpwrvgnd_1
XTAP_TAPCELL_ROW_12_486 VGND VPWR sky130_fd_sc_hd__tapvpwrvgnd_1
XFILLER_128_699 VGND VGND VPWR VPWR sky130_fd_sc_hd__fill_1
XANTENNA__2772__A1 _3031_/A1 VGND VGND VPWR VPWR sky130_fd_sc_hd__diode_2
Xhold919 _3592_/X VGND VGND VPWR VPWR _5626_/D sky130_fd_sc_hd__dlygate4sd3_1
Xhold908 _6049_/Q VGND VGND VPWR VPWR hold908/X sky130_fd_sc_hd__dlygate4sd3_1
X_3470_ _4899_/A0 _3470_/A1 _3477_/S VGND VGND VPWR VPWR _3470_/X sky130_fd_sc_hd__mux2_1
XTAP_TAPCELL_ROW_77_1458 VGND VPWR sky130_fd_sc_hd__tapvpwrvgnd_1
XFILLER_6_473 VGND VGND VPWR VPWR sky130_fd_sc_hd__fill_2
XFILLER_131_809 VPWR VGND VPWR VGND sky130_ef_sc_hd__decap_40_12
XANTENNA__5171__C1 _5176_/A VGND VGND VPWR VPWR sky130_fd_sc_hd__diode_2
XTAP_TAPCELL_ROW_90_1647 VGND VPWR sky130_fd_sc_hd__tapvpwrvgnd_1
X_5140_ _5160_/A _5140_/B VGND VGND VPWR VPWR _5140_/Y sky130_fd_sc_hd__nand2_1
XFILLER_36_3 VGND VGND VPWR VPWR sky130_fd_sc_hd__fill_8
X_5071_ _5239_/A1 _5071_/A1 _5081_/S VGND VGND VPWR VPWR _5071_/X sky130_fd_sc_hd__mux2_1
Xhold1608 _5554_/Q VGND VGND VPWR VPWR _3510_/A1 sky130_fd_sc_hd__dlygate4sd3_1
Xhold1619 _5691_/Q VGND VGND VPWR VPWR _3666_/A1 sky130_fd_sc_hd__dlygate4sd3_1
XFILLER_56_108 VGND VGND VPWR VPWR sky130_fd_sc_hd__fill_4
XANTENNA__4277__A1 _5040_/A1 VGND VGND VPWR VPWR sky130_fd_sc_hd__diode_2
X_4022_ _6036_/Q _6344_/Q _4213_/S VGND VGND VPWR VPWR _4022_/X sky130_fd_sc_hd__mux2_1
XANTENNA__5226__A0 _5238_/A1 VGND VGND VPWR VPWR sky130_fd_sc_hd__diode_2
XFILLER_64_141 VPWR VGND VPWR VGND sky130_ef_sc_hd__decap_40_12
XFILLER_64_130 VGND VGND VPWR VPWR sky130_fd_sc_hd__fill_2
XTAP_TAPCELL_ROW_121_2113 VGND VPWR sky130_fd_sc_hd__tapvpwrvgnd_1
XFILLER_65_697 VGND VGND VPWR VPWR sky130_fd_sc_hd__fill_4
XFILLER_64_185 VGND VGND VPWR VPWR sky130_fd_sc_hd__fill_2
XFILLER_53_837 VGND VGND VPWR VPWR sky130_fd_sc_hd__fill_2
X_5973_ _6334_/CLK _5973_/D VGND VGND VPWR VPWR _5973_/Q sky130_fd_sc_hd__dfxtp_1
XFILLER_80_645 VGND VGND VPWR VPWR sky130_fd_sc_hd__fill_4
X_4924_ _4924_/A _5323_/Q _4924_/C VGND VGND VPWR VPWR _4965_/B sky130_fd_sc_hd__or3_2
XFILLER_100_27 VGND VGND VPWR VPWR sky130_fd_sc_hd__fill_1
X_4855_ _5069_/B _4881_/B VGND VGND VPWR VPWR _4867_/S sky130_fd_sc_hd__or2_4
XFILLER_60_380 VGND VGND VPWR VPWR sky130_fd_sc_hd__fill_2
XFILLER_20_222 VGND VGND VPWR VPWR sky130_fd_sc_hd__fill_1
XFILLER_138_419 VGND VGND VPWR VPWR sky130_fd_sc_hd__fill_1
X_3806_ input20/X _5233_/A0 _3810_/S VGND VGND VPWR VPWR _5812_/D sky130_fd_sc_hd__mux2_1
X_4786_ _5093_/A1 _4785_/X _4786_/S VGND VGND VPWR VPWR _4786_/X sky130_fd_sc_hd__mux2_1
XTAP_TAPCELL_ROW_31_762 VGND VPWR sky130_fd_sc_hd__tapvpwrvgnd_1
XTAP_TAPCELL_ROW_119_2086 VGND VPWR sky130_fd_sc_hd__tapvpwrvgnd_1
X_3737_ hold347/X _4846_/A0 _3745_/S VGND VGND VPWR VPWR _3737_/X sky130_fd_sc_hd__mux2_1
XANTENNA__2763__A1 _3036_/A1 VGND VGND VPWR VPWR sky130_fd_sc_hd__diode_2
XFILLER_109_47 VGND VGND VPWR VPWR sky130_fd_sc_hd__fill_1
XFILLER_107_839 VGND VGND VPWR VPWR sky130_fd_sc_hd__fill_1
XFILLER_134_625 VPWR VGND VPWR VGND sky130_ef_sc_hd__decap_40_12
Xclkload70 _5820_/CLK VGND VGND VPWR VPWR clkload70/X sky130_fd_sc_hd__clkbuf_4
XFILLER_69_29 VGND VGND VPWR VPWR sky130_fd_sc_hd__fill_4
X_3668_ _3777_/A _3668_/B _3668_/C VGND VGND VPWR VPWR _3919_/B sky130_fd_sc_hd__or3_4
XFILLER_134_669 VPWR VGND VPWR VGND sky130_ef_sc_hd__decap_40_12
XTAP_TAPCELL_ROW_132_2286 VGND VPWR sky130_fd_sc_hd__tapvpwrvgnd_1
X_5407_ _5565_/CLK _5407_/D VGND VGND VPWR VPWR _5407_/Q sky130_fd_sc_hd__dfxtp_1
XTAP_TAPCELL_ROW_132_2275 VGND VPWR sky130_fd_sc_hd__tapvpwrvgnd_1
XFILLER_122_809 VGND VGND VPWR VPWR sky130_fd_sc_hd__fill_2
Xclkload81 _6429_/CLK VGND VGND VPWR VPWR clkload81/Y sky130_fd_sc_hd__bufinv_16
Xclkload92 _6057_/CLK VGND VGND VPWR VPWR clkload92/Y sky130_fd_sc_hd__clkinv_8
X_3599_ _4618_/A2 _5210_/A1 _3605_/S VGND VGND VPWR VPWR _3599_/X sky130_fd_sc_hd__mux2_1
X_6387_ _6388_/CLK _6387_/D VGND VGND VPWR VPWR _6387_/Q sky130_fd_sc_hd__dfxtp_2
XFILLER_87_200 VGND VGND VPWR VPWR sky130_fd_sc_hd__fill_1
X_5338_ _6421_/CLK _5338_/D VGND VGND VPWR VPWR _5338_/Q sky130_fd_sc_hd__dfxtp_2
XFILLER_125_57 VGND VGND VPWR VPWR sky130_fd_sc_hd__fill_1
XFILLER_102_533 VPWR VGND VPWR VGND sky130_ef_sc_hd__decap_40_12
X_5269_ _6196_/CLK _5269_/D VGND VGND VPWR VPWR _5269_/Q sky130_fd_sc_hd__dfxtp_1
XFILLER_56_642 VGND VGND VPWR VPWR sky130_fd_sc_hd__fill_2
XFILLER_18_11 VGND VGND VPWR VPWR sky130_fd_sc_hd__fill_1
XANTENNA__3530__S _3541_/S VGND VGND VPWR VPWR sky130_fd_sc_hd__diode_2
XANTENNA__4626__S _4778_/S VGND VGND VPWR VPWR sky130_fd_sc_hd__diode_2
XANTENNA__5217__B1 _3801_/A VGND VGND VPWR VPWR sky130_fd_sc_hd__diode_2
XFILLER_56_697 VGND VGND VPWR VPWR sky130_fd_sc_hd__fill_2
XTAP_TAPCELL_ROW_48_1026 VGND VPWR sky130_fd_sc_hd__tapvpwrvgnd_1
XTAP_TAPCELL_ROW_48_1015 VGND VPWR sky130_fd_sc_hd__tapvpwrvgnd_1
XFILLER_44_837 VGND VGND VPWR VPWR sky130_fd_sc_hd__fill_4
XTAP_TAPCELL_ROW_39_884 VGND VPWR sky130_fd_sc_hd__tapvpwrvgnd_1
XANTENNA__4440__B2 _4899_/A0 VGND VGND VPWR VPWR sky130_fd_sc_hd__diode_2
XTAP_TAPCELL_ROW_61_1215 VGND VPWR sky130_fd_sc_hd__tapvpwrvgnd_1
XFILLER_12_701 VPWR VGND VPWR VGND sky130_ef_sc_hd__decap_40_12
XFILLER_31_509 VGND VGND VPWR VPWR sky130_fd_sc_hd__fill_2
XFILLER_8_749 VGND VGND VPWR VPWR sky130_fd_sc_hd__fill_4
XFILLER_109_143 VGND VGND VPWR VPWR sky130_fd_sc_hd__fill_1
XFILLER_50_53 VGND VGND VPWR VPWR sky130_fd_sc_hd__fill_1
XFILLER_137_485 VPWR VGND VPWR VGND sky130_ef_sc_hd__decap_40_12
XANTENNA__4868__Y _4880_/S VGND VGND VPWR VPWR sky130_fd_sc_hd__diode_2
XFILLER_3_421 VGND VGND VPWR VPWR sky130_fd_sc_hd__fill_4
XFILLER_125_669 VGND VGND VPWR VPWR sky130_fd_sc_hd__fill_2
XFILLER_113_809 VPWR VGND VPWR VGND sky130_ef_sc_hd__decap_40_12
XANTENNA__3705__S _3707_/S VGND VGND VPWR VPWR sky130_fd_sc_hd__diode_2
XTAP_TAPCELL_ROW_59_1188 VGND VPWR sky130_fd_sc_hd__tapvpwrvgnd_1
XFILLER_3_432 VPWR VGND VPWR VGND sky130_ef_sc_hd__decap_40_12
XANTENNA__3703__A0 _5212_/A1 VGND VGND VPWR VPWR sky130_fd_sc_hd__diode_2
XTAP_TAPCELL_ROW_72_1377 VGND VPWR sky130_fd_sc_hd__tapvpwrvgnd_1
XFILLER_94_737 VPWR VGND VPWR VGND sky130_ef_sc_hd__decap_40_12
XANTENNA__4536__S _4547_/S VGND VGND VPWR VPWR sky130_fd_sc_hd__diode_2
XANTENNA__3440__S _3450_/S VGND VGND VPWR VPWR sky130_fd_sc_hd__diode_2
XANTENNA_clkload6_A clkload6/A VGND VGND VPWR VPWR sky130_fd_sc_hd__diode_2
XFILLER_74_494 VGND VGND VPWR VPWR sky130_fd_sc_hd__fill_2
XFILLER_34_325 VGND VGND VPWR VPWR sky130_fd_sc_hd__fill_1
XFILLER_35_837 VGND VGND VPWR VPWR sky130_fd_sc_hd__fill_2
XANTENNA__2690__B1 _4547_/S VGND VGND VPWR VPWR sky130_fd_sc_hd__diode_2
XFILLER_62_645 VGND VGND VPWR VPWR sky130_fd_sc_hd__fill_2
XFILLER_61_111 VGND VGND VPWR VPWR sky130_fd_sc_hd__fill_1
X_2970_ _3044_/A _2970_/B VGND VGND VPWR VPWR _2970_/X sky130_fd_sc_hd__or2_1
XANTENNA__3379__C input4/X VGND VGND VPWR VPWR sky130_fd_sc_hd__diode_2
XFILLER_15_561 VPWR VGND VPWR VGND sky130_ef_sc_hd__decap_40_12
XTAP_TAPCELL_ROW_17_556 VGND VPWR sky130_fd_sc_hd__tapvpwrvgnd_1
XFILLER_30_531 VGND VGND VPWR VPWR sky130_fd_sc_hd__fill_1
X_4640_ _4809_/A _4640_/B VGND VGND VPWR VPWR _4640_/Y sky130_fd_sc_hd__nor2_1
XANTENNA__2745__A1 _4846_/A0 VGND VGND VPWR VPWR sky130_fd_sc_hd__diode_2
X_4571_ _4791_/A1 _4570_/X _4792_/A1 VGND VGND VPWR VPWR _4571_/Y sky130_fd_sc_hd__o21ai_1
X_6310_ _6310_/CLK _6310_/D VGND VGND VPWR VPWR _6310_/Q sky130_fd_sc_hd__dfxtp_1
X_3522_ _4899_/A0 _3522_/A1 _3529_/S VGND VGND VPWR VPWR _3522_/X sky130_fd_sc_hd__mux2_1
XFILLER_116_625 VPWR VGND VPWR VGND sky130_ef_sc_hd__decap_40_12
Xhold716 _6235_/Q VGND VGND VPWR VPWR hold716/X sky130_fd_sc_hd__dlygate4sd3_1
Xhold705 _2748_/X VGND VGND VPWR VPWR _5278_/D sky130_fd_sc_hd__dlygate4sd3_1
Xhold727 _4477_/X VGND VGND VPWR VPWR _6084_/D sky130_fd_sc_hd__dlygate4sd3_1
X_3453_ hold210/X _5239_/A1 _3463_/S VGND VGND VPWR VPWR _3453_/X sky130_fd_sc_hd__mux2_1
XFILLER_116_669 VPWR VGND VPWR VGND sky130_ef_sc_hd__decap_40_12
XFILLER_104_809 VGND VGND VPWR VPWR sky130_fd_sc_hd__fill_2
X_6241_ _6241_/CLK _6241_/D VGND VGND VPWR VPWR _6241_/Q sky130_fd_sc_hd__dfxtp_1
Xhold749 _5984_/Q VGND VGND VPWR VPWR hold749/X sky130_fd_sc_hd__dlygate4sd3_1
Xhold738 _4930_/X VGND VGND VPWR VPWR _6267_/D sky130_fd_sc_hd__dlygate4sd3_1
XFILLER_131_617 VPWR VGND VPWR VGND sky130_ef_sc_hd__decap_40_12
X_6172_ _6172_/CLK _6172_/D VGND VGND VPWR VPWR _6172_/Q sky130_fd_sc_hd__dfxtp_1
XANTENNA__4498__A1 _5212_/A1 VGND VGND VPWR VPWR sky130_fd_sc_hd__diode_2
XFILLER_130_138 VGND VGND VPWR VPWR sky130_fd_sc_hd__fill_2
Xhold2106 _5146_/X VGND VGND VPWR VPWR _6393_/D sky130_fd_sc_hd__dlygate4sd3_1
Xhold2117 _5183_/X VGND VGND VPWR VPWR _5184_/A2 sky130_fd_sc_hd__dlygate4sd3_1
X_5123_ _5123_/A _5123_/B VGND VGND VPWR VPWR _5123_/X sky130_fd_sc_hd__and2_1
X_3384_ hold280/X _4978_/A1 _3390_/S VGND VGND VPWR VPWR _3384_/X sky130_fd_sc_hd__mux2_1
XANTENNA__3170__A1 _3172_/B VGND VGND VPWR VPWR sky130_fd_sc_hd__diode_2
XFILLER_111_341 VGND VGND VPWR VPWR sky130_fd_sc_hd__fill_1
Xhold1405 _4836_/X VGND VGND VPWR VPWR _6189_/D sky130_fd_sc_hd__dlygate4sd3_1
Xhold2139 _5177_/Y VGND VGND VPWR VPWR _5180_/A1 sky130_fd_sc_hd__dlygate4sd3_1
Xhold2128 _5060_/B VGND VGND VPWR VPWR _3798_/B sky130_fd_sc_hd__dlygate4sd3_1
XFILLER_57_417 VGND VGND VPWR VPWR sky130_fd_sc_hd__fill_2
Xhold1416 _4372_/X VGND VGND VPWR VPWR _6013_/D sky130_fd_sc_hd__dlygate4sd3_1
XFILLER_97_597 VPWR VGND VPWR VGND sky130_ef_sc_hd__decap_40_12
Xhold1427 _5874_/Q VGND VGND VPWR VPWR _3895_/A0 sky130_fd_sc_hd__dlygate4sd3_1
Xhold1438 _3545_/X VGND VGND VPWR VPWR _5586_/D sky130_fd_sc_hd__dlygate4sd3_1
XFILLER_57_428 VGND VGND VPWR VPWR sky130_fd_sc_hd__fill_1
Xhold1449 _6273_/Q VGND VGND VPWR VPWR _4937_/A1 sky130_fd_sc_hd__dlygate4sd3_1
X_5054_ hold647/X _5826_/Q _5059_/S VGND VGND VPWR VPWR _5054_/X sky130_fd_sc_hd__mux2_1
X_4005_ _5010_/A _4004_/Y _3997_/X VGND VGND VPWR VPWR _4007_/B sky130_fd_sc_hd__o21ai_1
XANTENNA_fanout178_A _3027_/A VGND VGND VPWR VPWR sky130_fd_sc_hd__diode_2
XFILLER_93_781 VGND VGND VPWR VPWR sky130_fd_sc_hd__fill_2
XFILLER_26_837 VGND VGND VPWR VPWR sky130_fd_sc_hd__fill_4
XFILLER_38_697 VGND VGND VPWR VPWR sky130_fd_sc_hd__fill_1
XFILLER_111_15 VPWR VGND VPWR VGND sky130_ef_sc_hd__decap_40_12
XTAP_TAPCELL_ROW_36_843 VGND VPWR sky130_fd_sc_hd__tapvpwrvgnd_1
XFILLER_111_59 VGND VGND VPWR VPWR sky130_fd_sc_hd__fill_2
XTAP_TAPCELL_ROW_101_1816 VGND VPWR sky130_fd_sc_hd__tapvpwrvgnd_1
XFILLER_80_475 VGND VGND VPWR VPWR sky130_fd_sc_hd__fill_1
X_5956_ _6334_/CLK _5956_/D VGND VGND VPWR VPWR _5956_/Q sky130_fd_sc_hd__dfxtp_1
X_4907_ _4922_/B _4922_/C VGND VGND VPWR VPWR _4907_/Y sky130_fd_sc_hd__nor2_2
X_5887_ _6114_/CLK _5887_/D VGND VGND VPWR VPWR _5887_/Q sky130_fd_sc_hd__dfxtp_1
X_4838_ _5813_/Q _4838_/A1 _4841_/S VGND VGND VPWR VPWR _4838_/X sky130_fd_sc_hd__mux2_1
XANTENNA_fanout133_X _4901_/A0 VGND VGND VPWR VPWR sky130_fd_sc_hd__diode_2
XTAP_TAPCELL_ROW_134_2315 VGND VPWR sky130_fd_sc_hd__tapvpwrvgnd_1
XTAP_TAPCELL_ROW_134_2304 VGND VPWR sky130_fd_sc_hd__tapvpwrvgnd_1
XANTENNA__3084__S1 _2962_/A VGND VGND VPWR VPWR sky130_fd_sc_hd__diode_2
XANTENNA__3933__A0 _4929_/A1 VGND VGND VPWR VPWR sky130_fd_sc_hd__diode_2
X_4769_ _4811_/A1 _4768_/X _4811_/C1 VGND VGND VPWR VPWR _4769_/X sky130_fd_sc_hd__o21a_1
XFILLER_20_23 VGND VGND VPWR VPWR sky130_fd_sc_hd__fill_2
XFILLER_107_669 VGND VGND VPWR VPWR sky130_fd_sc_hd__fill_2
XFILLER_134_477 VPWR VGND VPWR VGND sky130_ef_sc_hd__decap_40_12
XANTENNA__3525__S _3529_/S VGND VGND VPWR VPWR sky130_fd_sc_hd__diode_2
XFILLER_106_168 VGND VGND VPWR VPWR sky130_fd_sc_hd__fill_1
XANTENNA__4033__S0 _4237_/S VGND VGND VPWR VPWR sky130_fd_sc_hd__diode_2
XTAP_TAPCELL_ROW_112_1978 VGND VPWR sky130_fd_sc_hd__tapvpwrvgnd_1
XFILLER_102_330 VGND VGND VPWR VPWR sky130_fd_sc_hd__fill_2
XFILLER_96_27 VGND VGND VPWR VPWR sky130_fd_sc_hd__fill_1
XFILLER_88_531 VGND VGND VPWR VPWR sky130_fd_sc_hd__fill_1
Xhold21 hold21/A VGND VGND VPWR VPWR hold21/X sky130_fd_sc_hd__dlygate4sd3_1
Xhold10 hold10/A VGND VGND VPWR VPWR hold10/X sky130_fd_sc_hd__dlygate4sd3_1
Xhold32 hold32/A VGND VGND VPWR VPWR hold32/X sky130_fd_sc_hd__dlygate4sd3_1
XFILLER_29_21 VGND VGND VPWR VPWR sky130_fd_sc_hd__fill_1
XFILLER_88_597 VGND VGND VPWR VPWR sky130_fd_sc_hd__fill_4
Xhold43 hold43/A VGND VGND VPWR VPWR hold43/X sky130_fd_sc_hd__dlygate4sd3_1
Xhold54 hold54/A VGND VGND VPWR VPWR hold54/X sky130_fd_sc_hd__dlygate4sd3_1
Xhold65 hold65/A VGND VGND VPWR VPWR hold65/X sky130_fd_sc_hd__dlygate4sd3_1
Xhold1972 _6170_/Q VGND VGND VPWR VPWR _5094_/A1 sky130_fd_sc_hd__dlygate4sd3_1
Xhold1961 _3156_/X VGND VGND VPWR VPWR _5337_/D sky130_fd_sc_hd__dlygate4sd3_1
XANTENNA__4356__S _4356_/S VGND VGND VPWR VPWR sky130_fd_sc_hd__diode_2
Xhold87 hold87/A VGND VGND VPWR VPWR hold87/X sky130_fd_sc_hd__dlygate4sd3_1
Xhold76 hold76/A VGND VGND VPWR VPWR hold76/X sky130_fd_sc_hd__dlygate4sd3_1
Xhold98 hold98/A VGND VGND VPWR VPWR hold98/X sky130_fd_sc_hd__dlygate4sd3_1
Xhold1950 _5395_/Q VGND VGND VPWR VPWR _3259_/A1 sky130_fd_sc_hd__dlygate4sd3_1
XANTENNA__2898__S1 _3005_/A VGND VGND VPWR VPWR sky130_fd_sc_hd__diode_2
XFILLER_91_729 VPWR VGND VPWR VGND sky130_ef_sc_hd__decap_40_12
XFILLER_17_837 VGND VGND VPWR VPWR sky130_fd_sc_hd__fill_2
XFILLER_28_152 VGND VGND VPWR VPWR sky130_fd_sc_hd__fill_4
Xhold1994 _5923_/Q VGND VGND VPWR VPWR _4163_/A1 sky130_fd_sc_hd__dlygate4sd3_1
Xhold1983 _4219_/X VGND VGND VPWR VPWR _5925_/D sky130_fd_sc_hd__dlygate4sd3_1
XFILLER_71_431 VGND VGND VPWR VPWR sky130_fd_sc_hd__fill_1
XFILLER_44_645 VGND VGND VPWR VPWR sky130_fd_sc_hd__fill_1
XFILLER_28_185 VGND VGND VPWR VPWR sky130_fd_sc_hd__fill_4
XFILLER_71_453 VGND VGND VPWR VPWR sky130_fd_sc_hd__fill_1
XFILLER_43_177 VGND VGND VPWR VPWR sky130_fd_sc_hd__fill_1
XTAP_TAPCELL_ROW_14_504 VGND VPWR sky130_fd_sc_hd__tapvpwrvgnd_1
XTAP_TAPCELL_ROW_14_515 VGND VPWR sky130_fd_sc_hd__tapvpwrvgnd_1
XFILLER_31_328 VGND VGND VPWR VPWR sky130_fd_sc_hd__fill_8
XANTENNA__4091__S _4262_/S VGND VGND VPWR VPWR sky130_fd_sc_hd__diode_2
XFILLER_8_513 VPWR VGND VPWR VGND sky130_ef_sc_hd__decap_40_12
XFILLER_12_531 VGND VGND VPWR VPWR sky130_fd_sc_hd__fill_1
XANTENNA_clkbuf_leaf_91_clk_A clkload1/A VGND VGND VPWR VPWR sky130_fd_sc_hd__diode_2
XFILLER_8_557 VPWR VGND VPWR VGND sky130_ef_sc_hd__decap_40_12
XPHY_EDGE_ROW_20_Left_159 VGND VGND VPWR VPWR sky130_fd_sc_hd__decap_3
XANTENNA__2822__S1 _3020_/A VGND VGND VPWR VPWR sky130_fd_sc_hd__diode_2
XTAP_TAPCELL_ROW_74_1417 VGND VPWR sky130_fd_sc_hd__tapvpwrvgnd_1
XTAP_TAPCELL_ROW_74_1406 VGND VPWR sky130_fd_sc_hd__tapvpwrvgnd_1
XANTENNA__5126__C1 _5200_/A VGND VGND VPWR VPWR sky130_fd_sc_hd__diode_2
XFILLER_113_617 VPWR VGND VPWR VGND sky130_ef_sc_hd__decap_40_12
XFILLER_98_306 VGND VGND VPWR VPWR sky130_fd_sc_hd__fill_2
XANTENNA__3435__S _3437_/S VGND VGND VPWR VPWR sky130_fd_sc_hd__diode_2
XFILLER_94_545 VPWR VGND VPWR VGND sky130_ef_sc_hd__decap_40_12
XFILLER_94_589 VPWR VGND VPWR VGND sky130_ef_sc_hd__decap_40_12
XANTENNA__4652__A1 _4791_/A1 VGND VGND VPWR VPWR sky130_fd_sc_hd__diode_2
XANTENNA_clkbuf_leaf_44_clk_A clkload4/A VGND VGND VPWR VPWR sky130_fd_sc_hd__diode_2
XTAP_TAPCELL_ROW_85_1579 VGND VPWR sky130_fd_sc_hd__tapvpwrvgnd_1
XTAP_TAPCELL_ROW_85_1568 VGND VPWR sky130_fd_sc_hd__tapvpwrvgnd_1
X_5810_ _5841_/CLK _5810_/D VGND VGND VPWR VPWR _5810_/Q sky130_fd_sc_hd__dfxtp_4
XTAP_TAPCELL_ROW_33_802 VGND VPWR sky130_fd_sc_hd__tapvpwrvgnd_1
X_2953_ _2735_/A _2938_/X _2952_/Y _2925_/S VGND VGND VPWR VPWR _2953_/X sky130_fd_sc_hd__o211a_1
X_5741_ _6307_/CLK _5741_/D VGND VGND VPWR VPWR _5741_/Q sky130_fd_sc_hd__dfxtp_1
XFILLER_15_380 VPWR VGND VPWR VGND sky130_ef_sc_hd__decap_40_12
XANTENNA__2966__B2 _3089_/C1 VGND VGND VPWR VPWR sky130_fd_sc_hd__diode_2
X_2884_ _6130_/Q _5553_/Q _3030_/S VGND VGND VPWR VPWR _2885_/B sky130_fd_sc_hd__mux2_1
X_5672_ _5714_/CLK _5672_/D VGND VGND VPWR VPWR _5672_/Q sky130_fd_sc_hd__dfxtp_1
XANTENNA_clkbuf_leaf_59_clk_A clkload6/A VGND VGND VPWR VPWR sky130_fd_sc_hd__diode_2
XTAP_TAPCELL_ROW_116_2034 VGND VPWR sky130_fd_sc_hd__tapvpwrvgnd_1
X_4623_ _4792_/A1 _4618_/X _4620_/X _4622_/X VGND VGND VPWR VPWR _4623_/X sky130_fd_sc_hd__a22o_1
Xhold502 _3104_/X VGND VGND VPWR VPWR _5299_/D sky130_fd_sc_hd__dlygate4sd3_1
XFILLER_129_783 VGND VGND VPWR VPWR sky130_fd_sc_hd__fill_1
XTAP_TAPCELL_ROW_116_2045 VGND VPWR sky130_fd_sc_hd__tapvpwrvgnd_1
X_4554_ hold79/X _4886_/A1 _4561_/S VGND VGND VPWR VPWR hold80/A sky130_fd_sc_hd__mux2_1
XANTENNA_clkbuf_leaf_102_clk_A clkload0/A VGND VGND VPWR VPWR sky130_fd_sc_hd__diode_2
XFILLER_116_455 VGND VGND VPWR VPWR sky130_fd_sc_hd__fill_4
Xhold524 _5573_/Q VGND VGND VPWR VPWR hold524/X sky130_fd_sc_hd__dlygate4sd3_1
X_3505_ _4882_/A1 _3505_/A1 _3516_/S VGND VGND VPWR VPWR _5549_/D sky130_fd_sc_hd__mux2_1
Xhold513 _4992_/X VGND VGND VPWR VPWR _6324_/D sky130_fd_sc_hd__dlygate4sd3_1
Xhold535 _4340_/X VGND VGND VPWR VPWR _5985_/D sky130_fd_sc_hd__dlygate4sd3_1
Xhold557 _4467_/X VGND VGND VPWR VPWR _6075_/D sky130_fd_sc_hd__dlygate4sd3_1
XFILLER_116_477 VPWR VGND VPWR VGND sky130_ef_sc_hd__decap_40_12
Xhold568 _5426_/Q VGND VGND VPWR VPWR hold568/X sky130_fd_sc_hd__dlygate4sd3_1
X_6224_ _6241_/CLK _6224_/D VGND VGND VPWR VPWR _6224_/Q sky130_fd_sc_hd__dfxtp_1
XFILLER_89_306 VGND VGND VPWR VPWR sky130_fd_sc_hd__fill_2
X_4485_ _4515_/A1 _4485_/A1 _4488_/S VGND VGND VPWR VPWR _6091_/D sky130_fd_sc_hd__mux2_1
Xhold546 _4382_/X VGND VGND VPWR VPWR _6022_/D sky130_fd_sc_hd__dlygate4sd3_1
Xhold579 _4987_/X VGND VGND VPWR VPWR _6319_/D sky130_fd_sc_hd__dlygate4sd3_1
XFILLER_131_447 VGND VGND VPWR VPWR sky130_fd_sc_hd__fill_1
XFILLER_106_15 VPWR VGND VPWR VGND sky130_ef_sc_hd__decap_40_12
XFILLER_103_138 VGND VGND VPWR VPWR sky130_fd_sc_hd__fill_1
X_3436_ _3436_/A0 _4905_/A0 _3437_/S VGND VGND VPWR VPWR _3436_/X sky130_fd_sc_hd__mux2_1
X_6155_ _6237_/CLK _6155_/D VGND VGND VPWR VPWR _6155_/Q sky130_fd_sc_hd__dfxtp_1
X_3367_ _3802_/A2 input6/X VGND VGND VPWR VPWR _4457_/S sky130_fd_sc_hd__and2b_4
Xhold1202 _5538_/Q VGND VGND VPWR VPWR _3493_/A1 sky130_fd_sc_hd__dlygate4sd3_1
Xhold1213 _6250_/Q VGND VGND VPWR VPWR _4902_/A1 sky130_fd_sc_hd__dlygate4sd3_1
XANTENNA__4891__A1 _4904_/A0 VGND VGND VPWR VPWR sky130_fd_sc_hd__diode_2
X_5106_ _5035_/C _3311_/Y _3312_/Y _5201_/B VGND VGND VPWR VPWR _5108_/C sky130_fd_sc_hd__a211o_1
Xhold1224 _3406_/X VGND VGND VPWR VPWR _5461_/D sky130_fd_sc_hd__dlygate4sd3_1
X_6086_ _6121_/CLK _6086_/D VGND VGND VPWR VPWR _6086_/Q sky130_fd_sc_hd__dfxtp_1
Xhold1246 _5319_/Q VGND VGND VPWR VPWR _3126_/A0 sky130_fd_sc_hd__dlygate4sd3_1
Xhold1257 _6227_/Q VGND VGND VPWR VPWR _4877_/A0 sky130_fd_sc_hd__dlygate4sd3_1
X_3298_ hold205/X _4883_/A1 _3308_/S VGND VGND VPWR VPWR _5416_/D sky130_fd_sc_hd__mux2_1
Xhold1235 _3602_/X VGND VGND VPWR VPWR _5635_/D sky130_fd_sc_hd__dlygate4sd3_1
X_5037_ _5037_/A0 _5395_/Q _5037_/S VGND VGND VPWR VPWR _5037_/X sky130_fd_sc_hd__mux2_1
Xhold1279 _5505_/Q VGND VGND VPWR VPWR _3456_/A0 sky130_fd_sc_hd__dlygate4sd3_1
Xhold1268 _3470_/X VGND VGND VPWR VPWR _5517_/D sky130_fd_sc_hd__dlygate4sd3_1
XFILLER_72_217 VGND VGND VPWR VPWR sky130_fd_sc_hd__fill_2
XFILLER_82_29 VPWR VGND VPWR VGND sky130_ef_sc_hd__decap_40_12
XFILLER_72_239 VGND VGND VPWR VPWR sky130_fd_sc_hd__fill_2
XANTENNA__3851__C1 _5176_/A VGND VGND VPWR VPWR sky130_fd_sc_hd__diode_2
XANTENNA__4904__S _4906_/S VGND VGND VPWR VPWR sky130_fd_sc_hd__diode_2
XTAP_TAPCELL_ROW_0_287 VGND VPWR sky130_fd_sc_hd__tapvpwrvgnd_1
XFILLER_13_306 VGND VGND VPWR VPWR sky130_fd_sc_hd__fill_1
XTAP_TAPCELL_ROW_0_298 VGND VPWR sky130_fd_sc_hd__tapvpwrvgnd_1
X_5939_ _6310_/CLK _5939_/D VGND VGND VPWR VPWR _5939_/Q sky130_fd_sc_hd__dfxtp_1
XANTENNA__4205__A _4205_/A VGND VGND VPWR VPWR sky130_fd_sc_hd__diode_2
XFILLER_127_709 VPWR VGND VPWR VGND sky130_ef_sc_hd__decap_40_12
XFILLER_5_505 VPWR VGND VPWR VGND sky130_ef_sc_hd__decap_40_12
XFILLER_135_753 VPWR VGND VPWR VGND sky130_ef_sc_hd__decap_40_12
XFILLER_134_230 VGND VGND VPWR VPWR sky130_fd_sc_hd__fill_1
XANTENNA__3382__A1 _4976_/A1 VGND VGND VPWR VPWR sky130_fd_sc_hd__diode_2
XFILLER_135_797 VPWR VGND VPWR VGND sky130_ef_sc_hd__decap_40_12
XFILLER_103_3 VPWR VGND VPWR VGND sky130_ef_sc_hd__decap_40_12
XTAP_TAPCELL_ROW_56_1147 VGND VPWR sky130_fd_sc_hd__tapvpwrvgnd_1
XTAP_TAPCELL_ROW_56_1136 VGND VPWR sky130_fd_sc_hd__tapvpwrvgnd_1
Xoutput33 _6460_/A VGND VGND VPWR VPWR i2c_sda_o sky130_fd_sc_hd__buf_2
Xoutput55 _6461_/X VGND VGND VPWR VPWR s_axil_wready sky130_fd_sc_hd__buf_2
XFILLER_0_210 VGND VGND VPWR VPWR sky130_fd_sc_hd__fill_1
Xoutput44 _6068_/Q VGND VGND VPWR VPWR s_axil_rdata[15] sky130_fd_sc_hd__buf_2
XANTENNA__4331__A0 _5043_/A1 VGND VGND VPWR VPWR sky130_fd_sc_hd__diode_2
XFILLER_49_704 VGND VGND VPWR VPWR sky130_fd_sc_hd__fill_1
XFILLER_1_777 VGND VGND VPWR VPWR sky130_fd_sc_hd__fill_4
XANTENNA__4882__A1 _4882_/A1 VGND VGND VPWR VPWR sky130_fd_sc_hd__diode_2
XFILLER_130_491 VPWR VGND VPWR VGND sky130_ef_sc_hd__decap_40_12
XANTENNA_input23_A s_axil_wdata[5] VGND VGND VPWR VPWR sky130_fd_sc_hd__diode_2
Xhold1780 _6204_/Q VGND VGND VPWR VPWR _4852_/A1 sky130_fd_sc_hd__dlygate4sd3_1
XANTENNA__4881__Y _4893_/S VGND VGND VPWR VPWR sky130_fd_sc_hd__diode_2
XFILLER_56_96 VGND VGND VPWR VPWR sky130_fd_sc_hd__fill_4
XANTENNA_clkbuf_3_1__f_clk_A clkbuf_0_clk/X VGND VGND VPWR VPWR sky130_fd_sc_hd__diode_2
XFILLER_16_111 VGND VGND VPWR VPWR sky130_fd_sc_hd__fill_1
Xhold1791 _4952_/X VGND VGND VPWR VPWR _6287_/D sky130_fd_sc_hd__dlygate4sd3_1
XFILLER_72_773 VGND VGND VPWR VPWR sky130_fd_sc_hd__fill_2
XTAP_TAPCELL_ROW_67_1298 VGND VPWR sky130_fd_sc_hd__tapvpwrvgnd_1
XANTENNA__4398__A0 _5051_/A1 VGND VGND VPWR VPWR sky130_fd_sc_hd__diode_2
XFILLER_72_73 VGND VGND VPWR VPWR sky130_fd_sc_hd__fill_1
XFILLER_9_833 VGND VGND VPWR VPWR sky130_fd_sc_hd__fill_4
XFILLER_12_361 VGND VGND VPWR VPWR sky130_fd_sc_hd__fill_2
XTAP_TAPCELL_ROW_80_1498 VGND VPWR sky130_fd_sc_hd__tapvpwrvgnd_1
XANTENNA__3048__S1 _3050_/A VGND VGND VPWR VPWR sky130_fd_sc_hd__diode_2
XFILLER_8_365 VPWR VGND VPWR VGND sky130_ef_sc_hd__decap_40_12
XFILLER_126_753 VGND VGND VPWR VPWR sky130_fd_sc_hd__fill_2
XFILLER_99_615 VGND VGND VPWR VPWR sky130_fd_sc_hd__fill_1
X_4270_ _5264_/Q _6053_/Q _4270_/S VGND VGND VPWR VPWR _4270_/X sky130_fd_sc_hd__mux2_1
XANTENNA__3125__A1 _5080_/A0 VGND VGND VPWR VPWR sky130_fd_sc_hd__diode_2
XFILLER_101_609 VGND VGND VPWR VPWR sky130_fd_sc_hd__fill_4
XFILLER_86_309 VGND VGND VPWR VPWR sky130_fd_sc_hd__fill_1
X_3221_ _3223_/B _4813_/S VGND VGND VPWR VPWR _3221_/X sky130_fd_sc_hd__and2b_1
XANTENNA__4873__A1 _4886_/A1 VGND VGND VPWR VPWR sky130_fd_sc_hd__diode_2
XFILLER_95_821 VPWR VGND VPWR VGND sky130_ef_sc_hd__decap_40_12
X_3152_ _5333_/Q _3152_/A1 _3156_/S VGND VGND VPWR VPWR _3152_/X sky130_fd_sc_hd__mux2_1
XANTENNA_hold2225_A _5825_/Q VGND VGND VPWR VPWR sky130_fd_sc_hd__diode_2
XFILLER_39_225 VGND VGND VPWR VPWR sky130_fd_sc_hd__fill_1
XTAP_TAPCELL_ROW_87_1608 VGND VPWR sky130_fd_sc_hd__tapvpwrvgnd_1
X_3083_ _3076_/X _3082_/X _3083_/S VGND VGND VPWR VPWR _3083_/X sky130_fd_sc_hd__mux2_1
XFILLER_82_526 VGND VGND VPWR VPWR sky130_fd_sc_hd__fill_4
XANTENNA__4720__S1 _4802_/A VGND VGND VPWR VPWR sky130_fd_sc_hd__diode_2
XFILLER_90_581 VGND VGND VPWR VPWR sky130_fd_sc_hd__fill_4
XTAP_TAPCELL_ROW_46_993 VGND VPWR sky130_fd_sc_hd__tapvpwrvgnd_1
XANTENNA__4389__A0 _5052_/A1 VGND VGND VPWR VPWR sky130_fd_sc_hd__diode_2
X_3985_ _3983_/Y _3984_/Y _3958_/Y VGND VGND VPWR VPWR _3985_/Y sky130_fd_sc_hd__o21ai_1
XFILLER_50_445 VGND VGND VPWR VPWR sky130_fd_sc_hd__fill_4
X_2936_ _5244_/Q _6249_/Q _5409_/Q _5507_/Q _3077_/S _3020_/A VGND VGND VPWR VPWR
+ _2936_/X sky130_fd_sc_hd__mux4_1
X_5724_ _6382_/CLK _5724_/D VGND VGND VPWR VPWR _5724_/Q sky130_fd_sc_hd__dfxtp_1
XFILLER_50_489 VGND VGND VPWR VPWR sky130_fd_sc_hd__fill_2
XFILLER_31_670 VGND VGND VPWR VPWR sky130_fd_sc_hd__fill_2
XFILLER_109_709 VPWR VGND VPWR VGND sky130_ef_sc_hd__decap_40_12
X_2867_ _2853_/X _2866_/X _2981_/S VGND VGND VPWR VPWR _2867_/X sky130_fd_sc_hd__mux2_1
X_5655_ _5682_/CLK _5655_/D VGND VGND VPWR VPWR _5655_/Q sky130_fd_sc_hd__dfxtp_1
X_4606_ _4789_/A _4606_/B VGND VGND VPWR VPWR _4606_/X sky130_fd_sc_hd__or2_1
Xhold310 _3293_/X VGND VGND VPWR VPWR _5412_/D sky130_fd_sc_hd__dlygate4sd3_1
XFILLER_117_753 VPWR VGND VPWR VGND sky130_ef_sc_hd__decap_40_12
X_2798_ _6127_/Q _5550_/Q _3030_/S VGND VGND VPWR VPWR _2799_/B sky130_fd_sc_hd__mux2_1
XANTENNA__4787__S1 _4794_/A VGND VGND VPWR VPWR sky130_fd_sc_hd__diode_2
X_5586_ _6094_/CLK _5586_/D VGND VGND VPWR VPWR _5586_/Q sky130_fd_sc_hd__dfxtp_1
XFILLER_132_701 VPWR VGND VPWR VGND sky130_ef_sc_hd__decap_40_12
X_4537_ hold869/X _5820_/Q _4547_/S VGND VGND VPWR VPWR _4537_/X sky130_fd_sc_hd__mux2_1
XFILLER_117_797 VPWR VGND VPWR VGND sky130_ef_sc_hd__decap_40_12
Xhold321 _5900_/Q VGND VGND VPWR VPWR hold321/X sky130_fd_sc_hd__dlygate4sd3_1
Xhold343 _5449_/Q VGND VGND VPWR VPWR hold343/X sky130_fd_sc_hd__dlygate4sd3_1
Xhold332 _4479_/X VGND VGND VPWR VPWR _6086_/D sky130_fd_sc_hd__dlygate4sd3_1
XFILLER_117_47 VGND VGND VPWR VPWR sky130_fd_sc_hd__fill_1
X_4468_ _5233_/A0 _4468_/A1 _4472_/S VGND VGND VPWR VPWR _4468_/X sky130_fd_sc_hd__mux2_1
Xhold354 _4544_/X VGND VGND VPWR VPWR _6146_/D sky130_fd_sc_hd__dlygate4sd3_1
Xhold365 _5608_/Q VGND VGND VPWR VPWR hold365/X sky130_fd_sc_hd__dlygate4sd3_1
Xhold387 _5610_/Q VGND VGND VPWR VPWR hold387/X sky130_fd_sc_hd__dlygate4sd3_1
Xhold376 _3396_/X VGND VGND VPWR VPWR _5453_/D sky130_fd_sc_hd__dlygate4sd3_1
XANTENNA__3116__A1 _5239_/A1 VGND VGND VPWR VPWR sky130_fd_sc_hd__diode_2
X_6207_ _6239_/CLK _6207_/D VGND VGND VPWR VPWR _6207_/Q sky130_fd_sc_hd__dfxtp_1
Xhold398 _4457_/X VGND VGND VPWR VPWR _6067_/D sky130_fd_sc_hd__dlygate4sd3_1
X_3419_ _3419_/A0 _5212_/A1 _3423_/S VGND VGND VPWR VPWR _3419_/X sky130_fd_sc_hd__mux2_1
XTAP_TAPCELL_ROW_129_2236 VGND VPWR sky130_fd_sc_hd__tapvpwrvgnd_1
X_6138_ _6148_/CLK _6138_/D VGND VGND VPWR VPWR _6138_/Q sky130_fd_sc_hd__dfxtp_1
XFILLER_98_681 VPWR VGND VPWR VGND sky130_ef_sc_hd__decap_40_12
XFILLER_58_523 VGND VGND VPWR VPWR sky130_fd_sc_hd__fill_1
X_4399_ _5052_/A1 _4399_/A1 _4406_/S VGND VGND VPWR VPWR _4399_/X sky130_fd_sc_hd__mux2_1
Xhold1010 _5374_/Q VGND VGND VPWR VPWR _3214_/A1 sky130_fd_sc_hd__dlygate4sd3_1
Xhold1032 _5355_/Q VGND VGND VPWR VPWR _3192_/A0 sky130_fd_sc_hd__dlygate4sd3_1
XTAP_TAPCELL_ROW_51_1066 VGND VPWR sky130_fd_sc_hd__tapvpwrvgnd_1
Xhold1021 _3382_/X VGND VGND VPWR VPWR _5441_/D sky130_fd_sc_hd__dlygate4sd3_1
XTAP_TAPCELL_ROW_5_379 VGND VPWR sky130_fd_sc_hd__tapvpwrvgnd_1
XTAP_TAPCELL_ROW_5_368 VGND VPWR sky130_fd_sc_hd__tapvpwrvgnd_1
X_6069_ _6428_/CLK _6069_/D VGND VGND VPWR VPWR _6069_/Q sky130_fd_sc_hd__dfxtp_1
Xhold1043 _4901_/X VGND VGND VPWR VPWR _6249_/D sky130_fd_sc_hd__dlygate4sd3_1
XFILLER_93_39 VGND VGND VPWR VPWR sky130_fd_sc_hd__fill_8
XFILLER_73_515 VGND VGND VPWR VPWR sky130_fd_sc_hd__fill_1
XFILLER_58_589 VGND VGND VPWR VPWR sky130_fd_sc_hd__fill_1
Xhold1054 _6068_/Q VGND VGND VPWR VPWR _4459_/A1 sky130_fd_sc_hd__dlygate4sd3_1
Xhold1076 _6274_/Q VGND VGND VPWR VPWR _4938_/A1 sky130_fd_sc_hd__dlygate4sd3_1
Xhold1065 _3784_/X VGND VGND VPWR VPWR _5792_/D sky130_fd_sc_hd__dlygate4sd3_1
XFILLER_100_697 VGND VGND VPWR VPWR sky130_fd_sc_hd__fill_2
Xhold1087 _4302_/X VGND VGND VPWR VPWR _5952_/D sky130_fd_sc_hd__dlygate4sd3_1
Xhold1098 _5886_/Q VGND VGND VPWR VPWR _3907_/A0 sky130_fd_sc_hd__dlygate4sd3_1
XTAP_TAPCELL_ROW_107_1899 VGND VPWR sky130_fd_sc_hd__tapvpwrvgnd_1
XFILLER_14_637 VGND VGND VPWR VPWR sky130_fd_sc_hd__fill_4
XFILLER_26_475 VGND VGND VPWR VPWR sky130_fd_sc_hd__fill_1
XANTENNA__5041__A1 _5053_/A1 VGND VGND VPWR VPWR sky130_fd_sc_hd__diode_2
XTAP_TAPCELL_ROW_24_654 VGND VPWR sky130_fd_sc_hd__tapvpwrvgnd_1
XANTENNA__3052__B1 _3089_/C1 VGND VGND VPWR VPWR sky130_fd_sc_hd__diode_2
XTAP_TAPCELL_ROW_24_665 VGND VPWR sky130_fd_sc_hd__tapvpwrvgnd_1
XFILLER_42_87 VGND VGND VPWR VPWR sky130_fd_sc_hd__fill_1
XFILLER_127_517 VPWR VGND VPWR VGND sky130_ef_sc_hd__decap_40_12
XFILLER_6_825 VPWR VGND VPWR VGND sky130_ef_sc_hd__decap_40_12
XFILLER_108_753 VGND VGND VPWR VPWR sky130_fd_sc_hd__fill_2
XFILLER_5_335 VGND VGND VPWR VPWR sky130_fd_sc_hd__fill_1
XFILLER_135_561 VPWR VGND VPWR VGND sky130_ef_sc_hd__decap_40_12
XFILLER_122_211 VGND VGND VPWR VPWR sky130_fd_sc_hd__fill_4
XFILLER_107_285 VGND VGND VPWR VPWR sky130_fd_sc_hd__fill_1
XANTENNA__3107__A1 _5232_/A0 VGND VGND VPWR VPWR sky130_fd_sc_hd__diode_2
XANTENNA__5196__A1_N _3958_/A VGND VGND VPWR VPWR sky130_fd_sc_hd__diode_2
XFILLER_3_15 VPWR VGND VPWR VGND sky130_ef_sc_hd__decap_40_12
XFILLER_1_541 VPWR VGND VPWR VGND sky130_ef_sc_hd__decap_40_12
XFILLER_122_277 VGND VGND VPWR VPWR sky130_fd_sc_hd__fill_2
XFILLER_77_821 VPWR VGND VPWR VGND sky130_ef_sc_hd__decap_40_12
XFILLER_67_40 VGND VGND VPWR VPWR sky130_fd_sc_hd__fill_2
XFILLER_1_585 VPWR VGND VPWR VGND sky130_ef_sc_hd__decap_40_12
XFILLER_92_813 VPWR VGND VPWR VGND sky130_ef_sc_hd__decap_40_12
XTAP_TAPCELL_ROW_69_1338 VGND VPWR sky130_fd_sc_hd__tapvpwrvgnd_1
XANTENNA__4544__S _4547_/S VGND VGND VPWR VPWR sky130_fd_sc_hd__diode_2
XPHY_EDGE_ROW_103_Left_242 VGND VGND VPWR VPWR sky130_fd_sc_hd__decap_3
XFILLER_45_762 VPWR VGND VPWR VGND sky130_ef_sc_hd__decap_40_12
XANTENNA__2837__A1_N _3096_/A1 VGND VGND VPWR VPWR sky130_fd_sc_hd__diode_2
XFILLER_91_389 VGND VGND VPWR VPWR sky130_fd_sc_hd__fill_2
XTAP_TAPCELL_ROW_82_1527 VGND VPWR sky130_fd_sc_hd__tapvpwrvgnd_1
XFILLER_17_497 VGND VGND VPWR VPWR sky130_fd_sc_hd__fill_4
XANTENNA__5134__A1_N _3958_/A VGND VGND VPWR VPWR sky130_fd_sc_hd__diode_2
XTAP_TAPCELL_ROW_43_952 VGND VPWR sky130_fd_sc_hd__tapvpwrvgnd_1
XTAP_TAPCELL_ROW_43_941 VGND VPWR sky130_fd_sc_hd__tapvpwrvgnd_1
X_3770_ _4978_/A1 _3770_/A1 _3776_/S VGND VGND VPWR VPWR _3770_/X sky130_fd_sc_hd__mux2_1
XANTENNA__4791__B1 _4791_/B1 VGND VGND VPWR VPWR sky130_fd_sc_hd__diode_2
XANTENNA__2999__S _3030_/S VGND VGND VPWR VPWR sky130_fd_sc_hd__diode_2
X_2721_ _2721_/A _2721_/B VGND VGND VPWR VPWR _2925_/S sky130_fd_sc_hd__nand2_4
XANTENNA__3594__A1 _4521_/A1 VGND VGND VPWR VPWR sky130_fd_sc_hd__diode_2
XFILLER_9_641 VPWR VGND VPWR VGND sky130_ef_sc_hd__decap_40_12
XPHY_EDGE_ROW_132_Right_132 VGND VGND VPWR VPWR sky130_fd_sc_hd__decap_3
X_5440_ _6380_/CLK _5440_/D VGND VGND VPWR VPWR _5440_/Q sky130_fd_sc_hd__dfxtp_1
XANTENNA__5149__A1_N _3958_/A VGND VGND VPWR VPWR sky130_fd_sc_hd__diode_2
XFILLER_9_685 VPWR VGND VPWR VGND sky130_ef_sc_hd__decap_40_12
X_2652_ _5006_/A VGND VGND VPWR VPWR _2652_/Y sky130_fd_sc_hd__inv_2
X_5371_ _6365_/CLK _5371_/D VGND VGND VPWR VPWR _5371_/Q sky130_fd_sc_hd__dfxtp_1
XFILLER_114_701 VPWR VGND VPWR VGND sky130_ef_sc_hd__decap_40_12
XPHY_EDGE_ROW_112_Left_251 VGND VGND VPWR VPWR sky130_fd_sc_hd__decap_3
X_4322_ hold530/X _5044_/A1 _4325_/S VGND VGND VPWR VPWR _4322_/X sky130_fd_sc_hd__mux2_1
XTAP_TAPCELL_ROW_93_1689 VGND VPWR sky130_fd_sc_hd__tapvpwrvgnd_1
Xfanout119 hold2230/X VGND VGND VPWR VPWR _4846_/A0 sky130_fd_sc_hd__clkbuf_8
Xfanout108 _5052_/A1 VGND VGND VPWR VPWR _5040_/A1 sky130_fd_sc_hd__buf_4
X_4253_ _5737_/Q _5467_/Q _5458_/Q _5449_/Q _4250_/S _4251_/A VGND VGND VPWR VPWR
+ _4253_/X sky130_fd_sc_hd__mux4_1
X_3204_ hold449/X _5235_/A0 _3206_/S VGND VGND VPWR VPWR _3204_/X sky130_fd_sc_hd__mux2_1
XFILLER_68_810 VGND VGND VPWR VPWR sky130_fd_sc_hd__fill_2
XFILLER_86_139 VGND VGND VPWR VPWR sky130_fd_sc_hd__fill_1
X_4184_ _4941_/A1 _6268_/Q _4257_/S VGND VGND VPWR VPWR _4184_/X sky130_fd_sc_hd__mux2_1
XFILLER_95_673 VPWR VGND VPWR VGND sky130_ef_sc_hd__decap_40_12
XTAP_TAPCELL_ROW_2_327 VGND VPWR sky130_fd_sc_hd__tapvpwrvgnd_1
X_3135_ _3135_/A _3135_/B VGND VGND VPWR VPWR _5322_/D sky130_fd_sc_hd__nor2_1
XPHY_EDGE_ROW_121_Left_260 VGND VGND VPWR VPWR sky130_fd_sc_hd__decap_3
X_3066_ _3094_/C1 _3061_/X _3064_/Y _3065_/Y VGND VGND VPWR VPWR _3066_/X sky130_fd_sc_hd__o2bb2a_1
XFILLER_103_27 VGND VGND VPWR VPWR sky130_fd_sc_hd__fill_4
XTAP_TAPCELL_ROW_124_2166 VGND VPWR sky130_fd_sc_hd__tapvpwrvgnd_1
XTAP_TAPCELL_ROW_124_2155 VGND VPWR sky130_fd_sc_hd__tapvpwrvgnd_1
XFILLER_70_507 VGND VGND VPWR VPWR sky130_fd_sc_hd__fill_1
XANTENNA__3859__A _5085_/A VGND VGND VPWR VPWR sky130_fd_sc_hd__diode_2
XFILLER_36_751 VGND VGND VPWR VPWR sky130_fd_sc_hd__fill_2
XANTENNA_fanout160_A _4178_/A VGND VGND VPWR VPWR sky130_fd_sc_hd__diode_2
XFILLER_23_445 VGND VGND VPWR VPWR sky130_fd_sc_hd__fill_2
X_3968_ _5060_/A _3967_/X _3315_/X VGND VGND VPWR VPWR _3972_/B sky130_fd_sc_hd__o21ba_1
XFILLER_11_629 VPWR VGND VPWR VGND sky130_ef_sc_hd__decap_40_12
X_2919_ _5518_/Q _5530_/Q _3077_/S VGND VGND VPWR VPWR _2919_/X sky130_fd_sc_hd__mux2_1
XTAP_TAPCELL_ROW_21_613 VGND VPWR sky130_fd_sc_hd__tapvpwrvgnd_1
X_5707_ _6122_/CLK _5707_/D VGND VGND VPWR VPWR _5707_/Q sky130_fd_sc_hd__dfxtp_1
XFILLER_137_837 VGND VGND VPWR VPWR sky130_fd_sc_hd__fill_2
X_3899_ _3899_/A0 _6406_/Q _3899_/S VGND VGND VPWR VPWR _3899_/X sky130_fd_sc_hd__mux2_1
X_5638_ _6237_/CLK _5638_/D VGND VGND VPWR VPWR _5638_/Q sky130_fd_sc_hd__dfxtp_1
XFILLER_117_561 VPWR VGND VPWR VGND sky130_ef_sc_hd__decap_40_12
X_5569_ _5571_/CLK _5569_/D VGND VGND VPWR VPWR _5569_/Q sky130_fd_sc_hd__dfxtp_1
XFILLER_88_17 VGND VGND VPWR VPWR sky130_fd_sc_hd__fill_8
XFILLER_132_531 VGND VGND VPWR VPWR sky130_fd_sc_hd__fill_1
Xhold151 _5613_/Q VGND VGND VPWR VPWR hold151/X sky130_fd_sc_hd__dlygate4sd3_1
Xhold162 _4360_/X VGND VGND VPWR VPWR _6002_/D sky130_fd_sc_hd__dlygate4sd3_1
XFILLER_3_839 VGND VGND VPWR VPWR sky130_fd_sc_hd__fill_1
Xhold140 _4516_/X VGND VGND VPWR VPWR _6119_/D sky130_fd_sc_hd__dlygate4sd3_1
XFILLER_78_607 VGND VGND VPWR VPWR sky130_fd_sc_hd__fill_1
Xhold195 _6001_/Q VGND VGND VPWR VPWR hold195/X sky130_fd_sc_hd__dlygate4sd3_1
Xhold173 _5771_/Q VGND VGND VPWR VPWR hold173/X sky130_fd_sc_hd__dlygate4sd3_1
Xhold184 _4341_/X VGND VGND VPWR VPWR _5986_/D sky130_fd_sc_hd__dlygate4sd3_1
XFILLER_120_737 VPWR VGND VPWR VGND sky130_ef_sc_hd__decap_40_12
XFILLER_104_288 VGND VGND VPWR VPWR sky130_fd_sc_hd__fill_1
XANTENNA__3533__S _3541_/S VGND VGND VPWR VPWR sky130_fd_sc_hd__diode_2
XFILLER_59_821 VPWR VGND VPWR VGND sky130_ef_sc_hd__decap_40_12
XFILLER_86_640 VGND VGND VPWR VPWR sky130_fd_sc_hd__fill_4
XANTENNA_fanout73_A _2629_/Y VGND VGND VPWR VPWR sky130_fd_sc_hd__diode_2
XTAP_TAPCELL_ROW_109_1928 VGND VPWR sky130_fd_sc_hd__tapvpwrvgnd_1
XFILLER_86_673 VGND VGND VPWR VPWR sky130_fd_sc_hd__fill_1
XFILLER_74_813 VPWR VGND VPWR VGND sky130_ef_sc_hd__decap_40_12
XFILLER_74_802 VGND VGND VPWR VPWR sky130_fd_sc_hd__fill_8
XFILLER_19_729 VPWR VGND VPWR VGND sky130_ef_sc_hd__decap_40_12
XTAP_TAPCELL_ROW_109_1939 VGND VPWR sky130_fd_sc_hd__tapvpwrvgnd_1
XFILLER_58_386 VGND VGND VPWR VPWR sky130_fd_sc_hd__fill_4
XFILLER_46_548 VPWR VGND VPWR VGND sky130_ef_sc_hd__decap_40_12
XTAP_TAPCELL_ROW_29_735 VGND VPWR sky130_fd_sc_hd__tapvpwrvgnd_1
XFILLER_61_507 VGND VGND VPWR VPWR sky130_fd_sc_hd__fill_1
XFILLER_27_762 VPWR VGND VPWR VGND sky130_ef_sc_hd__decap_40_12
XFILLER_14_401 VPWR VGND VPWR VGND sky130_ef_sc_hd__decap_40_12
XTAP_TAPCELL_ROW_64_1257 VGND VPWR sky130_fd_sc_hd__tapvpwrvgnd_1
XFILLER_42_765 VPWR VGND VPWR VGND sky130_ef_sc_hd__decap_40_12
XFILLER_14_445 VPWR VGND VPWR VGND sky130_ef_sc_hd__decap_40_12
XFILLER_14_489 VPWR VGND VPWR VGND sky130_ef_sc_hd__decap_40_12
XTAP_TAPCELL_ROW_40_900 VGND VPWR sky130_fd_sc_hd__tapvpwrvgnd_1
XANTENNA__3576__A1 _5208_/A1 VGND VGND VPWR VPWR sky130_fd_sc_hd__diode_2
XFILLER_128_837 VGND VGND VPWR VPWR sky130_fd_sc_hd__fill_4
XFILLER_127_314 VGND VGND VPWR VPWR sky130_fd_sc_hd__fill_2
XFILLER_6_699 VGND VGND VPWR VPWR sky130_fd_sc_hd__fill_1
XFILLER_5_165 VGND VGND VPWR VPWR sky130_fd_sc_hd__fill_1
XFILLER_123_553 VGND VGND VPWR VPWR sky130_fd_sc_hd__fill_4
XANTENNA__4539__S _4547_/S VGND VGND VPWR VPWR sky130_fd_sc_hd__diode_2
XFILLER_123_597 VPWR VGND VPWR VGND sky130_ef_sc_hd__decap_40_12
XANTENNA__3443__S _3450_/S VGND VGND VPWR VPWR sky130_fd_sc_hd__diode_2
XANTENNA__2848__A _2962_/A VGND VGND VPWR VPWR sky130_fd_sc_hd__diode_2
XFILLER_1_371 VGND VGND VPWR VPWR sky130_fd_sc_hd__fill_1
XFILLER_68_139 VGND VGND VPWR VPWR sky130_fd_sc_hd__fill_1
XFILLER_1_393 VGND VGND VPWR VPWR sky130_fd_sc_hd__fill_1
XFILLER_77_673 VGND VGND VPWR VPWR sky130_fd_sc_hd__fill_2
XFILLER_92_643 VGND VGND VPWR VPWR sky130_fd_sc_hd__fill_1
XFILLER_91_175 VGND VGND VPWR VPWR sky130_fd_sc_hd__fill_1
X_4940_ _4980_/A1 _4940_/A1 _4944_/S VGND VGND VPWR VPWR _4940_/X sky130_fd_sc_hd__mux2_1
X_4871_ _4871_/A0 _5819_/Q _4880_/S VGND VGND VPWR VPWR _4871_/X sky130_fd_sc_hd__mux2_1
XFILLER_33_765 VPWR VGND VPWR VGND sky130_ef_sc_hd__decap_40_12
X_3822_ _3818_/S _3821_/X _3819_/X _5176_/A VGND VGND VPWR VPWR _5822_/D sky130_fd_sc_hd__o211a_1
X_3753_ _4982_/A1 _4193_/A0 _3755_/S VGND VGND VPWR VPWR _3753_/X sky130_fd_sc_hd__mux2_1
XTAP_TAPCELL_ROW_95_1729 VGND VPWR sky130_fd_sc_hd__tapvpwrvgnd_1
XTAP_TAPCELL_ROW_95_1718 VGND VPWR sky130_fd_sc_hd__tapvpwrvgnd_1
X_3684_ _4488_/A0 _3684_/A1 _3688_/S VGND VGND VPWR VPWR _5706_/D sky130_fd_sc_hd__mux2_1
X_2704_ _3160_/A _2704_/B _3160_/C _3160_/D VGND VGND VPWR VPWR _4451_/A sky130_fd_sc_hd__or4b_4
XFILLER_106_509 VPWR VGND VPWR VGND sky130_ef_sc_hd__decap_40_12
X_5423_ _5820_/CLK _5423_/D VGND VGND VPWR VPWR _5423_/Q sky130_fd_sc_hd__dfxtp_1
X_2635_ _3172_/B VGND VGND VPWR VPWR _2635_/Y sky130_fd_sc_hd__inv_2
X_5354_ _5583_/CLK _5354_/D VGND VGND VPWR VPWR _5354_/Q sky130_fd_sc_hd__dfxtp_1
XFILLER_114_531 VGND VGND VPWR VPWR sky130_fd_sc_hd__fill_1
XTAP_TAPCELL_ROW_7_408 VGND VPWR sky130_fd_sc_hd__tapvpwrvgnd_1
X_4305_ _4346_/A _4305_/B _5323_/Q VGND VGND VPWR VPWR _4336_/B sky130_fd_sc_hd__or3b_4
XFILLER_102_737 VPWR VGND VPWR VGND sky130_ef_sc_hd__decap_40_12
XFILLER_87_426 VGND VGND VPWR VPWR sky130_fd_sc_hd__fill_1
X_5285_ _6394_/CLK hold5/X VGND VGND VPWR VPWR hold4/A sky130_fd_sc_hd__dfxtp_1
XFILLER_114_15 VPWR VGND VPWR VGND sky130_ef_sc_hd__decap_40_12
XFILLER_101_225 VGND VGND VPWR VPWR sky130_fd_sc_hd__fill_4
X_4236_ _4251_/A _4236_/B VGND VGND VPWR VPWR _4236_/Y sky130_fd_sc_hd__nor2_1
XFILLER_56_813 VPWR VGND VPWR VGND sky130_ef_sc_hd__decap_40_12
X_4167_ _4264_/A1 _4166_/X _3172_/B VGND VGND VPWR VPWR _4167_/X sky130_fd_sc_hd__o21a_1
X_3118_ hold845/X _5241_/A1 _3126_/S VGND VGND VPWR VPWR _3118_/X sky130_fd_sc_hd__mux2_1
XFILLER_110_781 VPWR VGND VPWR VGND sky130_ef_sc_hd__decap_40_12
XFILLER_55_345 VGND VGND VPWR VPWR sky130_fd_sc_hd__fill_2
X_4098_ _2636_/Y _4095_/X _4271_/S1 VGND VGND VPWR VPWR _4098_/X sky130_fd_sc_hd__o21a_1
X_3049_ hold23/A _6253_/Q _3051_/S VGND VGND VPWR VPWR _3050_/B sky130_fd_sc_hd__mux2_1
XANTENNA__4452__C1 _3801_/B VGND VGND VPWR VPWR sky130_fd_sc_hd__diode_2
XANTENNA__4184__S _4257_/S VGND VGND VPWR VPWR sky130_fd_sc_hd__diode_2
XANTENNA_fanout163_X _4212_/A VGND VGND VPWR VPWR sky130_fd_sc_hd__diode_2
XTAP_TAPCELL_ROW_104_1858 VGND VPWR sky130_fd_sc_hd__tapvpwrvgnd_1
XANTENNA__3007__B1 _3094_/C1 VGND VGND VPWR VPWR sky130_fd_sc_hd__diode_2
XFILLER_90_29 VGND VGND VPWR VPWR sky130_fd_sc_hd__fill_1
XTAP_TAPCELL_ROW_137_2357 VGND VPWR sky130_fd_sc_hd__tapvpwrvgnd_1
XANTENNA__3528__S _3529_/S VGND VGND VPWR VPWR sky130_fd_sc_hd__diode_2
XFILLER_23_67 VGND VGND VPWR VPWR sky130_fd_sc_hd__fill_1
XFILLER_99_27 VGND VGND VPWR VPWR sky130_fd_sc_hd__fill_4
XFILLER_23_89 VGND VGND VPWR VPWR sky130_fd_sc_hd__fill_2
XFILLER_124_306 VGND VGND VPWR VPWR sky130_fd_sc_hd__fill_2
XFILLER_124_317 VGND VGND VPWR VPWR sky130_fd_sc_hd__fill_1
XANTENNA__5180__B1 _5176_/A VGND VGND VPWR VPWR sky130_fd_sc_hd__diode_2
XFILLER_117_391 VGND VGND VPWR VPWR sky130_fd_sc_hd__fill_1
XFILLER_105_531 VPWR VGND VPWR VGND sky130_ef_sc_hd__decap_40_12
XFILLER_3_669 VGND VGND VPWR VPWR sky130_fd_sc_hd__fill_2
XFILLER_105_597 VPWR VGND VPWR VGND sky130_ef_sc_hd__decap_40_12
XFILLER_120_545 VPWR VGND VPWR VGND sky130_ef_sc_hd__decap_40_12
XFILLER_78_437 VGND VGND VPWR VPWR sky130_fd_sc_hd__fill_1
XANTENNA_fanout76_X _4521_/A1 VGND VGND VPWR VPWR sky130_fd_sc_hd__diode_2
XANTENNA__3494__A0 _4445_/A VGND VGND VPWR VPWR sky130_fd_sc_hd__diode_2
XFILLER_120_589 VPWR VGND VPWR VGND sky130_ef_sc_hd__decap_40_12
XFILLER_48_64 VGND VGND VPWR VPWR sky130_fd_sc_hd__fill_4
XFILLER_101_781 VGND VGND VPWR VPWR sky130_fd_sc_hd__fill_2
XFILLER_74_643 VGND VGND VPWR VPWR sky130_fd_sc_hd__fill_1
XFILLER_74_676 VGND VGND VPWR VPWR sky130_fd_sc_hd__fill_2
XFILLER_58_194 VGND VGND VPWR VPWR sky130_fd_sc_hd__fill_2
XFILLER_0_27 VGND VGND VPWR VPWR sky130_fd_sc_hd__fill_1
XFILLER_19_559 VGND VGND VPWR VPWR sky130_fd_sc_hd__fill_1
XANTENNA__5050__Y _5059_/S VGND VGND VPWR VPWR sky130_fd_sc_hd__diode_2
XFILLER_15_721 VGND VGND VPWR VPWR sky130_fd_sc_hd__fill_4
XFILLER_61_337 VGND VGND VPWR VPWR sky130_fd_sc_hd__fill_2
XANTENNA__3797__A1 _5202_/A1 VGND VGND VPWR VPWR sky130_fd_sc_hd__diode_2
XANTENNA__4822__S _4828_/S VGND VGND VPWR VPWR sky130_fd_sc_hd__diode_2
XFILLER_15_765 VPWR VGND VPWR VGND sky130_ef_sc_hd__decap_40_12
XANTENNA__3549__A1 _4961_/A0 VGND VGND VPWR VPWR sky130_fd_sc_hd__diode_2
XFILLER_42_584 VGND VGND VPWR VPWR sky130_fd_sc_hd__fill_4
XFILLER_30_757 VPWR VGND VPWR VGND sky130_ef_sc_hd__decap_40_12
XFILLER_128_601 VPWR VGND VPWR VGND sky130_ef_sc_hd__decap_40_12
Xfanout90 _5208_/A1 VGND VGND VPWR VPWR _4484_/A0 sky130_fd_sc_hd__clkbuf_4
XFILLER_128_645 VPWR VGND VPWR VGND sky130_ef_sc_hd__decap_40_12
XTAP_TAPCELL_ROW_12_476 VGND VPWR sky130_fd_sc_hd__tapvpwrvgnd_1
XTAP_TAPCELL_ROW_12_487 VGND VPWR sky130_fd_sc_hd__tapvpwrvgnd_1
XTAP_TAPCELL_ROW_77_1448 VGND VPWR sky130_fd_sc_hd__tapvpwrvgnd_1
Xhold909 _4412_/X VGND VGND VPWR VPWR _6049_/D sky130_fd_sc_hd__dlygate4sd3_1
XTAP_TAPCELL_ROW_77_1459 VGND VPWR sky130_fd_sc_hd__tapvpwrvgnd_1
XFILLER_96_201 VGND VGND VPWR VPWR sky130_fd_sc_hd__fill_2
XTAP_TAPCELL_ROW_90_1648 VGND VPWR sky130_fd_sc_hd__tapvpwrvgnd_1
XANTENNA__3721__A1 _5040_/A1 VGND VGND VPWR VPWR sky130_fd_sc_hd__diode_2
X_5070_ _5238_/A1 _5070_/A1 _5081_/S VGND VGND VPWR VPWR _5070_/X sky130_fd_sc_hd__mux2_1
Xhold1609 _3510_/X VGND VGND VPWR VPWR _5554_/D sky130_fd_sc_hd__dlygate4sd3_1
X_4021_ _4212_/A _4021_/B VGND VGND VPWR VPWR _4021_/X sky130_fd_sc_hd__or2_1
XFILLER_29_3 VPWR VGND VPWR VGND sky130_ef_sc_hd__decap_40_12
XFILLER_38_802 VGND VGND VPWR VPWR sky130_fd_sc_hd__fill_8
XFILLER_38_813 VPWR VGND VPWR VGND sky130_ef_sc_hd__decap_40_12
XTAP_TAPCELL_ROW_121_2114 VGND VPWR sky130_fd_sc_hd__tapvpwrvgnd_1
XFILLER_92_473 VGND VGND VPWR VPWR sky130_fd_sc_hd__fill_2
X_5972_ _5990_/CLK hold98/X VGND VGND VPWR VPWR hold97/A sky130_fd_sc_hd__dfxtp_1
X_4923_ _5199_/A1 _4907_/Y _4922_/X _5200_/A VGND VGND VPWR VPWR _6262_/D sky130_fd_sc_hd__o211a_1
XFILLER_18_581 VGND VGND VPWR VPWR sky130_fd_sc_hd__fill_4
XFILLER_33_551 VGND VGND VPWR VPWR sky130_fd_sc_hd__fill_1
X_4854_ _4906_/A0 _4854_/A1 _4854_/S VGND VGND VPWR VPWR _4854_/X sky130_fd_sc_hd__mux2_1
X_3805_ input19/X _5232_/A0 _3810_/S VGND VGND VPWR VPWR _5811_/D sky130_fd_sc_hd__mux2_1
X_4785_ _4771_/X _4784_/X _4785_/S VGND VGND VPWR VPWR _4785_/X sky130_fd_sc_hd__mux2_1
XFILLER_20_234 VGND VGND VPWR VPWR sky130_fd_sc_hd__fill_1
XTAP_TAPCELL_ROW_119_2087 VGND VPWR sky130_fd_sc_hd__tapvpwrvgnd_1
X_3736_ hold145/X _5228_/A0 _3745_/S VGND VGND VPWR VPWR _3736_/X sky130_fd_sc_hd__mux2_1
XANTENNA_fanout123_A _5816_/Q VGND VGND VPWR VPWR sky130_fd_sc_hd__diode_2
XTAP_TAPCELL_ROW_31_763 VGND VPWR sky130_fd_sc_hd__tapvpwrvgnd_1
XFILLER_109_15 VPWR VGND VPWR VGND sky130_ef_sc_hd__decap_40_12
XFILLER_9_290 VGND VGND VPWR VPWR sky130_fd_sc_hd__fill_1
XFILLER_134_637 VGND VGND VPWR VPWR sky130_fd_sc_hd__fill_4
XFILLER_109_59 VGND VGND VPWR VPWR sky130_fd_sc_hd__fill_1
Xclkload71 _5583_/CLK VGND VGND VPWR VPWR clkload71/Y sky130_fd_sc_hd__clkinv_2
X_3667_ _4964_/A0 _3667_/A1 _3667_/S VGND VGND VPWR VPWR _3667_/X sky130_fd_sc_hd__mux2_1
Xclkload60 _6388_/CLK VGND VGND VPWR VPWR clkload60/Y sky130_fd_sc_hd__inv_12
XTAP_TAPCELL_ROW_132_2287 VGND VPWR sky130_fd_sc_hd__tapvpwrvgnd_1
X_5406_ _6432_/CLK _5406_/D VGND VGND VPWR VPWR _5406_/Q sky130_fd_sc_hd__dfxtp_1
XTAP_TAPCELL_ROW_132_2276 VGND VPWR sky130_fd_sc_hd__tapvpwrvgnd_1
Xclkload82 _6434_/CLK VGND VGND VPWR VPWR clkload82/Y sky130_fd_sc_hd__clkinv_2
Xclkload93 _5870_/CLK VGND VGND VPWR VPWR clkload93/Y sky130_fd_sc_hd__inv_6
X_6386_ _6386_/CLK _6386_/D VGND VGND VPWR VPWR _6386_/Q sky130_fd_sc_hd__dfxtp_4
X_3598_ hold516/X _5209_/A1 _3605_/S VGND VGND VPWR VPWR _3598_/X sky130_fd_sc_hd__mux2_1
XFILLER_133_169 VGND VGND VPWR VPWR sky130_fd_sc_hd__fill_1
XFILLER_114_361 VGND VGND VPWR VPWR sky130_fd_sc_hd__fill_1
X_5337_ _6172_/CLK _5337_/D VGND VGND VPWR VPWR _5337_/Q sky130_fd_sc_hd__dfxtp_1
XFILLER_0_617 VPWR VGND VPWR VGND sky130_ef_sc_hd__decap_40_12
XANTENNA__3712__A1 _4929_/A1 VGND VGND VPWR VPWR sky130_fd_sc_hd__diode_2
XFILLER_125_47 VGND VGND VPWR VPWR sky130_fd_sc_hd__fill_1
XFILLER_102_545 VPWR VGND VPWR VGND sky130_ef_sc_hd__decap_40_12
XFILLER_88_757 VPWR VGND VPWR VGND sky130_ef_sc_hd__decap_40_12
X_5268_ _6196_/CLK _5268_/D VGND VGND VPWR VPWR _5268_/Q sky130_fd_sc_hd__dfxtp_1
XFILLER_102_589 VPWR VGND VPWR VGND sky130_ef_sc_hd__decap_40_12
X_4219_ _4219_/A1 _4218_/A _4203_/X _4218_/Y VGND VGND VPWR VPWR _4219_/X sky130_fd_sc_hd__a22o_1
XANTENNA__3476__A0 _4905_/A0 VGND VGND VPWR VPWR sky130_fd_sc_hd__diode_2
X_5199_ _5199_/A1 _3956_/Y _5160_/A _5123_/X _5198_/X VGND VGND VPWR VPWR _5200_/B
+ sky130_fd_sc_hd__a41o_1
XFILLER_44_805 VGND VGND VPWR VPWR sky130_fd_sc_hd__fill_4
XFILLER_28_334 VGND VGND VPWR VPWR sky130_fd_sc_hd__fill_4
XFILLER_71_613 VGND VGND VPWR VPWR sky130_fd_sc_hd__fill_2
XTAP_TAPCELL_ROW_48_1027 VGND VPWR sky130_fd_sc_hd__tapvpwrvgnd_1
XTAP_TAPCELL_ROW_48_1016 VGND VPWR sky130_fd_sc_hd__tapvpwrvgnd_1
XFILLER_16_529 VGND VGND VPWR VPWR sky130_fd_sc_hd__fill_2
XTAP_TAPCELL_ROW_39_885 VGND VPWR sky130_fd_sc_hd__tapvpwrvgnd_1
XFILLER_55_186 VGND VGND VPWR VPWR sky130_fd_sc_hd__fill_1
XANTENNA__3779__A1 _5208_/A1 VGND VGND VPWR VPWR sky130_fd_sc_hd__diode_2
XANTENNA__4440__A2 _3366_/X VGND VGND VPWR VPWR sky130_fd_sc_hd__diode_2
XFILLER_12_713 VPWR VGND VPWR VGND sky130_ef_sc_hd__decap_40_12
XTAP_TAPCELL_ROW_61_1216 VGND VPWR sky130_fd_sc_hd__tapvpwrvgnd_1
XFILLER_11_223 VGND VGND VPWR VPWR sky130_fd_sc_hd__fill_1
XFILLER_24_584 VGND VGND VPWR VPWR sky130_fd_sc_hd__fill_2
XFILLER_133_3 VPWR VGND VPWR VGND sky130_ef_sc_hd__decap_40_12
XFILLER_12_757 VPWR VGND VPWR VGND sky130_ef_sc_hd__decap_40_12
XFILLER_125_615 VGND VGND VPWR VPWR sky130_fd_sc_hd__fill_1
XFILLER_137_497 VGND VGND VPWR VPWR sky130_fd_sc_hd__fill_4
XTAP_TAPCELL_ROW_59_1189 VGND VPWR sky130_fd_sc_hd__tapvpwrvgnd_1
XTAP_TAPCELL_ROW_59_1178 VGND VPWR sky130_fd_sc_hd__tapvpwrvgnd_1
XFILLER_3_444 VGND VGND VPWR VPWR sky130_fd_sc_hd__fill_4
XANTENNA__4900__A0 _5810_/Q VGND VGND VPWR VPWR sky130_fd_sc_hd__diode_2
XFILLER_121_821 VPWR VGND VPWR VGND sky130_ef_sc_hd__decap_40_12
XANTENNA__4089__S _4260_/S VGND VGND VPWR VPWR sky130_fd_sc_hd__diode_2
XTAP_TAPCELL_ROW_72_1378 VGND VPWR sky130_fd_sc_hd__tapvpwrvgnd_1
XFILLER_78_267 VGND VGND VPWR VPWR sky130_fd_sc_hd__fill_1
XANTENNA__3467__A0 _5239_/A1 VGND VGND VPWR VPWR sky130_fd_sc_hd__diode_2
XFILLER_94_749 VGND VGND VPWR VPWR sky130_fd_sc_hd__fill_4
XANTENNA__4817__S _4828_/S VGND VGND VPWR VPWR sky130_fd_sc_hd__diode_2
XANTENNA__5208__A1 _5208_/A1 VGND VGND VPWR VPWR sky130_fd_sc_hd__diode_2
XFILLER_46_131 VGND VGND VPWR VPWR sky130_fd_sc_hd__fill_8
XANTENNA__3219__A0 _5080_/A0 VGND VGND VPWR VPWR sky130_fd_sc_hd__diode_2
XFILLER_75_84 VGND VGND VPWR VPWR sky130_fd_sc_hd__fill_1
XFILLER_74_473 VGND VGND VPWR VPWR sky130_fd_sc_hd__fill_1
XFILLER_47_687 VGND VGND VPWR VPWR sky130_fd_sc_hd__fill_1
XANTENNA__2690__B2 _2682_/A VGND VGND VPWR VPWR sky130_fd_sc_hd__diode_2
XANTENNA__4967__A0 _5824_/Q VGND VGND VPWR VPWR sky130_fd_sc_hd__diode_2
XFILLER_34_348 VGND VGND VPWR VPWR sky130_fd_sc_hd__fill_4
XTAP_TAPCELL_ROW_17_557 VGND VPWR sky130_fd_sc_hd__tapvpwrvgnd_1
XANTENNA__2861__A _3050_/A VGND VGND VPWR VPWR sky130_fd_sc_hd__diode_2
XANTENNA__4552__S _4561_/S VGND VGND VPWR VPWR sky130_fd_sc_hd__diode_2
XFILLER_15_573 VPWR VGND VPWR VGND sky130_ef_sc_hd__decap_40_12
XANTENNA__4719__B1 _4811_/C1 VGND VGND VPWR VPWR sky130_fd_sc_hd__diode_2
X_4570_ _5843_/Q _5621_/Q _4713_/S VGND VGND VPWR VPWR _4570_/X sky130_fd_sc_hd__mux2_1
XANTENNA__4195__A1 _4149_/A VGND VGND VPWR VPWR sky130_fd_sc_hd__diode_2
X_3521_ _5818_/Q _3521_/A1 _3529_/S VGND VGND VPWR VPWR _3521_/X sky130_fd_sc_hd__mux2_1
XFILLER_128_475 VGND VGND VPWR VPWR sky130_fd_sc_hd__fill_1
XFILLER_116_637 VGND VGND VPWR VPWR sky130_fd_sc_hd__fill_4
Xhold717 _4886_/X VGND VGND VPWR VPWR _6235_/D sky130_fd_sc_hd__dlygate4sd3_1
Xhold706 _5903_/Q VGND VGND VPWR VPWR hold706/X sky130_fd_sc_hd__dlygate4sd3_1
XANTENNA_clkbuf_leaf_3_clk_A clkbuf_leaf_9_clk/A VGND VGND VPWR VPWR sky130_fd_sc_hd__diode_2
XFILLER_7_783 VGND VGND VPWR VPWR sky130_fd_sc_hd__fill_1
Xhold728 _5987_/Q VGND VGND VPWR VPWR hold728/X sky130_fd_sc_hd__dlygate4sd3_1
X_3452_ hold572/X _5238_/A1 _3463_/S VGND VGND VPWR VPWR _3452_/X sky130_fd_sc_hd__mux2_1
X_6240_ _6241_/CLK _6240_/D VGND VGND VPWR VPWR _6240_/Q sky130_fd_sc_hd__dfxtp_1
XANTENNA__2800__S _3030_/S VGND VGND VPWR VPWR sky130_fd_sc_hd__diode_2
Xhold739 _5967_/Q VGND VGND VPWR VPWR hold739/X sky130_fd_sc_hd__dlygate4sd3_1
XFILLER_131_629 VPWR VGND VPWR VGND sky130_ef_sc_hd__decap_40_12
XFILLER_130_106 VGND VGND VPWR VPWR sky130_fd_sc_hd__fill_1
XFILLER_115_169 VGND VGND VPWR VPWR sky130_fd_sc_hd__fill_1
X_6171_ _6239_/CLK _6171_/D VGND VGND VPWR VPWR _6171_/Q sky130_fd_sc_hd__dfxtp_1
X_3383_ hold285/X _5040_/A1 _3390_/S VGND VGND VPWR VPWR _3383_/X sky130_fd_sc_hd__mux2_1
XFILLER_124_681 VPWR VGND VPWR VGND sky130_ef_sc_hd__decap_40_12
Xhold2107 _6397_/Q VGND VGND VPWR VPWR _5162_/A sky130_fd_sc_hd__dlygate4sd3_1
XFILLER_69_223 VGND VGND VPWR VPWR sky130_fd_sc_hd__fill_1
Xhold2118 _5184_/Y VGND VGND VPWR VPWR _6401_/D sky130_fd_sc_hd__dlygate4sd3_1
X_5122_ _4006_/Y _5121_/Y _4007_/A VGND VGND VPWR VPWR _5145_/A sky130_fd_sc_hd__a21oi_2
XFILLER_111_364 VGND VGND VPWR VPWR sky130_fd_sc_hd__fill_1
Xhold2129 _5396_/Q VGND VGND VPWR VPWR _4994_/A sky130_fd_sc_hd__dlygate4sd3_1
Xhold1406 _5744_/Q VGND VGND VPWR VPWR _4193_/A1 sky130_fd_sc_hd__dlygate4sd3_1
XFILLER_29_109 VGND VGND VPWR VPWR sky130_fd_sc_hd__fill_2
XFILLER_85_738 VGND VGND VPWR VPWR sky130_fd_sc_hd__fill_1
Xhold1428 _3895_/X VGND VGND VPWR VPWR _5874_/D sky130_fd_sc_hd__dlygate4sd3_1
X_5053_ hold657/X _5053_/A1 _5059_/S VGND VGND VPWR VPWR _5053_/X sky130_fd_sc_hd__mux2_1
Xhold1439 _5785_/Q VGND VGND VPWR VPWR _3775_/A1 sky130_fd_sc_hd__dlygate4sd3_1
Xhold1417 _5897_/Q VGND VGND VPWR VPWR _3920_/A0 sky130_fd_sc_hd__dlygate4sd3_1
X_4004_ _5029_/B _5010_/B VGND VGND VPWR VPWR _4004_/Y sky130_fd_sc_hd__nor2_1
XFILLER_26_805 VGND VGND VPWR VPWR sky130_fd_sc_hd__fill_4
XFILLER_1_81 VPWR VGND VPWR VGND sky130_ef_sc_hd__decap_40_12
XFILLER_111_27 VPWR VGND VPWR VGND sky130_ef_sc_hd__decap_40_12
XANTENNA__4958__A0 _4958_/A0 VGND VGND VPWR VPWR sky130_fd_sc_hd__diode_2
XFILLER_25_337 VGND VGND VPWR VPWR sky130_fd_sc_hd__fill_4
XTAP_TAPCELL_ROW_36_833 VGND VPWR sky130_fd_sc_hd__tapvpwrvgnd_1
XTAP_TAPCELL_ROW_36_844 VGND VPWR sky130_fd_sc_hd__tapvpwrvgnd_1
X_5955_ _6334_/CLK hold66/X VGND VGND VPWR VPWR hold65/A sky130_fd_sc_hd__dfxtp_1
XFILLER_40_307 VGND VGND VPWR VPWR sky130_fd_sc_hd__fill_1
XANTENNA__4462__S _4472_/S VGND VGND VPWR VPWR sky130_fd_sc_hd__diode_2
X_4906_ _4906_/A0 _4906_/A1 _4906_/S VGND VGND VPWR VPWR _4906_/X sky130_fd_sc_hd__mux2_1
XTAP_TAPCELL_ROW_101_1817 VGND VPWR sky130_fd_sc_hd__tapvpwrvgnd_1
X_5886_ _6414_/CLK _5886_/D VGND VGND VPWR VPWR _5886_/Q sky130_fd_sc_hd__dfxtp_1
X_4837_ _4889_/A1 _4837_/A1 _4841_/S VGND VGND VPWR VPWR _4837_/X sky130_fd_sc_hd__mux2_1
XTAP_TAPCELL_ROW_134_2316 VGND VPWR sky130_fd_sc_hd__tapvpwrvgnd_1
XTAP_TAPCELL_ROW_134_2305 VGND VPWR sky130_fd_sc_hd__tapvpwrvgnd_1
XANTENNA__4805__S0 _4803_/S VGND VGND VPWR VPWR sky130_fd_sc_hd__diode_2
XFILLER_119_453 VGND VGND VPWR VPWR sky130_fd_sc_hd__fill_1
XANTENNA_fanout126_X _5235_/A0 VGND VGND VPWR VPWR sky130_fd_sc_hd__diode_2
XFILLER_5_709 VPWR VGND VPWR VGND sky130_ef_sc_hd__decap_40_12
X_4768_ _6124_/Q _6115_/Q _4801_/S VGND VGND VPWR VPWR _4768_/X sky130_fd_sc_hd__mux2_1
XFILLER_107_615 VGND VGND VPWR VPWR sky130_fd_sc_hd__fill_1
X_3719_ _5050_/B _3767_/B VGND VGND VPWR VPWR _3728_/S sky130_fd_sc_hd__nor2_4
X_4699_ _5679_/Q _5661_/Q _5652_/Q hold63/A _4808_/S _4809_/A VGND VGND VPWR VPWR
+ _4699_/X sky130_fd_sc_hd__mux4_1
X_6438_ _6438_/CLK _6438_/D VGND VGND VPWR VPWR _6438_/Q sky130_fd_sc_hd__dfxtp_1
XANTENNA__2710__S _2716_/S VGND VGND VPWR VPWR sky130_fd_sc_hd__diode_2
XFILLER_134_489 VPWR VGND VPWR VGND sky130_ef_sc_hd__decap_40_12
XANTENNA__4033__S1 _4251_/A VGND VGND VPWR VPWR sky130_fd_sc_hd__diode_2
XFILLER_121_117 VGND VGND VPWR VPWR sky130_fd_sc_hd__fill_1
X_6369_ _6369_/CLK _6369_/D VGND VGND VPWR VPWR _6369_/Q sky130_fd_sc_hd__dfxtp_1
XFILLER_114_180 VGND VGND VPWR VPWR sky130_fd_sc_hd__fill_1
XTAP_TAPCELL_ROW_112_1979 VGND VPWR sky130_fd_sc_hd__tapvpwrvgnd_1
XFILLER_103_821 VPWR VGND VPWR VGND sky130_ef_sc_hd__decap_40_12
XFILLER_88_543 VGND VGND VPWR VPWR sky130_fd_sc_hd__fill_4
XFILLER_0_436 VGND VGND VPWR VPWR sky130_fd_sc_hd__fill_1
Xhold11 hold11/A VGND VGND VPWR VPWR hold11/X sky130_fd_sc_hd__dlygate4sd3_1
Xhold22 hold22/A VGND VGND VPWR VPWR hold22/X sky130_fd_sc_hd__dlygate4sd3_1
XFILLER_76_705 VGND VGND VPWR VPWR sky130_fd_sc_hd__fill_1
XFILLER_0_447 VGND VGND VPWR VPWR sky130_fd_sc_hd__fill_1
Xhold55 hold55/A VGND VGND VPWR VPWR hold55/X sky130_fd_sc_hd__dlygate4sd3_1
XANTENNA__3541__S _3541_/S VGND VGND VPWR VPWR sky130_fd_sc_hd__diode_2
Xhold33 hold33/A VGND VGND VPWR VPWR hold33/X sky130_fd_sc_hd__dlygate4sd3_1
Xhold44 hold44/A VGND VGND VPWR VPWR hold44/X sky130_fd_sc_hd__dlygate4sd3_1
Xhold77 hold77/A VGND VGND VPWR VPWR hold77/X sky130_fd_sc_hd__dlygate4sd3_1
Xhold99 hold99/A VGND VGND VPWR VPWR hold99/X sky130_fd_sc_hd__dlygate4sd3_1
Xhold1940 _5724_/Q VGND VGND VPWR VPWR _3703_/A1 sky130_fd_sc_hd__dlygate4sd3_1
Xhold66 hold66/A VGND VGND VPWR VPWR hold66/X sky130_fd_sc_hd__dlygate4sd3_1
Xhold88 hold88/A VGND VGND VPWR VPWR hold88/X sky130_fd_sc_hd__dlygate4sd3_1
Xhold1962 _5391_/Q VGND VGND VPWR VPWR _3356_/A1 sky130_fd_sc_hd__dlygate4sd3_1
Xhold1951 _3259_/X VGND VGND VPWR VPWR _5395_/D sky130_fd_sc_hd__dlygate4sd3_1
Xhold1973 _5094_/X VGND VGND VPWR VPWR _6382_/D sky130_fd_sc_hd__dlygate4sd3_1
XFILLER_56_462 VGND VGND VPWR VPWR sky130_fd_sc_hd__fill_1
XFILLER_28_164 VGND VGND VPWR VPWR sky130_fd_sc_hd__fill_4
Xhold1984 _5922_/Q VGND VGND VPWR VPWR _4133_/A1 sky130_fd_sc_hd__dlygate4sd3_1
Xhold1995 _4163_/X VGND VGND VPWR VPWR _5923_/D sky130_fd_sc_hd__dlygate4sd3_1
XANTENNA__2672__A1 _4889_/A1 VGND VGND VPWR VPWR sky130_fd_sc_hd__diode_2
XFILLER_71_421 VGND VGND VPWR VPWR sky130_fd_sc_hd__fill_2
XANTENNA__4949__A0 _5042_/A1 VGND VGND VPWR VPWR sky130_fd_sc_hd__diode_2
XTAP_TAPCELL_ROW_14_505 VGND VPWR sky130_fd_sc_hd__tapvpwrvgnd_1
XTAP_TAPCELL_ROW_14_516 VGND VPWR sky130_fd_sc_hd__tapvpwrvgnd_1
XFILLER_40_841 VGND VGND VPWR VPWR sky130_fd_sc_hd__fill_1
XFILLER_61_86 VGND VGND VPWR VPWR sky130_fd_sc_hd__fill_1
XFILLER_8_525 VGND VGND VPWR VPWR sky130_fd_sc_hd__fill_4
XFILLER_12_587 VGND VGND VPWR VPWR sky130_fd_sc_hd__fill_1
XFILLER_138_751 VGND VGND VPWR VPWR sky130_fd_sc_hd__fill_1
XFILLER_8_569 VPWR VGND VPWR VGND sky130_ef_sc_hd__decap_40_12
XFILLER_6_15 VPWR VGND VPWR VGND sky130_ef_sc_hd__decap_40_12
XFILLER_6_48 VGND VGND VPWR VPWR sky130_fd_sc_hd__fill_4
XANTENNA__3924__A1 _4488_/A0 VGND VGND VPWR VPWR sky130_fd_sc_hd__diode_2
XTAP_TAPCELL_ROW_74_1407 VGND VPWR sky130_fd_sc_hd__tapvpwrvgnd_1
XFILLER_6_59 VGND VGND VPWR VPWR sky130_fd_sc_hd__fill_1
XFILLER_4_753 VGND VGND VPWR VPWR sky130_fd_sc_hd__fill_2
XFILLER_113_629 VPWR VGND VPWR VGND sky130_ef_sc_hd__decap_40_12
XANTENNA__3688__A0 _5202_/A1 VGND VGND VPWR VPWR sky130_fd_sc_hd__diode_2
XFILLER_106_681 VPWR VGND VPWR VGND sky130_ef_sc_hd__decap_40_12
XANTENNA__2856__A _3044_/A VGND VGND VPWR VPWR sky130_fd_sc_hd__diode_2
XFILLER_121_673 VPWR VGND VPWR VGND sky130_ef_sc_hd__decap_40_12
XANTENNA__4547__S _4547_/S VGND VGND VPWR VPWR sky130_fd_sc_hd__diode_2
XANTENNA__4637__C1 _4811_/C1 VGND VGND VPWR VPWR sky130_fd_sc_hd__diode_2
XFILLER_39_429 VGND VGND VPWR VPWR sky130_fd_sc_hd__fill_2
XFILLER_94_557 VPWR VGND VPWR VGND sky130_ef_sc_hd__decap_40_12
XFILLER_90_741 VPWR VGND VPWR VGND sky130_ef_sc_hd__decap_40_12
XTAP_TAPCELL_ROW_85_1569 VGND VPWR sky130_fd_sc_hd__tapvpwrvgnd_1
XFILLER_22_307 VGND VGND VPWR VPWR sky130_fd_sc_hd__fill_1
XFILLER_35_679 VGND VGND VPWR VPWR sky130_fd_sc_hd__fill_1
XFILLER_96_3 VPWR VGND VPWR VGND sky130_ef_sc_hd__decap_40_12
X_2952_ _2967_/S _2951_/X _2945_/Y _2735_/A VGND VGND VPWR VPWR _2952_/Y sky130_fd_sc_hd__o211ai_1
X_5740_ _5908_/CLK _5740_/D VGND VGND VPWR VPWR _5740_/Q sky130_fd_sc_hd__dfxtp_1
Xclkbuf_leaf_108_clk clkload0/A VGND VGND VPWR VPWR _6310_/CLK sky130_fd_sc_hd__clkbuf_8
XFILLER_31_841 VGND VGND VPWR VPWR sky130_fd_sc_hd__fill_1
X_2883_ _3085_/A _2883_/B VGND VGND VPWR VPWR _2883_/X sky130_fd_sc_hd__and2_1
X_5671_ _5902_/CLK _5671_/D VGND VGND VPWR VPWR _5671_/Q sky130_fd_sc_hd__dfxtp_1
XTAP_TAPCELL_ROW_116_2035 VGND VPWR sky130_fd_sc_hd__tapvpwrvgnd_1
X_4622_ _4791_/A1 _4621_/X _4791_/B1 VGND VGND VPWR VPWR _4622_/X sky130_fd_sc_hd__o21a_1
XTAP_TAPCELL_ROW_116_2046 VGND VPWR sky130_fd_sc_hd__tapvpwrvgnd_1
X_4553_ hold574/X _5241_/A1 _4561_/S VGND VGND VPWR VPWR _4553_/X sky130_fd_sc_hd__mux2_1
XANTENNA__3915__A1 _5213_/A1 VGND VGND VPWR VPWR sky130_fd_sc_hd__diode_2
Xhold514 _5300_/Q VGND VGND VPWR VPWR hold514/X sky130_fd_sc_hd__dlygate4sd3_1
X_3504_ _4523_/B _5069_/B VGND VGND VPWR VPWR _3516_/S sky130_fd_sc_hd__or2_4
Xhold536 _5356_/Q VGND VGND VPWR VPWR hold536/X sky130_fd_sc_hd__dlygate4sd3_1
Xhold525 _3530_/X VGND VGND VPWR VPWR _5573_/D sky130_fd_sc_hd__dlygate4sd3_1
X_4484_ _4484_/A0 _4484_/A1 _4492_/S VGND VGND VPWR VPWR _6090_/D sky130_fd_sc_hd__mux2_1
Xhold503 _5905_/Q VGND VGND VPWR VPWR hold503/X sky130_fd_sc_hd__dlygate4sd3_1
XFILLER_131_404 VGND VGND VPWR VPWR sky130_fd_sc_hd__fill_1
XFILLER_116_489 VPWR VGND VPWR VGND sky130_ef_sc_hd__decap_40_12
Xhold569 _3308_/X VGND VGND VPWR VPWR _5426_/D sky130_fd_sc_hd__dlygate4sd3_1
X_6223_ _6232_/CLK _6223_/D VGND VGND VPWR VPWR _6223_/Q sky130_fd_sc_hd__dfxtp_1
X_3435_ hold427/X _4904_/A0 _3437_/S VGND VGND VPWR VPWR _3435_/X sky130_fd_sc_hd__mux2_1
Xhold558 _5961_/Q VGND VGND VPWR VPWR hold558/X sky130_fd_sc_hd__dlygate4sd3_1
Xhold547 _5454_/Q VGND VGND VPWR VPWR hold547/X sky130_fd_sc_hd__dlygate4sd3_1
XFILLER_131_426 VGND VGND VPWR VPWR sky130_fd_sc_hd__fill_1
XFILLER_106_27 VGND VGND VPWR VPWR sky130_fd_sc_hd__fill_1
XFILLER_98_841 VGND VGND VPWR VPWR sky130_fd_sc_hd__fill_1
X_6154_ _6232_/CLK hold80/X VGND VGND VPWR VPWR hold79/A sky130_fd_sc_hd__dfxtp_1
X_3366_ input5/X input4/X VGND VGND VPWR VPWR _3366_/X sky130_fd_sc_hd__and2_4
XANTENNA__4340__A1 _4929_/A1 VGND VGND VPWR VPWR sky130_fd_sc_hd__diode_2
XANTENNA__3143__A2 _4993_/S VGND VGND VPWR VPWR sky130_fd_sc_hd__diode_2
Xhold1203 _3493_/X VGND VGND VPWR VPWR _5538_/D sky130_fd_sc_hd__dlygate4sd3_1
Xhold1214 _4902_/X VGND VGND VPWR VPWR _6250_/D sky130_fd_sc_hd__dlygate4sd3_1
XFILLER_100_813 VPWR VGND VPWR VGND sky130_ef_sc_hd__decap_40_12
X_3297_ hold972/X _4882_/A1 _3308_/S VGND VGND VPWR VPWR _5415_/D sky130_fd_sc_hd__mux2_1
XANTENNA_fanout190_A _3086_/S VGND VGND VPWR VPWR sky130_fd_sc_hd__diode_2
XANTENNA__4457__S _4457_/S VGND VGND VPWR VPWR sky130_fd_sc_hd__diode_2
X_5105_ _3964_/B _3998_/Y _5097_/B _5099_/B VGND VGND VPWR VPWR _5110_/B sky130_fd_sc_hd__o31ai_1
X_6085_ _6121_/CLK _6085_/D VGND VGND VPWR VPWR _6085_/Q sky130_fd_sc_hd__dfxtp_1
Xhold1225 _6083_/Q VGND VGND VPWR VPWR _4476_/A0 sky130_fd_sc_hd__dlygate4sd3_1
Xhold1236 _5522_/Q VGND VGND VPWR VPWR _3475_/A1 sky130_fd_sc_hd__dlygate4sd3_1
Xhold1247 _3126_/X VGND VGND VPWR VPWR _5319_/D sky130_fd_sc_hd__dlygate4sd3_1
Xhold1258 _4877_/X VGND VGND VPWR VPWR _6227_/D sky130_fd_sc_hd__dlygate4sd3_1
X_5036_ _5201_/A _5112_/A VGND VGND VPWR VPWR _5037_/S sky130_fd_sc_hd__and2_1
XFILLER_122_15 VPWR VGND VPWR VGND sky130_ef_sc_hd__decap_40_12
Xhold1269 _5348_/Q VGND VGND VPWR VPWR _3185_/A0 sky130_fd_sc_hd__dlygate4sd3_1
XFILLER_72_207 VGND VGND VPWR VPWR sky130_fd_sc_hd__fill_1
XFILLER_82_19 VGND VGND VPWR VPWR sky130_fd_sc_hd__fill_8
XFILLER_72_229 VGND VGND VPWR VPWR sky130_fd_sc_hd__fill_4
XFILLER_81_785 VPWR VGND VPWR VGND sky130_ef_sc_hd__decap_40_12
XTAP_TAPCELL_ROW_0_288 VGND VPWR sky130_fd_sc_hd__tapvpwrvgnd_1
XTAP_TAPCELL_ROW_0_299 VGND VPWR sky130_fd_sc_hd__tapvpwrvgnd_1
XFILLER_13_329 VGND VGND VPWR VPWR sky130_fd_sc_hd__fill_2
X_5938_ _6316_/CLK _5938_/D VGND VGND VPWR VPWR _5938_/Q sky130_fd_sc_hd__dfxtp_1
XFILLER_25_189 VGND VGND VPWR VPWR sky130_fd_sc_hd__fill_1
XFILLER_41_627 VGND VGND VPWR VPWR sky130_fd_sc_hd__fill_1
XANTENNA__4800__C1 _3278_/A VGND VGND VPWR VPWR sky130_fd_sc_hd__diode_2
XFILLER_22_841 VGND VGND VPWR VPWR sky130_fd_sc_hd__fill_1
X_5869_ _5870_/CLK _5869_/D VGND VGND VPWR VPWR _5869_/Q sky130_fd_sc_hd__dfxtp_1
XFILLER_135_721 VGND VGND VPWR VPWR sky130_fd_sc_hd__fill_4
XANTENNA__3906__A1 _5214_/A1 VGND VGND VPWR VPWR sky130_fd_sc_hd__diode_2
XFILLER_5_517 VPWR VGND VPWR VGND sky130_ef_sc_hd__decap_40_12
XFILLER_135_765 VPWR VGND VPWR VGND sky130_ef_sc_hd__decap_40_12
XANTENNA__3536__S _3541_/S VGND VGND VPWR VPWR sky130_fd_sc_hd__diode_2
XTAP_TAPCELL_ROW_56_1137 VGND VPWR sky130_fd_sc_hd__tapvpwrvgnd_1
Xoutput34 _6460_/X VGND VGND VPWR VPWR i2c_sda_t sky130_fd_sc_hd__buf_2
XFILLER_89_841 VGND VGND VPWR VPWR sky130_fd_sc_hd__fill_1
Xoutput45 _6058_/Q VGND VGND VPWR VPWR s_axil_rdata[1] sky130_fd_sc_hd__buf_2
XFILLER_103_673 VPWR VGND VPWR VGND sky130_ef_sc_hd__decap_40_12
XFILLER_49_727 VGND VGND VPWR VPWR sky130_fd_sc_hd__fill_1
Xhold1770 _6370_/Q VGND VGND VPWR VPWR _5079_/A1 sky130_fd_sc_hd__dlygate4sd3_1
XFILLER_91_516 VPWR VGND VPWR VGND sky130_ef_sc_hd__decap_40_12
XFILLER_57_782 VGND VGND VPWR VPWR sky130_fd_sc_hd__fill_2
XFILLER_56_75 VGND VGND VPWR VPWR sky130_fd_sc_hd__fill_1
XANTENNA_input16_A s_axil_wdata[13] VGND VGND VPWR VPWR sky130_fd_sc_hd__diode_2
XFILLER_17_613 VGND VGND VPWR VPWR sky130_fd_sc_hd__fill_2
XFILLER_29_462 VGND VGND VPWR VPWR sky130_fd_sc_hd__fill_4
Xhold1792 _6230_/Q VGND VGND VPWR VPWR _4880_/A0 sky130_fd_sc_hd__dlygate4sd3_1
Xhold1781 _4852_/X VGND VGND VPWR VPWR _6204_/D sky130_fd_sc_hd__dlygate4sd3_1
XFILLER_63_229 VGND VGND VPWR VPWR sky130_fd_sc_hd__fill_1
XFILLER_44_421 VGND VGND VPWR VPWR sky130_fd_sc_hd__fill_2
XPHY_EDGE_ROW_113_Right_113 VGND VGND VPWR VPWR sky130_fd_sc_hd__decap_3
XTAP_TAPCELL_ROW_67_1299 VGND VPWR sky130_fd_sc_hd__tapvpwrvgnd_1
XFILLER_31_115 VGND VGND VPWR VPWR sky130_fd_sc_hd__fill_1
XFILLER_13_841 VGND VGND VPWR VPWR sky130_fd_sc_hd__fill_1
XANTENNA__4830__S _4841_/S VGND VGND VPWR VPWR sky130_fd_sc_hd__diode_2
XTAP_TAPCELL_ROW_80_1499 VGND VPWR sky130_fd_sc_hd__tapvpwrvgnd_1
XFILLER_75_8 VPWR VGND VPWR VGND sky130_ef_sc_hd__decap_40_12
XFILLER_40_693 VGND VGND VPWR VPWR sky130_fd_sc_hd__fill_4
XFILLER_8_377 VPWR VGND VPWR VGND sky130_ef_sc_hd__decap_40_12
XANTENNA__3446__S _3450_/S VGND VGND VPWR VPWR sky130_fd_sc_hd__diode_2
XFILLER_113_426 VGND VGND VPWR VPWR sky130_fd_sc_hd__fill_1
X_3220_ _5237_/A0 _3220_/A1 _3220_/S VGND VGND VPWR VPWR _3220_/X sky130_fd_sc_hd__mux2_1
XANTENNA__4322__A1 _5044_/A1 VGND VGND VPWR VPWR sky130_fd_sc_hd__diode_2
XFILLER_95_833 VGND VGND VPWR VPWR sky130_fd_sc_hd__fill_4
X_3151_ _5062_/A0 hold455/X _3156_/S VGND VGND VPWR VPWR _3151_/X sky130_fd_sc_hd__mux2_1
XTAP_TAPCELL_ROW_87_1609 VGND VPWR sky130_fd_sc_hd__tapvpwrvgnd_1
XANTENNA_hold2218_A _5832_/Q VGND VGND VPWR VPWR sky130_fd_sc_hd__diode_2
XFILLER_11_3 VPWR VGND VPWR VGND sky130_ef_sc_hd__decap_40_12
X_3082_ _2641_/Y _3081_/X _3080_/X VGND VGND VPWR VPWR _3082_/X sky130_fd_sc_hd__a21o_1
XFILLER_48_771 VPWR VGND VPWR VGND sky130_ef_sc_hd__decap_40_12
XFILLER_63_785 VPWR VGND VPWR VGND sky130_ef_sc_hd__decap_40_12
XFILLER_62_262 VGND VGND VPWR VPWR sky130_fd_sc_hd__fill_2
XTAP_TAPCELL_ROW_46_994 VGND VPWR sky130_fd_sc_hd__tapvpwrvgnd_1
XTAP_TAPCELL_ROW_46_983 VGND VPWR sky130_fd_sc_hd__tapvpwrvgnd_1
X_3984_ _5112_/B _3980_/Y _3982_/Y VGND VGND VPWR VPWR _3984_/Y sky130_fd_sc_hd__o21ai_1
XFILLER_22_126 VGND VGND VPWR VPWR sky130_fd_sc_hd__fill_1
XFILLER_22_137 VGND VGND VPWR VPWR sky130_fd_sc_hd__fill_1
X_2935_ _3036_/A1 _2934_/X _3027_/A VGND VGND VPWR VPWR _2935_/X sky130_fd_sc_hd__o21a_1
X_5723_ _6237_/CLK _5723_/D VGND VGND VPWR VPWR _5723_/Q sky130_fd_sc_hd__dfxtp_1
X_2866_ _2859_/X _2865_/X _3083_/S VGND VGND VPWR VPWR _2866_/X sky130_fd_sc_hd__mux2_1
X_5654_ _5714_/CLK _5654_/D VGND VGND VPWR VPWR _5654_/Q sky130_fd_sc_hd__dfxtp_1
XFILLER_136_529 VGND VGND VPWR VPWR sky130_fd_sc_hd__fill_2
XFILLER_117_721 VGND VGND VPWR VPWR sky130_fd_sc_hd__fill_4
X_4605_ hold151/X _6291_/Q _4773_/S VGND VGND VPWR VPWR _4606_/B sky130_fd_sc_hd__mux2_1
XANTENNA__4561__A1 _4906_/A0 VGND VGND VPWR VPWR sky130_fd_sc_hd__diode_2
X_2797_ _3085_/A _2797_/B VGND VGND VPWR VPWR _2797_/X sky130_fd_sc_hd__and2_1
X_5585_ _6292_/CLK _5585_/D VGND VGND VPWR VPWR _5585_/Q sky130_fd_sc_hd__dfxtp_1
Xhold300 _5045_/X VGND VGND VPWR VPWR _6340_/D sky130_fd_sc_hd__dlygate4sd3_1
Xhold311 _5933_/Q VGND VGND VPWR VPWR hold311/X sky130_fd_sc_hd__dlygate4sd3_1
XANTENNA__3364__A2 _5035_/C VGND VGND VPWR VPWR sky130_fd_sc_hd__diode_2
XFILLER_132_713 VPWR VGND VPWR VGND sky130_ef_sc_hd__decap_40_12
Xhold333 _5242_/Q VGND VGND VPWR VPWR hold333/X sky130_fd_sc_hd__dlygate4sd3_1
X_4536_ _4536_/A0 _5821_/Q _4547_/S VGND VGND VPWR VPWR _4536_/X sky130_fd_sc_hd__mux2_1
XFILLER_117_765 VPWR VGND VPWR VGND sky130_ef_sc_hd__decap_40_12
XFILLER_117_15 VPWR VGND VPWR VGND sky130_ef_sc_hd__decap_40_12
XFILLER_116_253 VGND VGND VPWR VPWR sky130_fd_sc_hd__fill_1
XANTENNA_fanout203_A _2682_/A VGND VGND VPWR VPWR sky130_fd_sc_hd__diode_2
XANTENNA__4573__A1_N _4791_/B1 VGND VGND VPWR VPWR sky130_fd_sc_hd__diode_2
Xhold322 _3923_/X VGND VGND VPWR VPWR _5900_/D sky130_fd_sc_hd__dlygate4sd3_1
Xhold344 _3390_/X VGND VGND VPWR VPWR _5449_/D sky130_fd_sc_hd__dlygate4sd3_1
X_4467_ _5811_/Q hold556/X _4472_/S VGND VGND VPWR VPWR _4467_/X sky130_fd_sc_hd__mux2_1
XFILLER_89_115 VGND VGND VPWR VPWR sky130_fd_sc_hd__fill_1
Xhold366 _3571_/X VGND VGND VPWR VPWR _5608_/D sky130_fd_sc_hd__dlygate4sd3_1
Xhold355 _6335_/Q VGND VGND VPWR VPWR hold355/X sky130_fd_sc_hd__dlygate4sd3_1
Xhold377 _5789_/Q VGND VGND VPWR VPWR hold377/X sky130_fd_sc_hd__dlygate4sd3_1
XFILLER_132_757 VPWR VGND VPWR VGND sky130_ef_sc_hd__decap_40_12
XFILLER_131_234 VGND VGND VPWR VPWR sky130_fd_sc_hd__fill_1
X_6206_ _6241_/CLK _6206_/D VGND VGND VPWR VPWR _6206_/Q sky130_fd_sc_hd__dfxtp_1
X_3418_ hold105/X _5211_/A1 _3423_/S VGND VGND VPWR VPWR _3418_/X sky130_fd_sc_hd__mux2_1
Xhold399 _5646_/Q VGND VGND VPWR VPWR hold399/X sky130_fd_sc_hd__dlygate4sd3_1
Xhold388 _3573_/X VGND VGND VPWR VPWR _5610_/D sky130_fd_sc_hd__dlygate4sd3_1
X_4398_ _5051_/A1 _4398_/A1 _4406_/S VGND VGND VPWR VPWR _4398_/X sky130_fd_sc_hd__mux2_1
XANTENNA__4313__A1 _5045_/A1 VGND VGND VPWR VPWR sky130_fd_sc_hd__diode_2
XTAP_TAPCELL_ROW_129_2237 VGND VPWR sky130_fd_sc_hd__tapvpwrvgnd_1
XFILLER_98_693 VGND VGND VPWR VPWR sky130_fd_sc_hd__fill_4
X_6137_ _6137_/CLK _6137_/D VGND VGND VPWR VPWR _6137_/Q sky130_fd_sc_hd__dfxtp_1
Xhold1000 _3550_/X VGND VGND VPWR VPWR _5591_/D sky130_fd_sc_hd__dlygate4sd3_1
XFILLER_86_811 VGND VGND VPWR VPWR sky130_fd_sc_hd__fill_1
XANTENNA_input8_A s_axil_awaddr[3] VGND VGND VPWR VPWR sky130_fd_sc_hd__diode_2
X_3349_ _6387_/Q _6385_/Q _6386_/Q _6388_/Q VGND VGND VPWR VPWR _5201_/B sky130_fd_sc_hd__and4bb_4
XFILLER_133_47 VGND VGND VPWR VPWR sky130_fd_sc_hd__fill_1
Xhold1011 _3214_/X VGND VGND VPWR VPWR _5374_/D sky130_fd_sc_hd__dlygate4sd3_1
Xhold1022 _6251_/Q VGND VGND VPWR VPWR _4903_/A1 sky130_fd_sc_hd__dlygate4sd3_1
XANTENNA__3091__S _3091_/S VGND VGND VPWR VPWR sky130_fd_sc_hd__diode_2
XANTENNA_fanout193_X _3072_/S VGND VGND VPWR VPWR sky130_fd_sc_hd__diode_2
Xhold1033 _3192_/X VGND VGND VPWR VPWR _5355_/D sky130_fd_sc_hd__dlygate4sd3_1
XFILLER_100_643 VGND VGND VPWR VPWR sky130_fd_sc_hd__fill_1
XTAP_TAPCELL_ROW_51_1067 VGND VPWR sky130_fd_sc_hd__tapvpwrvgnd_1
XTAP_TAPCELL_ROW_5_369 VGND VPWR sky130_fd_sc_hd__tapvpwrvgnd_1
XANTENNA__4588__A1_N _4811_/C1 VGND VGND VPWR VPWR sky130_fd_sc_hd__diode_2
Xhold1066 _6152_/Q VGND VGND VPWR VPWR _4552_/A0 sky130_fd_sc_hd__dlygate4sd3_1
Xhold1044 _5326_/Q VGND VGND VPWR VPWR _3967_/B sky130_fd_sc_hd__dlygate4sd3_1
X_6068_ _6068_/CLK _6068_/D VGND VGND VPWR VPWR _6068_/Q sky130_fd_sc_hd__dfxtp_1
Xhold1055 _4459_/X VGND VGND VPWR VPWR _6068_/D sky130_fd_sc_hd__dlygate4sd3_1
XFILLER_54_730 VGND VGND VPWR VPWR sky130_fd_sc_hd__fill_8
X_5019_ _5019_/A _5019_/B _5006_/Y _5018_/X VGND VGND VPWR VPWR _5029_/C sky130_fd_sc_hd__or4bb_1
Xhold1077 _4938_/X VGND VGND VPWR VPWR _6274_/D sky130_fd_sc_hd__dlygate4sd3_1
XFILLER_26_421 VPWR VGND VPWR VGND sky130_ef_sc_hd__decap_40_12
Xhold1099 _3907_/X VGND VGND VPWR VPWR _5886_/D sky130_fd_sc_hd__dlygate4sd3_1
XANTENNA_clkbuf_leaf_90_clk_A clkload1/A VGND VGND VPWR VPWR sky130_fd_sc_hd__diode_2
Xhold1088 _5701_/Q VGND VGND VPWR VPWR _3678_/A1 sky130_fd_sc_hd__dlygate4sd3_1
XFILLER_13_137 VGND VGND VPWR VPWR sky130_fd_sc_hd__fill_2
XFILLER_10_811 VGND VGND VPWR VPWR sky130_fd_sc_hd__fill_1
XTAP_TAPCELL_ROW_24_655 VGND VPWR sky130_fd_sc_hd__tapvpwrvgnd_1
XTAP_TAPCELL_ROW_24_666 VGND VPWR sky130_fd_sc_hd__tapvpwrvgnd_1
XFILLER_127_529 VPWR VGND VPWR VGND sky130_ef_sc_hd__decap_40_12
XFILLER_6_837 VGND VGND VPWR VPWR sky130_fd_sc_hd__fill_4
XANTENNA__4552__A1 _4445_/A VGND VGND VPWR VPWR sky130_fd_sc_hd__diode_2
XFILLER_5_314 VGND VGND VPWR VPWR sky130_fd_sc_hd__fill_1
XFILLER_135_573 VPWR VGND VPWR VGND sky130_ef_sc_hd__decap_40_12
XANTENNA_clkbuf_leaf_43_clk_A clkload4/A VGND VGND VPWR VPWR sky130_fd_sc_hd__diode_2
XANTENNA__4304__A1 _5047_/A1 VGND VGND VPWR VPWR sky130_fd_sc_hd__diode_2
XFILLER_3_27 VPWR VGND VPWR VGND sky130_ef_sc_hd__decap_40_12
XFILLER_1_553 VGND VGND VPWR VPWR sky130_fd_sc_hd__fill_4
XFILLER_110_407 VPWR VGND VPWR VGND sky130_ef_sc_hd__decap_40_12
XFILLER_77_833 VGND VGND VPWR VPWR sky130_fd_sc_hd__fill_4
XFILLER_49_502 VGND VGND VPWR VPWR sky130_fd_sc_hd__fill_2
XFILLER_1_597 VPWR VGND VPWR VGND sky130_ef_sc_hd__decap_40_12
XANTENNA_clkbuf_leaf_58_clk_A clkload6/A VGND VGND VPWR VPWR sky130_fd_sc_hd__diode_2
XFILLER_92_825 VPWR VGND VPWR VGND sky130_ef_sc_hd__decap_40_12
XFILLER_91_302 VGND VGND VPWR VPWR sky130_fd_sc_hd__fill_4
XFILLER_76_376 VPWR VGND VPWR VGND sky130_ef_sc_hd__decap_40_12
XFILLER_76_365 VGND VGND VPWR VPWR sky130_fd_sc_hd__fill_2
XTAP_TAPCELL_ROW_69_1328 VGND VPWR sky130_fd_sc_hd__tapvpwrvgnd_1
XFILLER_67_96 VGND VGND VPWR VPWR sky130_fd_sc_hd__fill_2
XANTENNA__4068__B1 _4272_/S VGND VGND VPWR VPWR sky130_fd_sc_hd__diode_2
XANTENNA__4825__S _4828_/S VGND VGND VPWR VPWR sky130_fd_sc_hd__diode_2
XTAP_TAPCELL_ROW_69_1339 VGND VPWR sky130_fd_sc_hd__tapvpwrvgnd_1
XANTENNA_clkbuf_leaf_101_clk_A clkload0/A VGND VGND VPWR VPWR sky130_fd_sc_hd__diode_2
XANTENNA__3291__A1 _4889_/A1 VGND VGND VPWR VPWR sky130_fd_sc_hd__diode_2
XFILLER_83_73 VGND VGND VPWR VPWR sky130_fd_sc_hd__fill_1
XTAP_TAPCELL_ROW_82_1528 VGND VPWR sky130_fd_sc_hd__tapvpwrvgnd_1
XFILLER_45_785 VPWR VGND VPWR VGND sky130_ef_sc_hd__decap_40_12
XFILLER_45_774 VGND VGND VPWR VPWR sky130_fd_sc_hd__fill_8
XFILLER_44_262 VGND VGND VPWR VPWR sky130_fd_sc_hd__fill_1
XFILLER_60_755 VGND VGND VPWR VPWR sky130_fd_sc_hd__fill_1
XTAP_TAPCELL_ROW_43_942 VGND VPWR sky130_fd_sc_hd__tapvpwrvgnd_1
XANTENNA__4126__A _4212_/A VGND VGND VPWR VPWR sky130_fd_sc_hd__diode_2
XFILLER_13_671 VGND VGND VPWR VPWR sky130_fd_sc_hd__fill_1
XANTENNA__4560__S _4561_/S VGND VGND VPWR VPWR sky130_fd_sc_hd__diode_2
XANTENNA__4791__A1 _4791_/A1 VGND VGND VPWR VPWR sky130_fd_sc_hd__diode_2
X_2720_ _2721_/A _2721_/B VGND VGND VPWR VPWR _3011_/A sky130_fd_sc_hd__and2_2
XFILLER_9_653 VPWR VGND VPWR VGND sky130_ef_sc_hd__decap_40_12
XFILLER_118_529 VGND VGND VPWR VPWR sky130_fd_sc_hd__fill_2
X_2651_ _2651_/A VGND VGND VPWR VPWR _2651_/Y sky130_fd_sc_hd__inv_2
XTAP_TAPCELL_ROW_97_1760 VGND VPWR sky130_fd_sc_hd__tapvpwrvgnd_1
XFILLER_9_697 VPWR VGND VPWR VGND sky130_ef_sc_hd__decap_40_12
X_5370_ _6148_/CLK _5370_/D VGND VGND VPWR VPWR _5370_/Q sky130_fd_sc_hd__dfxtp_1
XANTENNA__4543__A1 _5233_/A0 VGND VGND VPWR VPWR sky130_fd_sc_hd__diode_2
XFILLER_114_713 VPWR VGND VPWR VGND sky130_ef_sc_hd__decap_40_12
X_4321_ hold570/X _4980_/A1 _4325_/S VGND VGND VPWR VPWR _4321_/X sky130_fd_sc_hd__mux2_1
XFILLER_114_757 VPWR VGND VPWR VGND sky130_ef_sc_hd__decap_40_12
XFILLER_87_619 VGND VGND VPWR VPWR sky130_fd_sc_hd__fill_1
Xfanout109 hold2226/X VGND VGND VPWR VPWR _5052_/A1 sky130_fd_sc_hd__buf_4
X_4252_ _4252_/A1 _4249_/X _4252_/B1 VGND VGND VPWR VPWR _4252_/X sky130_fd_sc_hd__o21a_1
X_3203_ hold284/X _5234_/A0 _3206_/S VGND VGND VPWR VPWR _5365_/D sky130_fd_sc_hd__mux2_1
XFILLER_95_641 VPWR VGND VPWR VGND sky130_ef_sc_hd__decap_40_12
XFILLER_79_181 VGND VGND VPWR VPWR sky130_fd_sc_hd__fill_2
X_4183_ _4241_/A _4183_/B VGND VGND VPWR VPWR _4183_/X sky130_fd_sc_hd__or2_1
XFILLER_95_685 VPWR VGND VPWR VGND sky130_ef_sc_hd__decap_40_12
XTAP_TAPCELL_ROW_2_328 VGND VPWR sky130_fd_sc_hd__tapvpwrvgnd_1
X_3134_ _4924_/C _5050_/B _5085_/A VGND VGND VPWR VPWR _3135_/B sky130_fd_sc_hd__a21o_1
X_3065_ _3034_/A _3062_/X _3096_/A1 VGND VGND VPWR VPWR _3065_/Y sky130_fd_sc_hd__o21ai_1
XFILLER_94_195 VGND VGND VPWR VPWR sky130_fd_sc_hd__fill_1
XTAP_TAPCELL_ROW_124_2167 VGND VPWR sky130_fd_sc_hd__tapvpwrvgnd_1
XTAP_TAPCELL_ROW_124_2156 VGND VPWR sky130_fd_sc_hd__tapvpwrvgnd_1
XFILLER_36_774 VPWR VGND VPWR VGND sky130_ef_sc_hd__decap_40_12
XANTENNA_fanout153_A _4713_/S VGND VGND VPWR VPWR sky130_fd_sc_hd__diode_2
X_3967_ _5329_/Q _3967_/B _5265_/Q _5428_/Q VGND VGND VPWR VPWR _3967_/X sky130_fd_sc_hd__and4b_1
X_2918_ _3050_/A _2918_/B VGND VGND VPWR VPWR _2918_/X sky130_fd_sc_hd__or2_1
XANTENNA__4470__S _4472_/S VGND VGND VPWR VPWR sky130_fd_sc_hd__diode_2
XTAP_TAPCELL_ROW_21_614 VGND VPWR sky130_fd_sc_hd__tapvpwrvgnd_1
X_5706_ _6122_/CLK _5706_/D VGND VGND VPWR VPWR _5706_/Q sky130_fd_sc_hd__dfxtp_1
Xclkbuf_leaf_30_clk clkload3/A VGND VGND VPWR VPWR _5753_/CLK sky130_fd_sc_hd__clkbuf_8
X_3898_ _3898_/A0 _5215_/A1 _3899_/S VGND VGND VPWR VPWR _3898_/X sky130_fd_sc_hd__mux2_1
X_2849_ _5348_/Q _5576_/Q _3086_/S VGND VGND VPWR VPWR _2849_/X sky130_fd_sc_hd__mux2_1
XANTENNA__3086__S _3086_/S VGND VGND VPWR VPWR sky130_fd_sc_hd__diode_2
X_5637_ _6294_/CLK _5637_/D VGND VGND VPWR VPWR _5637_/Q sky130_fd_sc_hd__dfxtp_1
XFILLER_128_58 VGND VGND VPWR VPWR sky130_fd_sc_hd__fill_2
XANTENNA_fanout206_X _5222_/A VGND VGND VPWR VPWR sky130_fd_sc_hd__diode_2
X_5568_ _6222_/CLK _5568_/D VGND VGND VPWR VPWR _5568_/Q sky130_fd_sc_hd__dfxtp_1
XANTENNA__4534__A1 _5080_/A0 VGND VGND VPWR VPWR sky130_fd_sc_hd__diode_2
Xhold130 _3106_/X VGND VGND VPWR VPWR _5301_/D sky130_fd_sc_hd__dlygate4sd3_1
XFILLER_117_573 VPWR VGND VPWR VGND sky130_ef_sc_hd__decap_40_12
XFILLER_88_29 VPWR VGND VPWR VGND sky130_ef_sc_hd__decap_40_12
Xhold152 _3577_/X VGND VGND VPWR VPWR _5613_/D sky130_fd_sc_hd__dlygate4sd3_1
XFILLER_2_317 VPWR VGND VPWR VGND sky130_ef_sc_hd__decap_40_12
Xhold141 _6121_/Q VGND VGND VPWR VPWR hold141/X sky130_fd_sc_hd__dlygate4sd3_1
X_4519_ hold481/X _5213_/A1 _4522_/S VGND VGND VPWR VPWR _4519_/X sky130_fd_sc_hd__mux2_1
Xhold163 _5506_/Q VGND VGND VPWR VPWR hold163/X sky130_fd_sc_hd__dlygate4sd3_1
XFILLER_104_245 VGND VGND VPWR VPWR sky130_fd_sc_hd__fill_1
X_5499_ _6146_/CLK _5499_/D VGND VGND VPWR VPWR _5499_/Q sky130_fd_sc_hd__dfxtp_1
Xhold174 _3760_/X VGND VGND VPWR VPWR _5771_/D sky130_fd_sc_hd__dlygate4sd3_1
Xhold185 _6269_/Q VGND VGND VPWR VPWR hold185/X sky130_fd_sc_hd__dlygate4sd3_1
XFILLER_132_587 VGND VGND VPWR VPWR sky130_fd_sc_hd__fill_1
Xhold196 _4359_/X VGND VGND VPWR VPWR _6001_/D sky130_fd_sc_hd__dlygate4sd3_1
XFILLER_120_749 VGND VGND VPWR VPWR sky130_fd_sc_hd__fill_4
XFILLER_59_833 VGND VGND VPWR VPWR sky130_fd_sc_hd__fill_4
Xclkbuf_leaf_97_clk clkload0/A VGND VGND VPWR VPWR clkload9/A sky130_fd_sc_hd__clkbuf_8
XANTENNA_fanout66_A _2641_/Y VGND VGND VPWR VPWR sky130_fd_sc_hd__diode_2
XTAP_TAPCELL_ROW_109_1929 VGND VPWR sky130_fd_sc_hd__tapvpwrvgnd_1
XFILLER_85_140 VGND VGND VPWR VPWR sky130_fd_sc_hd__fill_2
XFILLER_74_825 VPWR VGND VPWR VGND sky130_ef_sc_hd__decap_40_12
XFILLER_58_365 VPWR VGND VPWR VGND sky130_ef_sc_hd__decap_40_12
XFILLER_37_11 VGND VGND VPWR VPWR sky130_fd_sc_hd__fill_2
XFILLER_73_324 VPWR VGND VPWR VGND sky130_ef_sc_hd__decap_40_12
XTAP_TAPCELL_ROW_29_736 VGND VPWR sky130_fd_sc_hd__tapvpwrvgnd_1
XFILLER_37_55 VGND VGND VPWR VPWR sky130_fd_sc_hd__fill_1
XANTENNA__4470__A0 _5235_/A0 VGND VGND VPWR VPWR sky130_fd_sc_hd__diode_2
XFILLER_14_413 VGND VGND VPWR VPWR sky130_fd_sc_hd__fill_4
XFILLER_27_774 VGND VGND VPWR VPWR sky130_fd_sc_hd__fill_8
XFILLER_27_785 VPWR VGND VPWR VGND sky130_ef_sc_hd__decap_40_12
XTAP_TAPCELL_ROW_64_1258 VGND VPWR sky130_fd_sc_hd__tapvpwrvgnd_1
XFILLER_53_54 VGND VGND VPWR VPWR sky130_fd_sc_hd__fill_2
XFILLER_42_755 VGND VGND VPWR VPWR sky130_fd_sc_hd__fill_1
XFILLER_42_777 VPWR VGND VPWR VGND sky130_ef_sc_hd__decap_40_12
XFILLER_14_457 VPWR VGND VPWR VGND sky130_ef_sc_hd__decap_40_12
XTAP_TAPCELL_ROW_40_901 VGND VPWR sky130_fd_sc_hd__tapvpwrvgnd_1
XFILLER_41_254 VGND VGND VPWR VPWR sky130_fd_sc_hd__fill_2
XFILLER_128_805 VGND VGND VPWR VPWR sky130_fd_sc_hd__fill_4
Xclkbuf_leaf_21_clk clkload3/A VGND VGND VPWR VPWR _6196_/CLK sky130_fd_sc_hd__clkbuf_8
XFILLER_10_641 VGND VGND VPWR VPWR sky130_fd_sc_hd__fill_2
XFILLER_6_601 VPWR VGND VPWR VGND sky130_ef_sc_hd__decap_40_12
XFILLER_127_337 VGND VGND VPWR VPWR sky130_fd_sc_hd__fill_2
XFILLER_6_645 VPWR VGND VPWR VGND sky130_ef_sc_hd__decap_40_12
XANTENNA__4525__A1 _4883_/A1 VGND VGND VPWR VPWR sky130_fd_sc_hd__diode_2
XTAP_TAPCELL_ROW_79_1490 VGND VPWR sky130_fd_sc_hd__tapvpwrvgnd_1
XFILLER_5_188 VGND VGND VPWR VPWR sky130_fd_sc_hd__fill_4
XFILLER_111_727 VGND VGND VPWR VPWR sky130_fd_sc_hd__fill_1
XFILLER_68_107 VGND VGND VPWR VPWR sky130_fd_sc_hd__fill_1
XFILLER_78_95 VGND VGND VPWR VPWR sky130_fd_sc_hd__fill_1
XFILLER_49_321 VGND VGND VPWR VPWR sky130_fd_sc_hd__fill_1
Xclkbuf_leaf_88_clk clkload1/A VGND VGND VPWR VPWR _6121_/CLK sky130_fd_sc_hd__clkbuf_8
XFILLER_65_825 VGND VGND VPWR VPWR sky130_fd_sc_hd__fill_2
XANTENNA__4555__S _4561_/S VGND VGND VPWR VPWR sky130_fd_sc_hd__diode_2
XFILLER_49_376 VGND VGND VPWR VPWR sky130_fd_sc_hd__fill_1
XFILLER_76_195 VGND VGND VPWR VPWR sky130_fd_sc_hd__fill_1
XANTENNA__4461__A0 _5238_/A1 VGND VGND VPWR VPWR sky130_fd_sc_hd__diode_2
XFILLER_92_699 VGND VGND VPWR VPWR sky130_fd_sc_hd__fill_1
X_4870_ _4870_/A0 _4883_/A1 _4880_/S VGND VGND VPWR VPWR _4870_/X sky130_fd_sc_hd__mux2_1
X_3821_ _4912_/A _4908_/A _3821_/C VGND VGND VPWR VPWR _3821_/X sky130_fd_sc_hd__or3_1
XFILLER_33_777 VGND VGND VPWR VPWR sky130_fd_sc_hd__fill_4
XANTENNA__2803__S _3091_/S VGND VGND VPWR VPWR sky130_fd_sc_hd__diode_2
XANTENNA__4290__S _4294_/S VGND VGND VPWR VPWR sky130_fd_sc_hd__diode_2
Xclkbuf_leaf_12_clk clkbuf_leaf_9_clk/A VGND VGND VPWR VPWR _6347_/CLK sky130_fd_sc_hd__clkbuf_8
XFILLER_9_461 VPWR VGND VPWR VGND sky130_ef_sc_hd__decap_40_12
X_3752_ _4981_/A1 _3752_/A1 _3755_/S VGND VGND VPWR VPWR _3752_/X sky130_fd_sc_hd__mux2_1
XANTENNA__4764__B2 _4811_/C1 VGND VGND VPWR VPWR sky130_fd_sc_hd__diode_2
XFILLER_118_337 VGND VGND VPWR VPWR sky130_fd_sc_hd__fill_1
XTAP_TAPCELL_ROW_95_1719 VGND VPWR sky130_fd_sc_hd__tapvpwrvgnd_1
X_3683_ _4517_/A1 _3683_/A1 _3688_/S VGND VGND VPWR VPWR _5705_/D sky130_fd_sc_hd__mux2_1
X_2703_ _2703_/A _2703_/B VGND VGND VPWR VPWR _3160_/D sky130_fd_sc_hd__xor2_1
XFILLER_118_359 VGND VGND VPWR VPWR sky130_fd_sc_hd__fill_4
X_5422_ _6399_/CLK _5422_/D VGND VGND VPWR VPWR _5422_/Q sky130_fd_sc_hd__dfxtp_1
X_2634_ _5343_/Q VGND VGND VPWR VPWR _2634_/Y sky130_fd_sc_hd__inv_2
XANTENNA__4516__A1 _5210_/A1 VGND VGND VPWR VPWR sky130_fd_sc_hd__diode_2
XFILLER_126_381 VGND VGND VPWR VPWR sky130_fd_sc_hd__fill_1
XFILLER_114_521 VGND VGND VPWR VPWR sky130_fd_sc_hd__fill_8
X_5353_ _5820_/CLK _5353_/D VGND VGND VPWR VPWR _5353_/Q sky130_fd_sc_hd__dfxtp_1
X_4304_ hold171/X _5047_/A1 _4304_/S VGND VGND VPWR VPWR _4304_/X sky130_fd_sc_hd__mux2_1
XTAP_TAPCELL_ROW_7_409 VGND VPWR sky130_fd_sc_hd__tapvpwrvgnd_1
XFILLER_114_587 VGND VGND VPWR VPWR sky130_fd_sc_hd__fill_1
X_5284_ _6394_/CLK hold3/X VGND VGND VPWR VPWR hold2/A sky130_fd_sc_hd__dfxtp_1
XFILLER_102_749 VGND VGND VPWR VPWR sky130_fd_sc_hd__fill_4
XFILLER_87_449 VGND VGND VPWR VPWR sky130_fd_sc_hd__fill_1
XANTENNA_clkbuf_3_3__f_clk_X clkload2/A VGND VGND VPWR VPWR sky130_fd_sc_hd__diode_2
Xclkbuf_leaf_79_clk clkload2/A VGND VGND VPWR VPWR _5850_/CLK sky130_fd_sc_hd__clkbuf_8
XFILLER_4_81 VGND VGND VPWR VPWR sky130_fd_sc_hd__fill_2
X_4235_ _5785_/Q _5913_/Q _4237_/S VGND VGND VPWR VPWR _4236_/B sky130_fd_sc_hd__mux2_1
XFILLER_114_27 VGND VGND VPWR VPWR sky130_fd_sc_hd__fill_1
X_4166_ _6005_/Q _5996_/Q _4213_/S VGND VGND VPWR VPWR _4166_/X sky130_fd_sc_hd__mux2_1
XANTENNA__4465__S _4472_/S VGND VGND VPWR VPWR sky130_fd_sc_hd__diode_2
X_3117_ hold327/X _5228_/A0 _3126_/S VGND VGND VPWR VPWR _3117_/X sky130_fd_sc_hd__mux2_1
XFILLER_110_793 VPWR VGND VPWR VGND sky130_ef_sc_hd__decap_40_12
XFILLER_68_685 VGND VGND VPWR VPWR sky130_fd_sc_hd__fill_2
XFILLER_67_173 VGND VGND VPWR VPWR sky130_fd_sc_hd__fill_2
XFILLER_56_825 VPWR VGND VPWR VGND sky130_ef_sc_hd__decap_40_12
XFILLER_82_143 VGND VGND VPWR VPWR sky130_fd_sc_hd__fill_4
X_4097_ _4178_/A _4097_/B VGND VGND VPWR VPWR _4097_/X sky130_fd_sc_hd__or2_1
XFILLER_130_15 VPWR VGND VPWR VGND sky130_ef_sc_hd__decap_40_12
X_3048_ _5547_/Q _5571_/Q _5523_/Q _5535_/Q _3077_/S _3050_/A VGND VGND VPWR VPWR
+ _3048_/X sky130_fd_sc_hd__mux4_1
XANTENNA__4452__B1 _4445_/B VGND VGND VPWR VPWR sky130_fd_sc_hd__diode_2
XTAP_TAPCELL_ROW_104_1859 VGND VPWR sky130_fd_sc_hd__tapvpwrvgnd_1
XFILLER_24_755 VGND VGND VPWR VPWR sky130_fd_sc_hd__fill_1
XANTENNA_fanout156_X _4260_/S VGND VGND VPWR VPWR sky130_fd_sc_hd__diode_2
XANTENNA__3007__A1 _3036_/A1 VGND VGND VPWR VPWR sky130_fd_sc_hd__diode_2
XFILLER_11_405 VPWR VGND VPWR VGND sky130_ef_sc_hd__decap_40_12
X_4999_ _4999_/A0 _4997_/X _5000_/A VGND VGND VPWR VPWR _4999_/X sky130_fd_sc_hd__mux2_1
XANTENNA__4755__A1 _4663_/A VGND VGND VPWR VPWR sky130_fd_sc_hd__diode_2
XFILLER_23_35 VGND VGND VPWR VPWR sky130_fd_sc_hd__fill_2
XANTENNA__2713__S _2716_/S VGND VGND VPWR VPWR sky130_fd_sc_hd__diode_2
XTAP_TAPCELL_ROW_137_2358 VGND VPWR sky130_fd_sc_hd__tapvpwrvgnd_1
XFILLER_137_613 VGND VGND VPWR VPWR sky130_fd_sc_hd__fill_2
XFILLER_109_304 VGND VGND VPWR VPWR sky130_fd_sc_hd__fill_2
XFILLER_11_449 VPWR VGND VPWR VGND sky130_ef_sc_hd__decap_40_12
XFILLER_23_57 VGND VGND VPWR VPWR sky130_fd_sc_hd__fill_8
XANTENNA__4507__A1 _4517_/A1 VGND VGND VPWR VPWR sky130_fd_sc_hd__diode_2
XFILLER_3_615 VGND VGND VPWR VPWR sky130_fd_sc_hd__fill_1
XFILLER_133_841 VGND VGND VPWR VPWR sky130_fd_sc_hd__fill_1
XFILLER_105_543 VPWR VGND VPWR VGND sky130_ef_sc_hd__decap_40_12
XFILLER_120_502 VPWR VGND VPWR VGND sky130_ef_sc_hd__decap_40_12
XANTENNA__2668__B _4881_/A VGND VGND VPWR VPWR sky130_fd_sc_hd__diode_2
XFILLER_120_557 VPWR VGND VPWR VGND sky130_ef_sc_hd__decap_40_12
XFILLER_19_505 VPWR VGND VPWR VGND sky130_ef_sc_hd__decap_40_12
XFILLER_58_173 VGND VGND VPWR VPWR sky130_fd_sc_hd__fill_1
XANTENNA__4118__S0 _4228_/S VGND VGND VPWR VPWR sky130_fd_sc_hd__diode_2
XANTENNA_fanout69_X _4264_/A1 VGND VGND VPWR VPWR sky130_fd_sc_hd__diode_2
XFILLER_46_357 VGND VGND VPWR VPWR sky130_fd_sc_hd__fill_2
XFILLER_104_82 VGND VGND VPWR VPWR sky130_fd_sc_hd__fill_2
XANTENNA__4443__B1 _4427_/B VGND VGND VPWR VPWR sky130_fd_sc_hd__diode_2
XANTENNA__3246__B2 _3237_/A VGND VGND VPWR VPWR sky130_fd_sc_hd__diode_2
XFILLER_46_368 VPWR VGND VPWR VGND sky130_ef_sc_hd__decap_40_12
XFILLER_9_15 VPWR VGND VPWR VGND sky130_ef_sc_hd__decap_40_12
XFILLER_15_777 VGND VGND VPWR VPWR sky130_fd_sc_hd__fill_4
XFILLER_30_703 VGND VGND VPWR VPWR sky130_fd_sc_hd__fill_1
XFILLER_80_41 VPWR VGND VPWR VGND sky130_ef_sc_hd__decap_40_12
XFILLER_14_287 VGND VGND VPWR VPWR sky130_fd_sc_hd__fill_1
XFILLER_128_613 VPWR VGND VPWR VGND sky130_ef_sc_hd__decap_40_12
Xfanout91 hold2147/X VGND VGND VPWR VPWR _5208_/A1 sky130_fd_sc_hd__buf_4
XFILLER_30_769 VPWR VGND VPWR VGND sky130_ef_sc_hd__decap_40_12
Xfanout80 _4961_/A0 VGND VGND VPWR VPWR _5213_/A1 sky130_fd_sc_hd__clkbuf_4
XTAP_TAPCELL_ROW_12_477 VGND VPWR sky130_fd_sc_hd__tapvpwrvgnd_1
XFILLER_128_657 VPWR VGND VPWR VGND sky130_ef_sc_hd__decap_40_12
XTAP_TAPCELL_ROW_77_1449 VGND VPWR sky130_fd_sc_hd__tapvpwrvgnd_1
XFILLER_6_475 VGND VGND VPWR VPWR sky130_fd_sc_hd__fill_1
XANTENNA__3454__S _3463_/S VGND VGND VPWR VPWR sky130_fd_sc_hd__diode_2
XFILLER_124_841 VGND VGND VPWR VPWR sky130_fd_sc_hd__fill_1
XFILLER_111_502 VGND VGND VPWR VPWR sky130_fd_sc_hd__fill_2
XFILLER_97_725 VGND VGND VPWR VPWR sky130_fd_sc_hd__fill_2
XTAP_TAPCELL_ROW_90_1649 VGND VPWR sky130_fd_sc_hd__tapvpwrvgnd_1
XFILLER_2_681 VPWR VGND VPWR VGND sky130_ef_sc_hd__decap_40_12
XFILLER_111_557 VGND VGND VPWR VPWR sky130_fd_sc_hd__fill_2
X_4020_ _5256_/Q _6045_/Q _4270_/S VGND VGND VPWR VPWR _4021_/B sky130_fd_sc_hd__mux2_1
Xclkbuf_leaf_1_clk clkload0/A VGND VGND VPWR VPWR clkload8/A sky130_fd_sc_hd__clkbuf_8
XANTENNA__4131__C1 _5343_/Q VGND VGND VPWR VPWR sky130_fd_sc_hd__diode_2
XANTENNA__3485__A1 _4901_/A0 VGND VGND VPWR VPWR sky130_fd_sc_hd__diode_2
XFILLER_77_482 VGND VGND VPWR VPWR sky130_fd_sc_hd__fill_1
XFILLER_38_825 VPWR VGND VPWR VGND sky130_ef_sc_hd__decap_40_12
XTAP_TAPCELL_ROW_121_2115 VGND VPWR sky130_fd_sc_hd__tapvpwrvgnd_1
XANTENNA__4434__B1 _3801_/B VGND VGND VPWR VPWR sky130_fd_sc_hd__diode_2
XFILLER_53_839 VGND VGND VPWR VPWR sky130_fd_sc_hd__fill_1
X_5971_ _5990_/CLK _5971_/D VGND VGND VPWR VPWR _5971_/Q sky130_fd_sc_hd__dfxtp_1
XFILLER_64_187 VGND VGND VPWR VPWR sky130_fd_sc_hd__fill_1
X_4922_ _4922_/A _4922_/B _4922_/C VGND VGND VPWR VPWR _4922_/X sky130_fd_sc_hd__or3_1
XANTENNA__4985__A1 _5051_/A1 VGND VGND VPWR VPWR sky130_fd_sc_hd__diode_2
XFILLER_33_563 VGND VGND VPWR VPWR sky130_fd_sc_hd__fill_1
X_4853_ _4905_/A0 _4853_/A1 _4854_/S VGND VGND VPWR VPWR _4853_/X sky130_fd_sc_hd__mux2_1
XFILLER_100_29 VGND VGND VPWR VPWR sky130_fd_sc_hd__fill_4
XFILLER_21_725 VGND VGND VPWR VPWR sky130_fd_sc_hd__fill_2
XFILLER_33_596 VGND VGND VPWR VPWR sky130_fd_sc_hd__fill_1
XFILLER_119_613 VGND VGND VPWR VPWR sky130_fd_sc_hd__fill_2
X_3804_ input12/X _5075_/A0 _3810_/S VGND VGND VPWR VPWR _5810_/D sky130_fd_sc_hd__mux2_1
X_4784_ _4783_/X _4777_/X _4799_/A VGND VGND VPWR VPWR _4784_/X sky130_fd_sc_hd__mux2_1
X_3735_ hold405/X _4883_/A1 _3745_/S VGND VGND VPWR VPWR _3735_/X sky130_fd_sc_hd__mux2_1
XTAP_TAPCELL_ROW_31_764 VGND VPWR sky130_fd_sc_hd__tapvpwrvgnd_1
XTAP_TAPCELL_ROW_119_2088 VGND VPWR sky130_fd_sc_hd__tapvpwrvgnd_1
XFILLER_109_27 VPWR VGND VPWR VGND sky130_ef_sc_hd__decap_40_12
X_5405_ _6248_/CLK _5405_/D VGND VGND VPWR VPWR _5405_/Q sky130_fd_sc_hd__dfxtp_1
XFILLER_106_307 VGND VGND VPWR VPWR sky130_fd_sc_hd__fill_1
Xclkload61 _6172_/CLK VGND VGND VPWR VPWR clkload61/Y sky130_fd_sc_hd__clkinv_2
X_3666_ _4521_/A1 _3666_/A1 _3667_/S VGND VGND VPWR VPWR _5691_/D sky130_fd_sc_hd__mux2_1
Xclkload50 _6114_/CLK VGND VGND VPWR VPWR clkload50/X sky130_fd_sc_hd__clkbuf_4
Xclkload83 _6432_/CLK VGND VGND VPWR VPWR clkload83/Y sky130_fd_sc_hd__clkinv_2
XTAP_TAPCELL_ROW_132_2277 VGND VPWR sky130_fd_sc_hd__tapvpwrvgnd_1
XFILLER_115_841 VGND VGND VPWR VPWR sky130_fd_sc_hd__fill_1
Xclkload72 _5753_/CLK VGND VGND VPWR VPWR clkload72/Y sky130_fd_sc_hd__clkinvlp_4
Xclkload94 _6095_/CLK VGND VGND VPWR VPWR clkload94/Y sky130_fd_sc_hd__clkinv_2
X_3597_ _4562_/A2 _5208_/A1 _3605_/S VGND VGND VPWR VPWR _3597_/X sky130_fd_sc_hd__mux2_1
X_6385_ _6388_/CLK _6385_/D VGND VGND VPWR VPWR _6385_/Q sky130_fd_sc_hd__dfxtp_2
XANTENNA__4596__S0 _4810_/S VGND VGND VPWR VPWR sky130_fd_sc_hd__diode_2
XANTENNA__3173__B1 _5200_/A VGND VGND VPWR VPWR sky130_fd_sc_hd__diode_2
XFILLER_130_811 VGND VGND VPWR VPWR sky130_fd_sc_hd__fill_1
XFILLER_125_15 VPWR VGND VPWR VGND sky130_ef_sc_hd__decap_40_12
X_5336_ _6172_/CLK _5336_/D VGND VGND VPWR VPWR _5336_/Q sky130_fd_sc_hd__dfxtp_1
XFILLER_0_629 VPWR VGND VPWR VGND sky130_ef_sc_hd__decap_40_12
XANTENNA__2920__B1 _3094_/C1 VGND VGND VPWR VPWR sky130_fd_sc_hd__diode_2
XFILLER_88_769 VPWR VGND VPWR VGND sky130_ef_sc_hd__decap_40_12
X_5267_ _6398_/CLK _5267_/D VGND VGND VPWR VPWR _5267_/Q sky130_fd_sc_hd__dfxtp_1
XFILLER_102_557 VPWR VGND VPWR VGND sky130_ef_sc_hd__decap_40_12
XFILLER_85_19 VPWR VGND VPWR VGND sky130_ef_sc_hd__decap_40_12
X_4218_ _4218_/A _4218_/B VGND VGND VPWR VPWR _4218_/Y sky130_fd_sc_hd__nor2_1
X_5198_ _3954_/X _4007_/A _5198_/B1 VGND VGND VPWR VPWR _5198_/X sky130_fd_sc_hd__o21a_1
XANTENNA__2708__S _2716_/S VGND VGND VPWR VPWR sky130_fd_sc_hd__diode_2
XFILLER_55_110 VGND VGND VPWR VPWR sky130_fd_sc_hd__fill_2
X_4149_ _4149_/A _4149_/B VGND VGND VPWR VPWR _4149_/X sky130_fd_sc_hd__and2_1
XFILLER_18_46 VGND VGND VPWR VPWR sky130_fd_sc_hd__fill_8
XANTENNA__4425__B1 _4420_/X VGND VGND VPWR VPWR sky130_fd_sc_hd__diode_2
XFILLER_56_699 VGND VGND VPWR VPWR sky130_fd_sc_hd__fill_1
XTAP_TAPCELL_ROW_48_1017 VGND VPWR sky130_fd_sc_hd__tapvpwrvgnd_1
XFILLER_43_305 VGND VGND VPWR VPWR sky130_fd_sc_hd__fill_4
XTAP_TAPCELL_ROW_39_886 VGND VPWR sky130_fd_sc_hd__tapvpwrvgnd_1
XFILLER_70_113 VGND VGND VPWR VPWR sky130_fd_sc_hd__fill_2
XANTENNA__4976__A1 _4976_/A1 VGND VGND VPWR VPWR sky130_fd_sc_hd__diode_2
XANTENNA__2987__B1 _3075_/C1 VGND VGND VPWR VPWR sky130_fd_sc_hd__diode_2
XANTENNA__3539__S _3541_/S VGND VGND VPWR VPWR sky130_fd_sc_hd__diode_2
XTAP_TAPCELL_ROW_61_1217 VGND VPWR sky130_fd_sc_hd__tapvpwrvgnd_1
XFILLER_12_725 VPWR VGND VPWR VGND sky130_ef_sc_hd__decap_40_12
XANTENNA__4728__A1 _4727_/X VGND VGND VPWR VPWR sky130_fd_sc_hd__diode_2
XFILLER_51_393 VGND VGND VPWR VPWR sky130_fd_sc_hd__fill_4
XFILLER_12_769 VPWR VGND VPWR VGND sky130_ef_sc_hd__decap_40_12
XFILLER_126_3 VPWR VGND VPWR VGND sky130_ef_sc_hd__decap_40_12
XFILLER_50_33 VGND VGND VPWR VPWR sky130_fd_sc_hd__fill_1
XANTENNA__3400__A1 _4983_/A1 VGND VGND VPWR VPWR sky130_fd_sc_hd__diode_2
Xclkload0 clkload0/A VGND VGND VPWR VPWR clkload0/X sky130_fd_sc_hd__clkbuf_8
XFILLER_50_66 VGND VGND VPWR VPWR sky130_fd_sc_hd__fill_2
XFILLER_109_178 VGND VGND VPWR VPWR sky130_fd_sc_hd__fill_8
XFILLER_106_841 VGND VGND VPWR VPWR sky130_fd_sc_hd__fill_1
XTAP_TAPCELL_ROW_59_1179 VGND VPWR sky130_fd_sc_hd__tapvpwrvgnd_1
XFILLER_133_671 VGND VGND VPWR VPWR sky130_fd_sc_hd__fill_1
XFILLER_79_725 VGND VGND VPWR VPWR sky130_fd_sc_hd__fill_2
XANTENNA__3164__B1 _5085_/A VGND VGND VPWR VPWR sky130_fd_sc_hd__diode_2
XFILLER_121_833 VGND VGND VPWR VPWR sky130_fd_sc_hd__fill_4
XFILLER_78_213 VGND VGND VPWR VPWR sky130_fd_sc_hd__fill_2
XFILLER_120_365 VGND VGND VPWR VPWR sky130_fd_sc_hd__fill_2
XFILLER_120_332 VGND VGND VPWR VPWR sky130_fd_sc_hd__fill_1
XFILLER_79_769 VPWR VGND VPWR VGND sky130_ef_sc_hd__decap_40_12
XTAP_TAPCELL_ROW_72_1379 VGND VPWR sky130_fd_sc_hd__tapvpwrvgnd_1
XFILLER_78_279 VGND VGND VPWR VPWR sky130_fd_sc_hd__fill_1
XFILLER_59_482 VGND VGND VPWR VPWR sky130_fd_sc_hd__fill_1
XFILLER_75_52 VGND VGND VPWR VPWR sky130_fd_sc_hd__fill_4
XFILLER_75_74 VGND VGND VPWR VPWR sky130_fd_sc_hd__fill_8
XANTENNA__4416__A0 _5047_/A1 VGND VGND VPWR VPWR sky130_fd_sc_hd__diode_2
XFILLER_34_305 VGND VGND VPWR VPWR sky130_fd_sc_hd__fill_2
XFILLER_35_839 VGND VGND VPWR VPWR sky130_fd_sc_hd__fill_1
XANTENNA__4833__S _4841_/S VGND VGND VPWR VPWR sky130_fd_sc_hd__diode_2
XFILLER_74_496 VGND VGND VPWR VPWR sky130_fd_sc_hd__fill_1
XFILLER_62_647 VGND VGND VPWR VPWR sky130_fd_sc_hd__fill_1
XFILLER_50_809 VGND VGND VPWR VPWR sky130_fd_sc_hd__fill_2
XFILLER_15_541 VPWR VGND VPWR VGND sky130_ef_sc_hd__decap_40_12
XTAP_TAPCELL_ROW_17_558 VGND VPWR sky130_fd_sc_hd__tapvpwrvgnd_1
XANTENNA__3449__S _3450_/S VGND VGND VPWR VPWR sky130_fd_sc_hd__diode_2
XFILLER_91_84 VGND VGND VPWR VPWR sky130_fd_sc_hd__fill_1
XFILLER_42_382 VGND VGND VPWR VPWR sky130_fd_sc_hd__fill_1
XFILLER_15_585 VPWR VGND VPWR VGND sky130_ef_sc_hd__decap_40_12
XANTENNA__4719__A1 _4811_/A1 VGND VGND VPWR VPWR sky130_fd_sc_hd__diode_2
XFILLER_30_555 VGND VGND VPWR VPWR sky130_fd_sc_hd__fill_2
XFILLER_30_566 VGND VGND VPWR VPWR sky130_fd_sc_hd__fill_2
X_3520_ _4445_/A _3520_/A1 _3529_/S VGND VGND VPWR VPWR _3520_/X sky130_fd_sc_hd__mux2_1
XFILLER_128_443 VGND VGND VPWR VPWR sky130_fd_sc_hd__fill_1
XANTENNA__2825__S0 _2963_/S VGND VGND VPWR VPWR sky130_fd_sc_hd__diode_2
XFILLER_115_115 VGND VGND VPWR VPWR sky130_fd_sc_hd__fill_2
Xhold718 _6232_/Q VGND VGND VPWR VPWR hold718/X sky130_fd_sc_hd__dlygate4sd3_1
Xhold707 _3926_/X VGND VGND VPWR VPWR _5903_/D sky130_fd_sc_hd__dlygate4sd3_1
X_3451_ _4894_/A _4868_/A VGND VGND VPWR VPWR _3463_/S sky130_fd_sc_hd__nor2_8
Xhold729 _4342_/X VGND VGND VPWR VPWR _5987_/D sky130_fd_sc_hd__dlygate4sd3_1
XFILLER_112_811 VGND VGND VPWR VPWR sky130_fd_sc_hd__fill_1
X_6170_ _6290_/CLK _6170_/D VGND VGND VPWR VPWR _6170_/Q sky130_fd_sc_hd__dfxtp_1
XANTENNA_hold2248_A _4492_/S VGND VGND VPWR VPWR sky130_fd_sc_hd__diode_2
X_3382_ _3382_/A0 _4976_/A1 _3390_/S VGND VGND VPWR VPWR _3382_/X sky130_fd_sc_hd__mux2_1
XFILLER_41_3 VGND VGND VPWR VPWR sky130_fd_sc_hd__fill_4
XFILLER_124_693 VGND VGND VPWR VPWR sky130_fd_sc_hd__fill_4
XANTENNA__2902__B1 _3096_/A1 VGND VGND VPWR VPWR sky130_fd_sc_hd__diode_2
Xhold2108 _5166_/X VGND VGND VPWR VPWR _6397_/D sky130_fd_sc_hd__dlygate4sd3_1
X_5121_ _3993_/Y _5116_/X _5120_/X VGND VGND VPWR VPWR _5121_/Y sky130_fd_sc_hd__o21ai_1
XFILLER_85_717 VGND VGND VPWR VPWR sky130_fd_sc_hd__fill_1
Xhold1407 _3726_/X VGND VGND VPWR VPWR _5744_/D sky130_fd_sc_hd__dlygate4sd3_1
Xhold2119 _6419_/Q VGND VGND VPWR VPWR _5084_/B2 sky130_fd_sc_hd__dlygate4sd3_1
XPHY_EDGE_ROW_127_Right_127 VGND VGND VPWR VPWR sky130_fd_sc_hd__decap_3
XANTENNA__3458__A1 _4901_/A0 VGND VGND VPWR VPWR sky130_fd_sc_hd__diode_2
X_5052_ hold254/X _5052_/A1 _5059_/S VGND VGND VPWR VPWR _5052_/X sky130_fd_sc_hd__mux2_1
Xhold1429 _6306_/Q VGND VGND VPWR VPWR _4973_/A1 sky130_fd_sc_hd__dlygate4sd3_1
XFILLER_38_622 VGND VGND VPWR VPWR sky130_fd_sc_hd__fill_1
Xhold1418 _3920_/X VGND VGND VPWR VPWR _5897_/D sky130_fd_sc_hd__dlygate4sd3_1
X_4003_ _3974_/B _5096_/B _4001_/Y _3999_/X VGND VGND VPWR VPWR _5010_/B sky130_fd_sc_hd__a2bb2o_1
XANTENNA__4750__S0 _4810_/S VGND VGND VPWR VPWR sky130_fd_sc_hd__diode_2
XFILLER_93_783 VGND VGND VPWR VPWR sky130_fd_sc_hd__fill_1
XFILLER_92_293 VGND VGND VPWR VPWR sky130_fd_sc_hd__fill_4
XFILLER_92_282 VGND VGND VPWR VPWR sky130_fd_sc_hd__fill_2
XFILLER_1_93 VGND VGND VPWR VPWR sky130_fd_sc_hd__fill_2
XTAP_TAPCELL_ROW_36_834 VGND VPWR sky130_fd_sc_hd__tapvpwrvgnd_1
XTAP_TAPCELL_ROW_36_845 VGND VPWR sky130_fd_sc_hd__tapvpwrvgnd_1
XANTENNA__5080__A0 _5080_/A0 VGND VGND VPWR VPWR sky130_fd_sc_hd__diode_2
XFILLER_111_39 VGND VGND VPWR VPWR sky130_fd_sc_hd__fill_1
XFILLER_80_477 VGND VGND VPWR VPWR sky130_fd_sc_hd__fill_2
X_5954_ _6342_/CLK _5954_/D VGND VGND VPWR VPWR _5954_/Q sky130_fd_sc_hd__dfxtp_1
XFILLER_41_809 VPWR VGND VPWR VGND sky130_ef_sc_hd__decap_40_12
X_4905_ _4905_/A0 _4905_/A1 _4906_/S VGND VGND VPWR VPWR _4905_/X sky130_fd_sc_hd__mux2_1
XTAP_TAPCELL_ROW_101_1818 VGND VPWR sky130_fd_sc_hd__tapvpwrvgnd_1
X_5885_ _6114_/CLK _5885_/D VGND VGND VPWR VPWR _5885_/Q sky130_fd_sc_hd__dfxtp_1
X_4836_ _4901_/A0 _4836_/A1 _4841_/S VGND VGND VPWR VPWR _4836_/X sky130_fd_sc_hd__mux2_1
XFILLER_33_393 VGND VGND VPWR VPWR sky130_fd_sc_hd__fill_1
XTAP_TAPCELL_ROW_134_2306 VGND VPWR sky130_fd_sc_hd__tapvpwrvgnd_1
XANTENNA__4805__S1 _4802_/A VGND VGND VPWR VPWR sky130_fd_sc_hd__diode_2
XTAP_TAPCELL_ROW_134_2317 VGND VPWR sky130_fd_sc_hd__tapvpwrvgnd_1
X_4767_ _4802_/A _4767_/B VGND VGND VPWR VPWR _4767_/X sky130_fd_sc_hd__or2_1
XFILLER_106_115 VGND VGND VPWR VPWR sky130_fd_sc_hd__fill_1
XANTENNA_fanout119_X _4846_/A0 VGND VGND VPWR VPWR sky130_fd_sc_hd__diode_2
XFILLER_20_25 VGND VGND VPWR VPWR sky130_fd_sc_hd__fill_1
X_3718_ _4924_/A _5322_/Q _5323_/Q VGND VGND VPWR VPWR _3767_/B sky130_fd_sc_hd__or3b_2
X_4698_ _4811_/A1 _4695_/X _4811_/C1 VGND VGND VPWR VPWR _4698_/X sky130_fd_sc_hd__o21a_1
X_6437_ _6437_/CLK _6437_/D VGND VGND VPWR VPWR _6437_/Q sky130_fd_sc_hd__dfxtp_1
X_3649_ hold282/X _4484_/A0 _3657_/S VGND VGND VPWR VPWR _3649_/X sky130_fd_sc_hd__mux2_1
XFILLER_115_671 VGND VGND VPWR VPWR sky130_fd_sc_hd__fill_1
X_6368_ _6434_/CLK _6368_/D VGND VGND VPWR VPWR _6368_/Q sky130_fd_sc_hd__dfxtp_1
X_5319_ _6434_/CLK _5319_/D VGND VGND VPWR VPWR _5319_/Q sky130_fd_sc_hd__dfxtp_1
XFILLER_103_833 VGND VGND VPWR VPWR sky130_fd_sc_hd__fill_4
XFILLER_96_29 VGND VGND VPWR VPWR sky130_fd_sc_hd__fill_2
XANTENNA__3697__A1 _4521_/A1 VGND VGND VPWR VPWR sky130_fd_sc_hd__diode_2
XFILLER_130_641 VGND VGND VPWR VPWR sky130_fd_sc_hd__fill_2
Xhold23 hold23/A VGND VGND VPWR VPWR hold23/X sky130_fd_sc_hd__dlygate4sd3_1
Xhold12 hold12/A VGND VGND VPWR VPWR hold12/X sky130_fd_sc_hd__dlygate4sd3_1
XFILLER_48_408 VGND VGND VPWR VPWR sky130_fd_sc_hd__fill_1
X_6299_ _6302_/CLK _6299_/D VGND VGND VPWR VPWR _6299_/Q sky130_fd_sc_hd__dfxtp_1
Xhold56 hold56/A VGND VGND VPWR VPWR hold56/X sky130_fd_sc_hd__dlygate4sd3_1
XANTENNA__3449__A1 _5080_/A0 VGND VGND VPWR VPWR sky130_fd_sc_hd__diode_2
Xhold34 hold34/A VGND VGND VPWR VPWR hold34/X sky130_fd_sc_hd__dlygate4sd3_1
Xhold45 hold45/A VGND VGND VPWR VPWR hold45/X sky130_fd_sc_hd__dlygate4sd3_1
Xhold78 hold78/A VGND VGND VPWR VPWR hold78/X sky130_fd_sc_hd__dlygate4sd3_1
Xhold89 hold89/A VGND VGND VPWR VPWR hold89/X sky130_fd_sc_hd__dlygate4sd3_1
XFILLER_91_709 VPWR VGND VPWR VGND sky130_ef_sc_hd__decap_40_12
Xhold1930 _3699_/X VGND VGND VPWR VPWR _5720_/D sky130_fd_sc_hd__dlygate4sd3_1
Xhold1952 _5330_/Q VGND VGND VPWR VPWR _3321_/B1 sky130_fd_sc_hd__dlygate4sd3_1
Xhold1941 _3703_/X VGND VGND VPWR VPWR _5724_/D sky130_fd_sc_hd__dlygate4sd3_1
XFILLER_56_430 VGND VGND VPWR VPWR sky130_fd_sc_hd__fill_2
Xhold67 hold67/A VGND VGND VPWR VPWR hold67/X sky130_fd_sc_hd__dlygate4sd3_1
Xhold1963 _3255_/X VGND VGND VPWR VPWR _5391_/D sky130_fd_sc_hd__dlygate4sd3_1
Xhold1996 _6162_/Q VGND VGND VPWR VPWR _4591_/A1 sky130_fd_sc_hd__dlygate4sd3_1
Xhold1974 _6165_/Q VGND VGND VPWR VPWR _4677_/A1 sky130_fd_sc_hd__dlygate4sd3_1
XFILLER_45_11 VGND VGND VPWR VPWR sky130_fd_sc_hd__fill_1
XFILLER_17_839 VGND VGND VPWR VPWR sky130_fd_sc_hd__fill_1
Xhold1985 _4133_/X VGND VGND VPWR VPWR _5922_/D sky130_fd_sc_hd__dlygate4sd3_1
XANTENNA__5071__A0 _5239_/A1 VGND VGND VPWR VPWR sky130_fd_sc_hd__diode_2
XANTENNA__2962__A _2962_/A VGND VGND VPWR VPWR sky130_fd_sc_hd__diode_2
XFILLER_45_66 VGND VGND VPWR VPWR sky130_fd_sc_hd__fill_2
XFILLER_32_809 VGND VGND VPWR VPWR sky130_fd_sc_hd__fill_2
XFILLER_71_499 VGND VGND VPWR VPWR sky130_fd_sc_hd__fill_1
XTAP_TAPCELL_ROW_14_506 VGND VPWR sky130_fd_sc_hd__tapvpwrvgnd_1
XTAP_TAPCELL_ROW_14_517 VGND VPWR sky130_fd_sc_hd__tapvpwrvgnd_1
XANTENNA__3621__A1 _4958_/A0 VGND VGND VPWR VPWR sky130_fd_sc_hd__diode_2
XFILLER_129_207 VGND VGND VPWR VPWR sky130_fd_sc_hd__fill_1
XFILLER_12_533 VPWR VGND VPWR VGND sky130_ef_sc_hd__decap_40_12
XFILLER_138_741 VGND VGND VPWR VPWR sky130_fd_sc_hd__fill_8
XANTENNA__2901__S _3062_/S VGND VGND VPWR VPWR sky130_fd_sc_hd__diode_2
XANTENNA__2807__S0 _3091_/S VGND VGND VPWR VPWR sky130_fd_sc_hd__diode_2
XFILLER_138_785 VPWR VGND VPWR VGND sky130_ef_sc_hd__decap_40_12
XFILLER_6_27 VGND VGND VPWR VPWR sky130_fd_sc_hd__fill_1
XFILLER_99_809 VPWR VGND VPWR VGND sky130_ef_sc_hd__decap_40_12
XTAP_TAPCELL_ROW_74_1408 VGND VPWR sky130_fd_sc_hd__tapvpwrvgnd_1
XFILLER_106_693 VGND VGND VPWR VPWR sky130_fd_sc_hd__fill_4
XFILLER_79_533 VGND VGND VPWR VPWR sky130_fd_sc_hd__fill_1
XFILLER_126_80 VGND VGND VPWR VPWR sky130_fd_sc_hd__fill_4
XFILLER_121_641 VPWR VGND VPWR VGND sky130_ef_sc_hd__decap_40_12
XANTENNA__4828__S _4828_/S VGND VGND VPWR VPWR sky130_fd_sc_hd__diode_2
XFILLER_79_577 VGND VGND VPWR VPWR sky130_fd_sc_hd__fill_2
XFILLER_121_685 VPWR VGND VPWR VGND sky130_ef_sc_hd__decap_40_12
XFILLER_94_569 VPWR VGND VPWR VGND sky130_ef_sc_hd__decap_40_12
XTAP_TAPCELL_ROW_89_1640 VGND VPWR sky130_fd_sc_hd__tapvpwrvgnd_1
XFILLER_86_95 VGND VGND VPWR VPWR sky130_fd_sc_hd__fill_1
XFILLER_47_441 VGND VGND VPWR VPWR sky130_fd_sc_hd__fill_4
XFILLER_75_772 VPWR VGND VPWR VGND sky130_ef_sc_hd__decap_40_12
XFILLER_34_102 VGND VGND VPWR VPWR sky130_fd_sc_hd__fill_2
XFILLER_90_753 VGND VGND VPWR VPWR sky130_fd_sc_hd__fill_2
XFILLER_23_809 VPWR VGND VPWR VGND sky130_ef_sc_hd__decap_40_12
X_2951_ _3096_/A1 _2950_/X _2947_/Y _2949_/Y VGND VGND VPWR VPWR _2951_/X sky130_fd_sc_hd__o2bb2a_1
XANTENNA__3612__A1 _5212_/A1 VGND VGND VPWR VPWR sky130_fd_sc_hd__diode_2
XFILLER_50_617 VGND VGND VPWR VPWR sky130_fd_sc_hd__fill_4
XFILLER_15_393 VPWR VGND VPWR VGND sky130_ef_sc_hd__decap_40_12
X_5670_ _5682_/CLK hold64/X VGND VGND VPWR VPWR hold63/A sky130_fd_sc_hd__dfxtp_1
X_2882_ hold37/A hold12/A _5349_/Q _5577_/Q _2963_/S _2962_/A VGND VGND VPWR VPWR
+ _2883_/B sky130_fd_sc_hd__mux4_1
XANTENNA_clkbuf_0_clk_A clk VGND VGND VPWR VPWR sky130_fd_sc_hd__diode_2
X_4621_ hold998/X _4621_/A1 _4778_/S VGND VGND VPWR VPWR _4621_/X sky130_fd_sc_hd__mux2_1
XFILLER_129_741 VPWR VGND VPWR VGND sky130_ef_sc_hd__decap_40_12
XFILLER_30_385 VGND VGND VPWR VPWR sky130_fd_sc_hd__fill_1
XFILLER_129_785 VPWR VGND VPWR VGND sky130_ef_sc_hd__decap_40_12
XFILLER_128_251 VGND VGND VPWR VPWR sky130_fd_sc_hd__fill_1
XTAP_TAPCELL_ROW_116_2047 VGND VPWR sky130_fd_sc_hd__tapvpwrvgnd_1
XTAP_TAPCELL_ROW_116_2036 VGND VPWR sky130_fd_sc_hd__tapvpwrvgnd_1
X_4552_ _4552_/A0 _4445_/A _4561_/S VGND VGND VPWR VPWR _4552_/X sky130_fd_sc_hd__mux2_1
Xhold515 _3105_/X VGND VGND VPWR VPWR _5300_/D sky130_fd_sc_hd__dlygate4sd3_1
X_3503_ _4906_/A0 _3503_/A1 _3503_/S VGND VGND VPWR VPWR _3503_/X sky130_fd_sc_hd__mux2_1
Xhold526 _5864_/Q VGND VGND VPWR VPWR hold526/X sky130_fd_sc_hd__dlygate4sd3_1
X_4483_ _4513_/A _4483_/B VGND VGND VPWR VPWR _4492_/S sky130_fd_sc_hd__or2_4
Xhold504 _3928_/X VGND VGND VPWR VPWR _5905_/D sky130_fd_sc_hd__dlygate4sd3_1
X_6222_ _6222_/CLK _6222_/D VGND VGND VPWR VPWR _6222_/Q sky130_fd_sc_hd__dfxtp_1
Xhold537 _3193_/X VGND VGND VPWR VPWR _5356_/D sky130_fd_sc_hd__dlygate4sd3_1
X_3434_ _3434_/A0 _4903_/A0 _3437_/S VGND VGND VPWR VPWR _3434_/X sky130_fd_sc_hd__mux2_1
Xhold559 _4313_/X VGND VGND VPWR VPWR _5961_/D sky130_fd_sc_hd__dlygate4sd3_1
Xhold548 _3397_/X VGND VGND VPWR VPWR _5454_/D sky130_fd_sc_hd__dlygate4sd3_1
XFILLER_112_641 VGND VGND VPWR VPWR sky130_fd_sc_hd__fill_2
X_6153_ _6242_/CLK _6153_/D VGND VGND VPWR VPWR _6153_/Q sky130_fd_sc_hd__dfxtp_1
XANTENNA__2887__C1 _3089_/C1 VGND VGND VPWR VPWR sky130_fd_sc_hd__diode_2
X_3365_ _5209_/A0 _3364_/X _3365_/S VGND VGND VPWR VPWR _3365_/X sky130_fd_sc_hd__mux2_1
Xhold1204 _6371_/Q VGND VGND VPWR VPWR _5080_/A1 sky130_fd_sc_hd__dlygate4sd3_1
X_3296_ _4881_/A _3438_/A VGND VGND VPWR VPWR _3308_/S sky130_fd_sc_hd__nor2_4
XFILLER_100_825 VPWR VGND VPWR VGND sky130_ef_sc_hd__decap_40_12
X_5104_ _3325_/X _5060_/A _3315_/X VGND VGND VPWR VPWR _5108_/A sky130_fd_sc_hd__a21oi_1
X_6084_ _6417_/CLK _6084_/D VGND VGND VPWR VPWR _6084_/Q sky130_fd_sc_hd__dfxtp_1
Xhold1215 _6005_/Q VGND VGND VPWR VPWR _4363_/A0 sky130_fd_sc_hd__dlygate4sd3_1
Xhold1237 _3475_/X VGND VGND VPWR VPWR _5522_/D sky130_fd_sc_hd__dlygate4sd3_1
X_5035_ _5035_/A _5427_/Q _5035_/C VGND VGND VPWR VPWR _5112_/A sky130_fd_sc_hd__and3_1
XFILLER_57_238 VGND VGND VPWR VPWR sky130_fd_sc_hd__fill_2
Xhold1226 _4476_/X VGND VGND VPWR VPWR _6083_/D sky130_fd_sc_hd__dlygate4sd3_1
Xhold1248 _6039_/Q VGND VGND VPWR VPWR _4401_/A1 sky130_fd_sc_hd__dlygate4sd3_1
XTAP_TAPCELL_ROW_127_2198 VGND VPWR sky130_fd_sc_hd__tapvpwrvgnd_1
XFILLER_122_27 VGND VGND VPWR VPWR sky130_fd_sc_hd__fill_1
XANTENNA_fanout183_A _3044_/A VGND VGND VPWR VPWR sky130_fd_sc_hd__diode_2
Xhold1259 _6177_/Q VGND VGND VPWR VPWR _4823_/A1 sky130_fd_sc_hd__dlygate4sd3_1
XFILLER_65_293 VGND VGND VPWR VPWR sky130_fd_sc_hd__fill_4
XTAP_TAPCELL_ROW_0_278 VGND VPWR sky130_fd_sc_hd__tapvpwrvgnd_1
XFILLER_14_809 VGND VGND VPWR VPWR sky130_fd_sc_hd__fill_2
XANTENNA__3603__A1 _5214_/A1 VGND VGND VPWR VPWR sky130_fd_sc_hd__diode_2
XFILLER_81_797 VPWR VGND VPWR VGND sky130_ef_sc_hd__decap_40_12
X_5937_ _6315_/CLK _5937_/D VGND VGND VPWR VPWR _5937_/Q sky130_fd_sc_hd__dfxtp_1
XTAP_TAPCELL_ROW_0_289 VGND VPWR sky130_fd_sc_hd__tapvpwrvgnd_1
XFILLER_15_47 VGND VGND VPWR VPWR sky130_fd_sc_hd__fill_1
XFILLER_40_127 VGND VGND VPWR VPWR sky130_fd_sc_hd__fill_4
X_5868_ _6097_/CLK _5868_/D VGND VGND VPWR VPWR _5868_/Q sky130_fd_sc_hd__dfxtp_1
XFILLER_21_363 VPWR VGND VPWR VGND sky130_ef_sc_hd__decap_40_12
X_4819_ _4445_/A _4819_/A1 _4828_/S VGND VGND VPWR VPWR _4819_/X sky130_fd_sc_hd__mux2_1
X_5799_ _6114_/CLK hold70/X VGND VGND VPWR VPWR hold69/A sky130_fd_sc_hd__dfxtp_1
XFILLER_119_273 VGND VGND VPWR VPWR sky130_fd_sc_hd__fill_1
XFILLER_5_529 VPWR VGND VPWR VGND sky130_ef_sc_hd__decap_40_12
XFILLER_135_777 VGND VGND VPWR VPWR sky130_fd_sc_hd__fill_4
XANTENNA__4741__A1_N _4791_/B1 VGND VGND VPWR VPWR sky130_fd_sc_hd__diode_2
XTAP_TAPCELL_ROW_56_1138 VGND VPWR sky130_fd_sc_hd__tapvpwrvgnd_1
XFILLER_134_298 VGND VGND VPWR VPWR sky130_fd_sc_hd__fill_1
XANTENNA__4867__A0 _4906_/A0 VGND VGND VPWR VPWR sky130_fd_sc_hd__diode_2
Xoutput35 _5808_/Q VGND VGND VPWR VPWR s_axil_arready sky130_fd_sc_hd__buf_2
Xoutput46 _6059_/Q VGND VGND VPWR VPWR s_axil_rdata[2] sky130_fd_sc_hd__buf_2
XFILLER_103_641 VPWR VGND VPWR VGND sky130_ef_sc_hd__decap_40_12
XANTENNA__2957__A _3005_/A VGND VGND VPWR VPWR sky130_fd_sc_hd__diode_2
XFILLER_103_685 VPWR VGND VPWR VGND sky130_ef_sc_hd__decap_40_12
XFILLER_76_514 VGND VGND VPWR VPWR sky130_fd_sc_hd__fill_4
XFILLER_76_503 VGND VGND VPWR VPWR sky130_fd_sc_hd__fill_1
XFILLER_49_739 VGND VGND VPWR VPWR sky130_fd_sc_hd__fill_4
XFILLER_102_195 VGND VGND VPWR VPWR sky130_fd_sc_hd__fill_1
XANTENNA__4714__S0 _4791_/A1 VGND VGND VPWR VPWR sky130_fd_sc_hd__diode_2
Xhold1771 _5079_/X VGND VGND VPWR VPWR _6370_/D sky130_fd_sc_hd__dlygate4sd3_1
XFILLER_91_528 VPWR VGND VPWR VGND sky130_ef_sc_hd__decap_40_12
Xhold1760 _6042_/Q VGND VGND VPWR VPWR _4404_/A1 sky130_fd_sc_hd__dlygate4sd3_1
Xhold1793 _4880_/X VGND VGND VPWR VPWR _6230_/D sky130_fd_sc_hd__dlygate4sd3_1
Xhold1782 _6182_/Q VGND VGND VPWR VPWR _4828_/A1 sky130_fd_sc_hd__dlygate4sd3_1
XFILLER_16_102 VGND VGND VPWR VPWR sky130_fd_sc_hd__fill_1
XANTENNA__4190__S1 _4251_/A VGND VGND VPWR VPWR sky130_fd_sc_hd__diode_2
XANTENNA_clkbuf_leaf_2_clk_A clkbuf_leaf_9_clk/A VGND VGND VPWR VPWR sky130_fd_sc_hd__diode_2
XFILLER_72_775 VGND VGND VPWR VPWR sky130_fd_sc_hd__fill_1
XFILLER_72_742 VGND VGND VPWR VPWR sky130_fd_sc_hd__fill_2
XFILLER_44_444 VGND VGND VPWR VPWR sky130_fd_sc_hd__fill_1
XFILLER_17_669 VGND VGND VPWR VPWR sky130_fd_sc_hd__fill_2
XPHY_EDGE_ROW_19_Right_19 VGND VGND VPWR VPWR sky130_fd_sc_hd__decap_3
XFILLER_72_31 VGND VGND VPWR VPWR sky130_fd_sc_hd__fill_1
XFILLER_12_363 VGND VGND VPWR VPWR sky130_fd_sc_hd__fill_1
Xclkbuf_3_1__f_clk clkbuf_0_clk/X VGND VGND VPWR VPWR clkbuf_leaf_9_clk/A sky130_fd_sc_hd__clkbuf_16
XANTENNA__3358__B1 _5201_/B VGND VGND VPWR VPWR sky130_fd_sc_hd__diode_2
XFILLER_126_755 VGND VGND VPWR VPWR sky130_fd_sc_hd__fill_1
XFILLER_8_389 VPWR VGND VPWR VGND sky130_ef_sc_hd__decap_40_12
XFILLER_99_617 VPWR VGND VPWR VGND sky130_ef_sc_hd__decap_40_12
XPHY_EDGE_ROW_28_Right_28 VGND VGND VPWR VPWR sky130_fd_sc_hd__decap_3
XANTENNA__4858__A0 _4445_/A VGND VGND VPWR VPWR sky130_fd_sc_hd__diode_2
XANTENNA__3462__S _3463_/S VGND VGND VPWR VPWR sky130_fd_sc_hd__diode_2
XFILLER_113_449 VGND VGND VPWR VPWR sky130_fd_sc_hd__fill_2
XANTENNA__4558__S _4561_/S VGND VGND VPWR VPWR sky130_fd_sc_hd__diode_2
X_3150_ _3317_/A hold867/X _3156_/S VGND VGND VPWR VPWR _3150_/X sky130_fd_sc_hd__mux2_1
XFILLER_67_525 VGND VGND VPWR VPWR sky130_fd_sc_hd__fill_1
XFILLER_67_503 VGND VGND VPWR VPWR sky130_fd_sc_hd__fill_1
X_3081_ _5249_/Q _6254_/Q _5414_/Q hold55/X _3051_/S _3050_/A VGND VGND VPWR VPWR
+ _3081_/X sky130_fd_sc_hd__mux4_1
XFILLER_48_783 VPWR VGND VPWR VGND sky130_ef_sc_hd__decap_40_12
XPHY_EDGE_ROW_37_Right_37 VGND VGND VPWR VPWR sky130_fd_sc_hd__decap_3
XANTENNA__4293__S _4294_/S VGND VGND VPWR VPWR sky130_fd_sc_hd__diode_2
XFILLER_23_606 VGND VGND VPWR VPWR sky130_fd_sc_hd__fill_1
XFILLER_90_561 VPWR VGND VPWR VGND sky130_ef_sc_hd__decap_40_12
XFILLER_63_797 VPWR VGND VPWR VGND sky130_ef_sc_hd__decap_40_12
XFILLER_50_425 VGND VGND VPWR VPWR sky130_fd_sc_hd__fill_2
XTAP_TAPCELL_ROW_46_995 VGND VPWR sky130_fd_sc_hd__tapvpwrvgnd_1
XTAP_TAPCELL_ROW_46_984 VGND VPWR sky130_fd_sc_hd__tapvpwrvgnd_1
X_5722_ _6290_/CLK _5722_/D VGND VGND VPWR VPWR _5722_/Q sky130_fd_sc_hd__dfxtp_1
X_3983_ _5117_/A _5112_/B VGND VGND VPWR VPWR _3983_/Y sky130_fd_sc_hd__nor2_1
X_2934_ _5519_/Q _5531_/Q _3077_/S VGND VGND VPWR VPWR _2934_/X sky130_fd_sc_hd__mux2_1
X_2865_ _2861_/X _2863_/X _2864_/X _3075_/C1 VGND VGND VPWR VPWR _2865_/X sky130_fd_sc_hd__a22o_1
X_5653_ _5682_/CLK _5653_/D VGND VGND VPWR VPWR _5653_/Q sky130_fd_sc_hd__dfxtp_1
X_5584_ _6146_/CLK _5584_/D VGND VGND VPWR VPWR _5584_/Q sky130_fd_sc_hd__dfxtp_1
X_4604_ _5469_/Q _5640_/Q _5631_/Q _5721_/Q _4773_/S _4789_/A VGND VGND VPWR VPWR
+ _4604_/X sky130_fd_sc_hd__mux4_1
XPHY_EDGE_ROW_46_Right_46 VGND VGND VPWR VPWR sky130_fd_sc_hd__decap_3
X_4535_ hold115/X _5237_/A0 _4535_/S VGND VGND VPWR VPWR _4535_/X sky130_fd_sc_hd__mux2_1
X_2796_ _5416_/Q _5490_/Q _5346_/Q _5574_/Q _2963_/S _2962_/A VGND VGND VPWR VPWR
+ _2797_/B sky130_fd_sc_hd__mux4_1
Xhold301 _5800_/Q VGND VGND VPWR VPWR hold301/X sky130_fd_sc_hd__dlygate4sd3_1
Xhold334 _2669_/X VGND VGND VPWR VPWR _5242_/D sky130_fd_sc_hd__dlygate4sd3_1
Xhold323 _5507_/Q VGND VGND VPWR VPWR hold323/X sky130_fd_sc_hd__dlygate4sd3_1
XFILLER_117_777 VGND VGND VPWR VPWR sky130_fd_sc_hd__fill_4
XFILLER_117_27 VPWR VGND VPWR VGND sky130_ef_sc_hd__decap_40_12
Xhold312 _4281_/X VGND VGND VPWR VPWR _5933_/D sky130_fd_sc_hd__dlygate4sd3_1
XFILLER_132_725 VPWR VGND VPWR VGND sky130_ef_sc_hd__decap_40_12
X_4466_ _5075_/A0 hold751/X _4472_/S VGND VGND VPWR VPWR _4466_/X sky130_fd_sc_hd__mux2_1
Xhold367 _5247_/Q VGND VGND VPWR VPWR hold367/X sky130_fd_sc_hd__dlygate4sd3_1
XANTENNA__4849__A0 _4901_/A0 VGND VGND VPWR VPWR sky130_fd_sc_hd__diode_2
Xhold356 _5040_/X VGND VGND VPWR VPWR _6335_/D sky130_fd_sc_hd__dlygate4sd3_1
Xhold345 _5651_/Q VGND VGND VPWR VPWR hold345/X sky130_fd_sc_hd__dlygate4sd3_1
Xhold378 _3781_/X VGND VGND VPWR VPWR _5789_/D sky130_fd_sc_hd__dlygate4sd3_1
XFILLER_132_769 VPWR VGND VPWR VGND sky130_ef_sc_hd__decap_40_12
XANTENNA__4468__S _4472_/S VGND VGND VPWR VPWR sky130_fd_sc_hd__diode_2
X_6205_ _6233_/CLK _6205_/D VGND VGND VPWR VPWR _6205_/Q sky130_fd_sc_hd__dfxtp_1
Xhold389 _6239_/Q VGND VGND VPWR VPWR hold389/X sky130_fd_sc_hd__dlygate4sd3_1
X_3417_ _4618_/A0 _5210_/A1 _3423_/S VGND VGND VPWR VPWR _3417_/X sky130_fd_sc_hd__mux2_1
X_4397_ _5050_/A _4935_/A VGND VGND VPWR VPWR _4406_/S sky130_fd_sc_hd__or2_4
XANTENNA__3521__A0 _5818_/Q VGND VGND VPWR VPWR sky130_fd_sc_hd__diode_2
XTAP_TAPCELL_ROW_129_2238 VGND VPWR sky130_fd_sc_hd__tapvpwrvgnd_1
X_6136_ _6434_/CLK _6136_/D VGND VGND VPWR VPWR _6136_/Q sky130_fd_sc_hd__dfxtp_1
X_3348_ _3339_/A _3315_/B _3338_/A _4997_/B VGND VGND VPWR VPWR _3365_/S sky130_fd_sc_hd__a211oi_4
XFILLER_133_15 VPWR VGND VPWR VGND sky130_ef_sc_hd__decap_40_12
Xhold1012 _6138_/Q VGND VGND VPWR VPWR _4536_/A0 sky130_fd_sc_hd__dlygate4sd3_1
Xhold1023 _4903_/X VGND VGND VPWR VPWR _6251_/D sky130_fd_sc_hd__dlygate4sd3_1
XFILLER_112_493 VPWR VGND VPWR VGND sky130_ef_sc_hd__decap_40_12
Xhold1001 _6057_/Q VGND VGND VPWR VPWR _4425_/A1 sky130_fd_sc_hd__dlygate4sd3_1
XTAP_TAPCELL_ROW_51_1068 VGND VPWR sky130_fd_sc_hd__tapvpwrvgnd_1
Xhold1034 _5531_/Q VGND VGND VPWR VPWR _3485_/A0 sky130_fd_sc_hd__dlygate4sd3_1
Xhold1067 _4552_/X VGND VGND VPWR VPWR _6152_/D sky130_fd_sc_hd__dlygate4sd3_1
X_6067_ _6342_/CLK _6067_/D VGND VGND VPWR VPWR _6067_/Q sky130_fd_sc_hd__dfxtp_1
Xhold1045 _3145_/X VGND VGND VPWR VPWR _5326_/D sky130_fd_sc_hd__dlygate4sd3_1
Xhold1056 _6051_/Q VGND VGND VPWR VPWR _4414_/A1 sky130_fd_sc_hd__dlygate4sd3_1
XPHY_EDGE_ROW_55_Right_55 VGND VGND VPWR VPWR sky130_fd_sc_hd__decap_3
X_3279_ _3801_/A _3279_/B VGND VGND VPWR VPWR _3279_/Y sky130_fd_sc_hd__nor2_1
Xhold1078 _5542_/Q VGND VGND VPWR VPWR _3497_/A1 sky130_fd_sc_hd__dlygate4sd3_1
XFILLER_100_699 VGND VGND VPWR VPWR sky130_fd_sc_hd__fill_1
XANTENNA__3824__A1 _5051_/A1 VGND VGND VPWR VPWR sky130_fd_sc_hd__diode_2
X_5018_ _5017_/X _5016_/X _5018_/S VGND VGND VPWR VPWR _5018_/X sky130_fd_sc_hd__mux2_1
Xhold1089 _3678_/X VGND VGND VPWR VPWR _5701_/D sky130_fd_sc_hd__dlygate4sd3_1
XANTENNA__2716__S _2716_/S VGND VGND VPWR VPWR sky130_fd_sc_hd__diode_2
XFILLER_26_433 VPWR VGND VPWR VGND sky130_ef_sc_hd__decap_40_12
XANTENNA__4931__S _4934_/S VGND VGND VPWR VPWR sky130_fd_sc_hd__diode_2
XTAP_TAPCELL_ROW_24_656 VGND VPWR sky130_fd_sc_hd__tapvpwrvgnd_1
XTAP_TAPCELL_ROW_24_667 VGND VPWR sky130_fd_sc_hd__tapvpwrvgnd_1
XPHY_EDGE_ROW_64_Right_64 VGND VGND VPWR VPWR sky130_fd_sc_hd__decap_3
XFILLER_21_171 VGND VGND VPWR VPWR sky130_fd_sc_hd__fill_1
XANTENNA__4232__A _4272_/S VGND VGND VPWR VPWR sky130_fd_sc_hd__diode_2
XFILLER_6_805 VGND VGND VPWR VPWR sky130_fd_sc_hd__fill_4
XFILLER_5_337 VPWR VGND VPWR VGND sky130_ef_sc_hd__decap_40_12
XFILLER_135_541 VPWR VGND VPWR VGND sky130_ef_sc_hd__decap_40_12
XFILLER_108_755 VGND VGND VPWR VPWR sky130_fd_sc_hd__fill_1
XFILLER_135_585 VPWR VGND VPWR VGND sky130_ef_sc_hd__decap_40_12
XFILLER_123_725 VGND VGND VPWR VPWR sky130_fd_sc_hd__fill_2
XANTENNA_fanout99_X _5045_/A1 VGND VGND VPWR VPWR sky130_fd_sc_hd__diode_2
Xhold890 _5585_/Q VGND VGND VPWR VPWR hold890/X sky130_fd_sc_hd__dlygate4sd3_1
XFILLER_122_279 VGND VGND VPWR VPWR sky130_fd_sc_hd__fill_1
XFILLER_110_419 VGND VGND VPWR VPWR sky130_fd_sc_hd__fill_1
XANTENNA__3512__A0 _5233_/A0 VGND VGND VPWR VPWR sky130_fd_sc_hd__diode_2
XFILLER_67_20 VPWR VGND VPWR VGND sky130_ef_sc_hd__decap_40_12
XFILLER_3_39 VPWR VGND VPWR VGND sky130_ef_sc_hd__decap_40_12
XFILLER_88_193 VGND VGND VPWR VPWR sky130_fd_sc_hd__fill_1
XPHY_EDGE_ROW_73_Right_73 VGND VGND VPWR VPWR sky130_fd_sc_hd__decap_3
XFILLER_67_53 VGND VGND VPWR VPWR sky130_fd_sc_hd__fill_2
XFILLER_67_42 VGND VGND VPWR VPWR sky130_fd_sc_hd__fill_1
XFILLER_49_525 VGND VGND VPWR VPWR sky130_fd_sc_hd__fill_4
XFILLER_76_344 VGND VGND VPWR VPWR sky130_fd_sc_hd__fill_1
XFILLER_92_837 VGND VGND VPWR VPWR sky130_fd_sc_hd__fill_4
XANTENNA__3815__A1 _4846_/A0 VGND VGND VPWR VPWR sky130_fd_sc_hd__diode_2
XFILLER_76_388 VGND VGND VPWR VPWR sky130_fd_sc_hd__fill_4
XTAP_TAPCELL_ROW_69_1329 VGND VPWR sky130_fd_sc_hd__tapvpwrvgnd_1
XFILLER_64_528 VGND VGND VPWR VPWR sky130_fd_sc_hd__fill_1
Xhold1590 _6206_/Q VGND VGND VPWR VPWR _4854_/A1 sky130_fd_sc_hd__dlygate4sd3_1
XTAP_TAPCELL_ROW_82_1529 VGND VPWR sky130_fd_sc_hd__tapvpwrvgnd_1
XFILLER_45_797 VPWR VGND VPWR VGND sky130_ef_sc_hd__decap_40_12
XTAP_TAPCELL_ROW_43_943 VGND VPWR sky130_fd_sc_hd__tapvpwrvgnd_1
XANTENNA__4841__S _4841_/S VGND VGND VPWR VPWR sky130_fd_sc_hd__diode_2
XPHY_EDGE_ROW_82_Right_82 VGND VGND VPWR VPWR sky130_fd_sc_hd__decap_3
XPHY_EDGE_ROW_17_Left_156 VGND VGND VPWR VPWR sky130_fd_sc_hd__decap_3
XANTENNA__3965__B _5201_/B VGND VGND VPWR VPWR sky130_fd_sc_hd__diode_2
XANTENNA__3457__S _3463_/S VGND VGND VPWR VPWR sky130_fd_sc_hd__diode_2
X_2650_ _2650_/A VGND VGND VPWR VPWR _2650_/Y sky130_fd_sc_hd__inv_2
XFILLER_9_665 VGND VGND VPWR VPWR sky130_fd_sc_hd__fill_4
XFILLER_12_193 VGND VGND VPWR VPWR sky130_fd_sc_hd__fill_1
XTAP_TAPCELL_ROW_97_1761 VGND VPWR sky130_fd_sc_hd__tapvpwrvgnd_1
XTAP_TAPCELL_ROW_97_1750 VGND VPWR sky130_fd_sc_hd__tapvpwrvgnd_1
XANTENNA__3751__A0 _5043_/A1 VGND VGND VPWR VPWR sky130_fd_sc_hd__diode_2
XFILLER_126_585 VGND VGND VPWR VPWR sky130_fd_sc_hd__fill_2
XFILLER_114_725 VPWR VGND VPWR VGND sky130_ef_sc_hd__decap_40_12
X_4320_ hold739/X _4929_/A1 _4325_/S VGND VGND VPWR VPWR _4320_/X sky130_fd_sc_hd__mux2_1
XFILLER_114_769 VPWR VGND VPWR VGND sky130_ef_sc_hd__decap_40_12
XANTENNA__4288__S _4294_/S VGND VGND VPWR VPWR sky130_fd_sc_hd__diode_2
X_4251_ _4251_/A _4251_/B VGND VGND VPWR VPWR _4251_/X sky130_fd_sc_hd__or2_1
X_3202_ hold155/X _5233_/A0 _3206_/S VGND VGND VPWR VPWR _3202_/X sky130_fd_sc_hd__mux2_1
XANTENNA__3503__A0 _4906_/A0 VGND VGND VPWR VPWR sky130_fd_sc_hd__diode_2
XPHY_EDGE_ROW_91_Right_91 VGND VGND VPWR VPWR sky130_fd_sc_hd__decap_3
XANTENNA_hold2230_A _5818_/Q VGND VGND VPWR VPWR sky130_fd_sc_hd__diode_2
XPHY_EDGE_ROW_26_Left_165 VGND VGND VPWR VPWR sky130_fd_sc_hd__decap_3
X_4182_ _6304_/Q _6286_/Q _4257_/S VGND VGND VPWR VPWR _4183_/B sky130_fd_sc_hd__mux2_1
XFILLER_95_653 VPWR VGND VPWR VGND sky130_ef_sc_hd__decap_40_12
XFILLER_94_141 VGND VGND VPWR VPWR sky130_fd_sc_hd__fill_4
XTAP_TAPCELL_ROW_2_329 VGND VPWR sky130_fd_sc_hd__tapvpwrvgnd_1
X_3133_ _4924_/C _5050_/B VGND VGND VPWR VPWR _3135_/A sky130_fd_sc_hd__nor2_1
X_3064_ _3092_/A _6193_/Q _3063_/X VGND VGND VPWR VPWR _3064_/Y sky130_fd_sc_hd__a21oi_1
XFILLER_95_697 VPWR VGND VPWR VGND sky130_ef_sc_hd__decap_40_12
XFILLER_83_837 VGND VGND VPWR VPWR sky130_fd_sc_hd__fill_2
XANTENNA__3806__A1 _5233_/A0 VGND VGND VPWR VPWR sky130_fd_sc_hd__diode_2
XTAP_TAPCELL_ROW_124_2157 VGND VPWR sky130_fd_sc_hd__tapvpwrvgnd_1
XFILLER_82_369 VGND VGND VPWR VPWR sky130_fd_sc_hd__fill_1
XFILLER_36_753 VGND VGND VPWR VPWR sky130_fd_sc_hd__fill_1
XFILLER_36_786 VPWR VGND VPWR VGND sky130_ef_sc_hd__decap_40_12
XTAP_TAPCELL_ROW_106_1890 VGND VPWR sky130_fd_sc_hd__tapvpwrvgnd_1
XFILLER_50_233 VGND VGND VPWR VPWR sky130_fd_sc_hd__fill_1
XFILLER_23_447 VGND VGND VPWR VPWR sky130_fd_sc_hd__fill_1
XPHY_EDGE_ROW_35_Left_174 VGND VGND VPWR VPWR sky130_fd_sc_hd__decap_3
X_3966_ _5019_/A _4010_/B _3965_/X VGND VGND VPWR VPWR _3972_/A sky130_fd_sc_hd__o21bai_1
XANTENNA__4751__S _4810_/S VGND VGND VPWR VPWR sky130_fd_sc_hd__diode_2
XFILLER_11_609 VGND VGND VPWR VPWR sky130_fd_sc_hd__fill_4
XANTENNA_fanout146_A _4803_/S VGND VGND VPWR VPWR sky130_fd_sc_hd__diode_2
X_2917_ _5542_/Q _5566_/Q _3077_/S VGND VGND VPWR VPWR _2918_/B sky130_fd_sc_hd__mux2_1
X_5705_ _5898_/CLK _5705_/D VGND VGND VPWR VPWR _5705_/Q sky130_fd_sc_hd__dfxtp_1
XANTENNA__4231__B2 _4271_/S1 VGND VGND VPWR VPWR sky130_fd_sc_hd__diode_2
XTAP_TAPCELL_ROW_21_615 VGND VPWR sky130_fd_sc_hd__tapvpwrvgnd_1
XFILLER_137_839 VGND VGND VPWR VPWR sky130_fd_sc_hd__fill_1
X_3897_ _3897_/A0 _6416_/Q _3899_/S VGND VGND VPWR VPWR _3897_/X sky130_fd_sc_hd__mux2_1
X_5636_ _6290_/CLK _5636_/D VGND VGND VPWR VPWR _5636_/Q sky130_fd_sc_hd__dfxtp_1
XFILLER_12_15 VGND VGND VPWR VPWR sky130_fd_sc_hd__fill_4
XFILLER_128_15 VPWR VGND VPWR VGND sky130_ef_sc_hd__decap_40_12
X_2848_ _2962_/A _2848_/B VGND VGND VPWR VPWR _2848_/X sky130_fd_sc_hd__or2_1
X_5567_ _5571_/CLK _5567_/D VGND VGND VPWR VPWR _5567_/Q sky130_fd_sc_hd__dfxtp_1
XFILLER_117_541 VPWR VGND VPWR VGND sky130_ef_sc_hd__decap_40_12
X_2779_ _3096_/A1 _2778_/X _2775_/Y _2777_/Y VGND VGND VPWR VPWR _2779_/X sky130_fd_sc_hd__o2bb2a_1
Xhold153 _6436_/Q VGND VGND VPWR VPWR hold153/X sky130_fd_sc_hd__dlygate4sd3_1
XFILLER_117_585 VPWR VGND VPWR VGND sky130_ef_sc_hd__decap_40_12
XFILLER_105_725 VGND VGND VPWR VPWR sky130_fd_sc_hd__fill_2
X_5498_ _5583_/CLK _5498_/D VGND VGND VPWR VPWR _5498_/Q sky130_fd_sc_hd__dfxtp_1
Xhold120 _3881_/X VGND VGND VPWR VPWR _5861_/D sky130_fd_sc_hd__dlygate4sd3_1
XANTENNA_fanout101_X _5044_/A1 VGND VGND VPWR VPWR sky130_fd_sc_hd__diode_2
XPHY_EDGE_ROW_44_Left_183 VGND VGND VPWR VPWR sky130_fd_sc_hd__decap_3
XFILLER_2_329 VPWR VGND VPWR VGND sky130_ef_sc_hd__decap_40_12
X_4518_ hold141/X _5212_/A1 _4522_/S VGND VGND VPWR VPWR _4518_/X sky130_fd_sc_hd__mux2_1
Xhold142 _4518_/X VGND VGND VPWR VPWR _6121_/D sky130_fd_sc_hd__dlygate4sd3_1
Xhold131 _5983_/Q VGND VGND VPWR VPWR hold131/X sky130_fd_sc_hd__dlygate4sd3_1
XFILLER_132_533 VPWR VGND VPWR VGND sky130_ef_sc_hd__decap_40_12
Xhold164 _3457_/X VGND VGND VPWR VPWR _5506_/D sky130_fd_sc_hd__dlygate4sd3_1
Xhold175 _5499_/Q VGND VGND VPWR VPWR hold175/X sky130_fd_sc_hd__dlygate4sd3_1
X_4449_ _6258_/Q _3366_/X _4445_/B _4883_/A1 _4448_/Y VGND VGND VPWR VPWR _4449_/X
+ sky130_fd_sc_hd__a221o_2
XANTENNA__4198__S _4257_/S VGND VGND VPWR VPWR sky130_fd_sc_hd__diode_2
Xhold186 _4932_/X VGND VGND VPWR VPWR _6269_/D sky130_fd_sc_hd__dlygate4sd3_1
Xhold197 _5681_/Q VGND VGND VPWR VPWR hold197/X sky130_fd_sc_hd__dlygate4sd3_1
XANTENNA__4298__A1 _5053_/A1 VGND VGND VPWR VPWR sky130_fd_sc_hd__diode_2
XFILLER_58_344 VPWR VGND VPWR VGND sky130_ef_sc_hd__decap_40_12
XANTENNA__4926__S _4934_/S VGND VGND VPWR VPWR sky130_fd_sc_hd__diode_2
XFILLER_19_709 VPWR VGND VPWR VGND sky130_ef_sc_hd__decap_40_12
X_6119_ _6125_/CLK _6119_/D VGND VGND VPWR VPWR _6119_/Q sky130_fd_sc_hd__dfxtp_1
XFILLER_74_837 VGND VGND VPWR VPWR sky130_fd_sc_hd__fill_2
XFILLER_58_377 VGND VGND VPWR VPWR sky130_fd_sc_hd__fill_2
XFILLER_46_539 VGND VGND VPWR VPWR sky130_fd_sc_hd__fill_1
XFILLER_46_517 VGND VGND VPWR VPWR sky130_fd_sc_hd__fill_4
XTAP_TAPCELL_ROW_29_737 VGND VPWR sky130_fd_sc_hd__tapvpwrvgnd_1
XANTENNA__4227__A _4263_/A VGND VGND VPWR VPWR sky130_fd_sc_hd__diode_2
XPHY_EDGE_ROW_53_Left_192 VGND VGND VPWR VPWR sky130_fd_sc_hd__decap_3
XFILLER_27_797 VPWR VGND VPWR VGND sky130_ef_sc_hd__decap_40_12
XANTENNA__2970__A _3044_/A VGND VGND VPWR VPWR sky130_fd_sc_hd__diode_2
XTAP_TAPCELL_ROW_64_1259 VGND VPWR sky130_fd_sc_hd__tapvpwrvgnd_1
XFILLER_42_789 VPWR VGND VPWR VGND sky130_ef_sc_hd__decap_40_12
XFILLER_14_469 VGND VGND VPWR VPWR sky130_fd_sc_hd__fill_4
XTAP_TAPCELL_ROW_40_902 VGND VPWR sky130_fd_sc_hd__tapvpwrvgnd_1
XFILLER_127_316 VGND VGND VPWR VPWR sky130_fd_sc_hd__fill_1
XFILLER_6_613 VPWR VGND VPWR VGND sky130_ef_sc_hd__decap_40_12
XTAP_TAPCELL_ROW_79_1480 VGND VPWR sky130_fd_sc_hd__tapvpwrvgnd_1
XFILLER_10_697 VGND VGND VPWR VPWR sky130_fd_sc_hd__fill_2
XFILLER_6_657 VPWR VGND VPWR VGND sky130_ef_sc_hd__decap_40_12
XFILLER_108_585 VGND VGND VPWR VPWR sky130_fd_sc_hd__fill_2
XTAP_TAPCELL_ROW_79_1491 VGND VPWR sky130_fd_sc_hd__tapvpwrvgnd_1
XFILLER_78_41 VPWR VGND VPWR VGND sky130_ef_sc_hd__decap_40_12
XTAP_TAPCELL_ROW_9_440 VGND VPWR sky130_fd_sc_hd__tapvpwrvgnd_1
XFILLER_2_841 VGND VGND VPWR VPWR sky130_fd_sc_hd__fill_1
XTAP_TAPCELL_ROW_92_1680 VGND VPWR sky130_fd_sc_hd__tapvpwrvgnd_1
XFILLER_78_85 VGND VGND VPWR VPWR sky130_fd_sc_hd__fill_1
XANTENNA__4289__A1 _5042_/A1 VGND VGND VPWR VPWR sky130_fd_sc_hd__diode_2
XFILLER_92_601 VPWR VGND VPWR VGND sky130_ef_sc_hd__decap_40_12
XANTENNA__3740__S _3745_/S VGND VGND VPWR VPWR sky130_fd_sc_hd__diode_2
XANTENNA__4836__S _4841_/S VGND VGND VPWR VPWR sky130_fd_sc_hd__diode_2
XFILLER_94_73 VGND VGND VPWR VPWR sky130_fd_sc_hd__fill_2
XFILLER_92_645 VPWR VGND VPWR VGND sky130_ef_sc_hd__decap_40_12
XFILLER_18_753 VGND VGND VPWR VPWR sky130_fd_sc_hd__fill_2
XFILLER_91_166 VGND VGND VPWR VPWR sky130_fd_sc_hd__fill_2
XFILLER_45_561 VGND VGND VPWR VPWR sky130_fd_sc_hd__fill_4
XFILLER_72_391 VPWR VGND VPWR VGND sky130_ef_sc_hd__decap_40_12
XFILLER_60_531 VGND VGND VPWR VPWR sky130_fd_sc_hd__fill_1
X_3820_ _4916_/A _4914_/A _4910_/A VGND VGND VPWR VPWR _3821_/C sky130_fd_sc_hd__or3_1
XANTENNA__4424__X _4424_/X VGND VGND VPWR VPWR sky130_fd_sc_hd__diode_2
XFILLER_20_417 VGND VGND VPWR VPWR sky130_fd_sc_hd__fill_2
X_3751_ _5043_/A1 _4137_/A0 _3755_/S VGND VGND VPWR VPWR _3751_/X sky130_fd_sc_hd__mux2_1
X_2702_ _5343_/Q _4346_/A _4924_/C _4149_/A _2701_/X VGND VGND VPWR VPWR _3160_/C
+ sky130_fd_sc_hd__a221o_1
XFILLER_9_473 VPWR VGND VPWR VGND sky130_ef_sc_hd__decap_40_12
X_3682_ _4958_/A0 _3682_/A1 _3688_/S VGND VGND VPWR VPWR _5704_/D sky130_fd_sc_hd__mux2_1
XFILLER_134_809 VGND VGND VPWR VPWR sky130_fd_sc_hd__fill_2
X_5421_ _5820_/CLK _5421_/D VGND VGND VPWR VPWR _5421_/Q sky130_fd_sc_hd__dfxtp_1
X_2633_ _3222_/B VGND VGND VPWR VPWR _3232_/A sky130_fd_sc_hd__inv_2
X_5352_ _5753_/CLK _5352_/D VGND VGND VPWR VPWR _5352_/Q sky130_fd_sc_hd__dfxtp_1
XANTENNA__4921__C1 _5200_/A VGND VGND VPWR VPWR sky130_fd_sc_hd__diode_2
XANTENNA__4600__A _4600_/A VGND VGND VPWR VPWR sky130_fd_sc_hd__diode_2
XFILLER_114_533 VPWR VGND VPWR VGND sky130_ef_sc_hd__decap_40_12
XFILLER_99_244 VGND VGND VPWR VPWR sky130_fd_sc_hd__fill_4
X_4303_ hold179/X _5046_/A1 _4304_/S VGND VGND VPWR VPWR _4303_/X sky130_fd_sc_hd__mux2_1
X_5283_ _6199_/CLK _5283_/D VGND VGND VPWR VPWR _5283_/Q sky130_fd_sc_hd__dfxtp_1
XFILLER_99_277 VGND VGND VPWR VPWR sky130_fd_sc_hd__fill_2
X_4234_ _5736_/Q _5466_/Q _5457_/Q _5448_/Q _4237_/S _4251_/A VGND VGND VPWR VPWR
+ _4234_/X sky130_fd_sc_hd__mux4_1
XANTENNA__5229__A0 _5241_/A1 VGND VGND VPWR VPWR sky130_fd_sc_hd__diode_2
XANTENNA__4746__S _4803_/S VGND VGND VPWR VPWR sky130_fd_sc_hd__diode_2
X_4165_ _4212_/A _4165_/B VGND VGND VPWR VPWR _4165_/X sky130_fd_sc_hd__or2_1
X_3116_ hold576/X _5239_/A1 _3126_/S VGND VGND VPWR VPWR _3116_/X sky130_fd_sc_hd__mux2_1
XFILLER_95_472 VGND VGND VPWR VPWR sky130_fd_sc_hd__fill_2
XFILLER_56_837 VGND VGND VPWR VPWR sky130_fd_sc_hd__fill_4
XFILLER_55_314 VGND VGND VPWR VPWR sky130_fd_sc_hd__fill_2
X_4096_ _5258_/Q _6047_/Q _4221_/S VGND VGND VPWR VPWR _4097_/B sky130_fd_sc_hd__mux2_1
XFILLER_55_358 VPWR VGND VPWR VGND sky130_ef_sc_hd__decap_40_12
XFILLER_130_27 VGND VGND VPWR VPWR sky130_fd_sc_hd__fill_1
X_3047_ _3076_/A1 _3042_/X _3044_/X _3046_/X VGND VGND VPWR VPWR _3047_/X sky130_fd_sc_hd__a22o_1
XANTENNA__4452__B2 _4882_/A1 VGND VGND VPWR VPWR sky130_fd_sc_hd__diode_2
XFILLER_24_701 VGND VGND VPWR VPWR sky130_fd_sc_hd__fill_2
XFILLER_130_49 VGND VGND VPWR VPWR sky130_fd_sc_hd__fill_2
XANTENNA_clkbuf_leaf_42_clk_A clkload4/A VGND VGND VPWR VPWR sky130_fd_sc_hd__diode_2
XANTENNA__2790__A _3050_/A VGND VGND VPWR VPWR sky130_fd_sc_hd__diode_2
X_4998_ _4010_/B _4998_/A2 _4997_/X VGND VGND VPWR VPWR _4998_/Y sky130_fd_sc_hd__a21oi_2
XANTENNA_fanout149_X _4810_/S VGND VGND VPWR VPWR sky130_fd_sc_hd__diode_2
XFILLER_11_417 VPWR VGND VPWR VGND sky130_ef_sc_hd__decap_40_12
XTAP_TAPCELL_ROW_137_2359 VGND VPWR sky130_fd_sc_hd__tapvpwrvgnd_1
XTAP_TAPCELL_ROW_137_2348 VGND VPWR sky130_fd_sc_hd__tapvpwrvgnd_1
X_3949_ _3952_/D VGND VGND VPWR VPWR _3949_/Y sky130_fd_sc_hd__inv_2
XFILLER_137_669 VGND VGND VPWR VPWR sky130_fd_sc_hd__fill_2
XFILLER_136_135 VGND VGND VPWR VPWR sky130_fd_sc_hd__fill_4
XFILLER_125_809 VPWR VGND VPWR VGND sky130_ef_sc_hd__decap_40_12
XANTENNA_clkbuf_leaf_57_clk_A clkload5/A VGND VGND VPWR VPWR sky130_fd_sc_hd__diode_2
X_5619_ _6297_/CLK _5619_/D VGND VGND VPWR VPWR _5619_/Q sky130_fd_sc_hd__dfxtp_1
XANTENNA_clkbuf_leaf_100_clk_A clkload0/A VGND VGND VPWR VPWR sky130_fd_sc_hd__diode_2
XFILLER_117_393 VGND VGND VPWR VPWR sky130_fd_sc_hd__fill_1
XANTENNA__3191__A1 _5235_/A0 VGND VGND VPWR VPWR sky130_fd_sc_hd__diode_2
XFILLER_120_514 VPWR VGND VPWR VGND sky130_ef_sc_hd__decap_40_12
XFILLER_105_555 VGND VGND VPWR VPWR sky130_fd_sc_hd__fill_4
XFILLER_120_569 VPWR VGND VPWR VGND sky130_ef_sc_hd__decap_40_12
XFILLER_101_783 VGND VGND VPWR VPWR sky130_fd_sc_hd__fill_1
XFILLER_47_837 VGND VGND VPWR VPWR sky130_fd_sc_hd__fill_2
XFILLER_19_517 VPWR VGND VPWR VGND sky130_ef_sc_hd__decap_40_12
XFILLER_73_111 VGND VGND VPWR VPWR sky130_fd_sc_hd__fill_1
XPHY_EDGE_ROW_61_Left_200 VGND VGND VPWR VPWR sky130_fd_sc_hd__decap_3
XANTENNA__4118__S1 _4263_/A VGND VGND VPWR VPWR sky130_fd_sc_hd__diode_2
XFILLER_0_29 VPWR VGND VPWR VGND sky130_ef_sc_hd__decap_40_12
XANTENNA__4443__B2 _2665_/Y VGND VGND VPWR VPWR sky130_fd_sc_hd__diode_2
XFILLER_64_54 VGND VGND VPWR VPWR sky130_fd_sc_hd__fill_2
XFILLER_61_339 VGND VGND VPWR VPWR sky130_fd_sc_hd__fill_1
XFILLER_54_391 VGND VGND VPWR VPWR sky130_fd_sc_hd__fill_1
XANTENNA__2904__S _2963_/S VGND VGND VPWR VPWR sky130_fd_sc_hd__diode_2
XFILLER_42_564 VPWR VGND VPWR VGND sky130_ef_sc_hd__decap_40_12
XFILLER_120_60 VGND VGND VPWR VPWR sky130_fd_sc_hd__fill_1
XFILLER_80_20 VGND VGND VPWR VPWR sky130_fd_sc_hd__fill_8
XFILLER_80_53 VGND VGND VPWR VPWR sky130_fd_sc_hd__fill_4
Xfanout92 _4964_/A0 VGND VGND VPWR VPWR _5202_/A1 sky130_fd_sc_hd__clkbuf_4
Xfanout70 _2635_/Y VGND VGND VPWR VPWR _4271_/S1 sky130_fd_sc_hd__buf_4
Xfanout81 _6415_/Q VGND VGND VPWR VPWR _4961_/A0 sky130_fd_sc_hd__buf_4
XFILLER_128_625 VPWR VGND VPWR VGND sky130_ef_sc_hd__decap_40_12
XTAP_TAPCELL_ROW_12_478 VGND VPWR sky130_fd_sc_hd__tapvpwrvgnd_1
XFILLER_128_669 VPWR VGND VPWR VGND sky130_ef_sc_hd__decap_40_12
XFILLER_116_809 VGND VGND VPWR VPWR sky130_fd_sc_hd__fill_2
XANTENNA__5156__C1 _2682_/A VGND VGND VPWR VPWR sky130_fd_sc_hd__diode_2
XFILLER_6_421 VPWR VGND VPWR VGND sky130_ef_sc_hd__decap_40_12
XFILLER_115_319 VGND VGND VPWR VPWR sky130_fd_sc_hd__fill_1
XPHY_EDGE_ROW_108_Right_108 VGND VGND VPWR VPWR sky130_fd_sc_hd__decap_3
XFILLER_108_360 VGND VGND VPWR VPWR sky130_fd_sc_hd__fill_1
XANTENNA__3735__S _3745_/S VGND VGND VPWR VPWR sky130_fd_sc_hd__diode_2
XFILLER_89_51 VGND VGND VPWR VPWR sky130_fd_sc_hd__fill_1
XANTENNA__3706__A0 _5215_/A1 VGND VGND VPWR VPWR sky130_fd_sc_hd__diode_2
XANTENNA__3182__A1 _4882_/A1 VGND VGND VPWR VPWR sky130_fd_sc_hd__diode_2
XFILLER_96_203 VGND VGND VPWR VPWR sky130_fd_sc_hd__fill_1
XFILLER_2_693 VGND VGND VPWR VPWR sky130_fd_sc_hd__fill_4
XANTENNA__3470__S _3477_/S VGND VGND VPWR VPWR sky130_fd_sc_hd__diode_2
XFILLER_38_837 VGND VGND VPWR VPWR sky130_fd_sc_hd__fill_4
XANTENNA__2693__B1 _5222_/A VGND VGND VPWR VPWR sky130_fd_sc_hd__diode_2
XTAP_TAPCELL_ROW_121_2116 VGND VPWR sky130_fd_sc_hd__tapvpwrvgnd_1
XFILLER_92_475 VGND VGND VPWR VPWR sky130_fd_sc_hd__fill_1
XFILLER_52_306 VGND VGND VPWR VPWR sky130_fd_sc_hd__fill_2
X_5970_ _6334_/CLK _5970_/D VGND VGND VPWR VPWR _5970_/Q sky130_fd_sc_hd__dfxtp_1
X_4921_ _5190_/A0 _4907_/Y _4920_/X _5200_/A VGND VGND VPWR VPWR _6261_/D sky130_fd_sc_hd__o211a_1
XFILLER_52_339 VGND VGND VPWR VPWR sky130_fd_sc_hd__fill_1
XANTENNA__2996__A1 _2995_/A VGND VGND VPWR VPWR sky130_fd_sc_hd__diode_2
X_4852_ _4904_/A0 _4852_/A1 _4854_/S VGND VGND VPWR VPWR _4852_/X sky130_fd_sc_hd__mux2_1
X_3803_ input8/X _3837_/A input7/X VGND VGND VPWR VPWR _3810_/S sky130_fd_sc_hd__or3b_4
XANTENNA__2748__A1 _5232_/A0 VGND VGND VPWR VPWR sky130_fd_sc_hd__diode_2
X_4783_ _4779_/X _4781_/X _4782_/X _4791_/B1 VGND VGND VPWR VPWR _4783_/X sky130_fd_sc_hd__a22o_1
XTAP_TAPCELL_ROW_119_2078 VGND VPWR sky130_fd_sc_hd__tapvpwrvgnd_1
X_3734_ _3734_/A0 _4882_/A1 _3745_/S VGND VGND VPWR VPWR _3734_/X sky130_fd_sc_hd__mux2_1
XTAP_TAPCELL_ROW_31_765 VGND VPWR sky130_fd_sc_hd__tapvpwrvgnd_1
XTAP_TAPCELL_ROW_119_2089 VGND VPWR sky130_fd_sc_hd__tapvpwrvgnd_1
XFILLER_119_669 VGND VGND VPWR VPWR sky130_fd_sc_hd__fill_2
XFILLER_107_809 VPWR VGND VPWR VGND sky130_ef_sc_hd__decap_40_12
X_3665_ _3926_/A1 _3665_/A1 _3667_/S VGND VGND VPWR VPWR _5690_/D sky130_fd_sc_hd__mux2_1
X_5404_ _6435_/CLK hold72/X VGND VGND VPWR VPWR hold71/A sky130_fd_sc_hd__dfxtp_1
XFILLER_109_39 VGND VGND VPWR VPWR sky130_fd_sc_hd__fill_8
Xclkload62 _6394_/CLK VGND VGND VPWR VPWR clkload62/Y sky130_fd_sc_hd__inv_6
Xclkload51 _6294_/CLK VGND VGND VPWR VPWR clkload51/Y sky130_fd_sc_hd__inv_6
Xclkload40 _6120_/CLK VGND VGND VPWR VPWR clkload40/Y sky130_fd_sc_hd__clkinv_2
XTAP_TAPCELL_ROW_132_2278 VGND VPWR sky130_fd_sc_hd__tapvpwrvgnd_1
Xclkload84 _6438_/CLK VGND VGND VPWR VPWR clkload84/Y sky130_fd_sc_hd__inv_8
Xclkload73 _6129_/CLK VGND VGND VPWR VPWR clkload73/Y sky130_fd_sc_hd__clkinvlp_4
Xclkload95 _6098_/CLK VGND VGND VPWR VPWR clkload95/X sky130_fd_sc_hd__clkbuf_4
X_3596_ _3607_/A _4513_/A VGND VGND VPWR VPWR _3605_/S sky130_fd_sc_hd__nor2_4
XANTENNA__4596__S1 _4600_/A VGND VGND VPWR VPWR sky130_fd_sc_hd__diode_2
XANTENNA__4370__A0 _5053_/A1 VGND VGND VPWR VPWR sky130_fd_sc_hd__diode_2
X_6384_ _6408_/CLK hold1/X VGND VGND VPWR VPWR _6384_/Q sky130_fd_sc_hd__dfxtp_1
XANTENNA__3173__A1 _4272_/S VGND VGND VPWR VPWR sky130_fd_sc_hd__diode_2
X_5335_ _6239_/CLK _5335_/D VGND VGND VPWR VPWR _5335_/Q sky130_fd_sc_hd__dfxtp_1
XANTENNA__2920__A1 _3036_/A1 VGND VGND VPWR VPWR sky130_fd_sc_hd__diode_2
XFILLER_125_27 VPWR VGND VPWR VGND sky130_ef_sc_hd__decap_40_12
XFILLER_88_737 VPWR VGND VPWR VGND sky130_ef_sc_hd__decap_40_12
XFILLER_87_225 VGND VGND VPWR VPWR sky130_fd_sc_hd__fill_1
X_5266_ _6398_/CLK _5266_/D VGND VGND VPWR VPWR _5266_/Q sky130_fd_sc_hd__dfxtp_1
XFILLER_102_569 VPWR VGND VPWR VGND sky130_ef_sc_hd__decap_40_12
X_4217_ _4260_/S _4216_/X _4210_/Y _5343_/Q VGND VGND VPWR VPWR _4218_/B sky130_fd_sc_hd__o211a_1
XFILLER_96_781 VPWR VGND VPWR VGND sky130_ef_sc_hd__decap_40_12
X_5197_ _5175_/S _5196_/X _5197_/B1 _5085_/A VGND VGND VPWR VPWR _5197_/Y sky130_fd_sc_hd__a211oi_1
XFILLER_28_314 VGND VGND VPWR VPWR sky130_fd_sc_hd__fill_1
XFILLER_29_837 VGND VGND VPWR VPWR sky130_fd_sc_hd__fill_2
XANTENNA__2684__B1 _5222_/A VGND VGND VPWR VPWR sky130_fd_sc_hd__diode_2
X_4148_ hold41/A hold39/A _5932_/Q _6321_/Q _4228_/S _4263_/A VGND VGND VPWR VPWR
+ _4149_/B sky130_fd_sc_hd__mux4_1
XFILLER_56_645 VGND VGND VPWR VPWR sky130_fd_sc_hd__fill_1
XFILLER_71_615 VGND VGND VPWR VPWR sky130_fd_sc_hd__fill_1
XTAP_TAPCELL_ROW_48_1018 VGND VPWR sky130_fd_sc_hd__tapvpwrvgnd_1
X_4079_ _5780_/Q _5908_/Q _4237_/S VGND VGND VPWR VPWR _4080_/B sky130_fd_sc_hd__mux2_1
XTAP_TAPCELL_ROW_39_887 VGND VPWR sky130_fd_sc_hd__tapvpwrvgnd_1
XANTENNA__4425__B2 _4424_/X VGND VGND VPWR VPWR sky130_fd_sc_hd__diode_2
XTAP_TAPCELL_ROW_61_1218 VGND VPWR sky130_fd_sc_hd__tapvpwrvgnd_1
XFILLER_12_737 VPWR VGND VPWR VGND sky130_ef_sc_hd__decap_40_12
XFILLER_11_225 VGND VGND VPWR VPWR sky130_fd_sc_hd__fill_1
XANTENNA__3936__A0 _4982_/A1 VGND VGND VPWR VPWR sky130_fd_sc_hd__diode_2
Xclkload1 clkload1/A VGND VGND VPWR VPWR clkload1/Y sky130_fd_sc_hd__clkinv_8
XFILLER_20_781 VPWR VGND VPWR VGND sky130_ef_sc_hd__decap_40_12
XFILLER_125_617 VPWR VGND VPWR VGND sky130_ef_sc_hd__decap_40_12
XFILLER_124_116 VGND VGND VPWR VPWR sky130_fd_sc_hd__fill_1
XFILLER_119_3 VPWR VGND VPWR VGND sky130_ef_sc_hd__decap_40_12
XANTENNA__3164__A1 _4213_/S VGND VGND VPWR VPWR sky130_fd_sc_hd__diode_2
XANTENNA__4587__S1 _4809_/A VGND VGND VPWR VPWR sky130_fd_sc_hd__diode_2
XFILLER_120_322 VGND VGND VPWR VPWR sky130_fd_sc_hd__fill_1
XANTENNA__4894__B _5069_/B VGND VGND VPWR VPWR sky130_fd_sc_hd__diode_2
XFILLER_105_374 VGND VGND VPWR VPWR sky130_fd_sc_hd__fill_1
XANTENNA_fanout81_X _4961_/A0 VGND VGND VPWR VPWR sky130_fd_sc_hd__diode_2
XANTENNA__4113__B1 _3172_/B VGND VGND VPWR VPWR sky130_fd_sc_hd__diode_2
XANTENNA__3290__S _3295_/S VGND VGND VPWR VPWR sky130_fd_sc_hd__diode_2
XFILLER_115_71 VGND VGND VPWR VPWR sky130_fd_sc_hd__fill_4
XFILLER_87_781 VGND VGND VPWR VPWR sky130_fd_sc_hd__fill_2
XFILLER_75_20 VPWR VGND VPWR VGND sky130_ef_sc_hd__decap_40_12
XFILLER_74_442 VGND VGND VPWR VPWR sky130_fd_sc_hd__fill_8
XFILLER_61_158 VGND VGND VPWR VPWR sky130_fd_sc_hd__fill_1
XFILLER_15_553 VGND VGND VPWR VPWR sky130_fd_sc_hd__fill_4
XTAP_TAPCELL_ROW_17_548 VGND VPWR sky130_fd_sc_hd__tapvpwrvgnd_1
XTAP_TAPCELL_ROW_17_559 VGND VPWR sky130_fd_sc_hd__tapvpwrvgnd_1
XFILLER_15_597 VPWR VGND VPWR VGND sky130_ef_sc_hd__decap_40_12
XFILLER_30_578 VGND VGND VPWR VPWR sky130_fd_sc_hd__fill_2
XANTENNA__2825__S1 _2962_/A VGND VGND VPWR VPWR sky130_fd_sc_hd__diode_2
XFILLER_7_741 VPWR VGND VPWR VGND sky130_ef_sc_hd__decap_40_12
XFILLER_11_781 VGND VGND VPWR VPWR sky130_fd_sc_hd__fill_2
Xhold719 _4883_/X VGND VGND VPWR VPWR _6232_/D sky130_fd_sc_hd__dlygate4sd3_1
XFILLER_7_785 VPWR VGND VPWR VGND sky130_ef_sc_hd__decap_40_12
Xhold708 _5735_/Q VGND VGND VPWR VPWR hold708/X sky130_fd_sc_hd__dlygate4sd3_1
X_3450_ hold10/X _5237_/A0 _3450_/S VGND VGND VPWR VPWR hold11/A sky130_fd_sc_hd__mux2_1
XFILLER_131_609 VGND VGND VPWR VPWR sky130_fd_sc_hd__fill_4
X_3381_ _3381_/A1 _4457_/S _3379_/X _3380_/X VGND VGND VPWR VPWR _3381_/X sky130_fd_sc_hd__o22a_1
XANTENNA__2902__A1 _3036_/A1 VGND VGND VPWR VPWR sky130_fd_sc_hd__diode_2
Xhold2109 _5438_/Q VGND VGND VPWR VPWR _3375_/A1 sky130_fd_sc_hd__dlygate4sd3_1
XFILLER_69_225 VGND VGND VPWR VPWR sky130_fd_sc_hd__fill_4
XFILLER_69_203 VGND VGND VPWR VPWR sky130_fd_sc_hd__fill_2
X_5120_ _5916_/Q _5118_/Y _5119_/Y VGND VGND VPWR VPWR _5120_/X sky130_fd_sc_hd__o21a_1
XFILLER_34_3 VPWR VGND VPWR VGND sky130_ef_sc_hd__decap_40_12
X_5051_ hold509/X _5051_/A1 _5059_/S VGND VGND VPWR VPWR _5051_/X sky130_fd_sc_hd__mux2_1
Xhold1419 _5370_/Q VGND VGND VPWR VPWR _3210_/A1 sky130_fd_sc_hd__dlygate4sd3_1
X_4002_ _4002_/A _4002_/B _3967_/X VGND VGND VPWR VPWR _5096_/B sky130_fd_sc_hd__or3b_1
Xhold1408 _5791_/Q VGND VGND VPWR VPWR _3783_/A0 sky130_fd_sc_hd__dlygate4sd3_1
XANTENNA__4750__S1 _4809_/A VGND VGND VPWR VPWR sky130_fd_sc_hd__diode_2
XFILLER_37_111 VGND VGND VPWR VPWR sky130_fd_sc_hd__fill_1
XFILLER_65_497 VGND VGND VPWR VPWR sky130_fd_sc_hd__fill_1
XTAP_TAPCELL_ROW_36_835 VGND VPWR sky130_fd_sc_hd__tapvpwrvgnd_1
X_5953_ _6341_/CLK _5953_/D VGND VGND VPWR VPWR _5953_/Q sky130_fd_sc_hd__dfxtp_1
XPHY_EDGE_ROW_9_Left_148 VGND VGND VPWR VPWR sky130_fd_sc_hd__decap_3
XTAP_TAPCELL_ROW_36_846 VGND VPWR sky130_fd_sc_hd__tapvpwrvgnd_1
X_4904_ _4904_/A0 _4904_/A1 _4906_/S VGND VGND VPWR VPWR _4904_/X sky130_fd_sc_hd__mux2_1
XTAP_TAPCELL_ROW_101_1819 VGND VPWR sky130_fd_sc_hd__tapvpwrvgnd_1
XTAP_TAPCELL_ROW_101_1808 VGND VPWR sky130_fd_sc_hd__tapvpwrvgnd_1
XFILLER_21_501 VGND VGND VPWR VPWR sky130_fd_sc_hd__fill_2
X_5884_ _6121_/CLK _5884_/D VGND VGND VPWR VPWR _5884_/Q sky130_fd_sc_hd__dfxtp_1
XFILLER_40_309 VGND VGND VPWR VPWR sky130_fd_sc_hd__fill_4
X_4835_ _4887_/A1 _4835_/A1 _4841_/S VGND VGND VPWR VPWR _4835_/X sky130_fd_sc_hd__mux2_1
XTAP_TAPCELL_ROW_134_2307 VGND VPWR sky130_fd_sc_hd__tapvpwrvgnd_1
X_4766_ _5803_/Q _5794_/Q _4801_/S VGND VGND VPWR VPWR _4767_/B sky130_fd_sc_hd__mux2_1
XANTENNA__3394__A1 _5040_/A1 VGND VGND VPWR VPWR sky130_fd_sc_hd__diode_2
X_3717_ _3717_/A0 _4984_/A1 _3717_/S VGND VGND VPWR VPWR _3717_/X sky130_fd_sc_hd__mux2_1
XFILLER_107_617 VPWR VGND VPWR VGND sky130_ef_sc_hd__decap_40_12
XFILLER_20_15 VGND VGND VPWR VPWR sky130_fd_sc_hd__fill_8
X_4697_ _4809_/A _4697_/B VGND VGND VPWR VPWR _4697_/X sky130_fd_sc_hd__or2_1
XFILLER_136_15 VPWR VGND VPWR VGND sky130_ef_sc_hd__decap_40_12
X_6436_ _6438_/CLK _6436_/D VGND VGND VPWR VPWR _6436_/Q sky130_fd_sc_hd__dfxtp_1
X_3648_ _4493_/B _3648_/B VGND VGND VPWR VPWR _3657_/S sky130_fd_sc_hd__nor2_4
XANTENNA__4060__A _4260_/S VGND VGND VPWR VPWR sky130_fd_sc_hd__diode_2
X_6367_ _6429_/CLK _6367_/D VGND VGND VPWR VPWR _6367_/Q sky130_fd_sc_hd__dfxtp_1
X_3579_ hold47/X _5211_/A1 _3584_/S VGND VGND VPWR VPWR hold48/A sky130_fd_sc_hd__mux2_1
X_5318_ _6435_/CLK _5318_/D VGND VGND VPWR VPWR _5318_/Q sky130_fd_sc_hd__dfxtp_1
XFILLER_102_311 VGND VGND VPWR VPWR sky130_fd_sc_hd__fill_1
Xhold13 hold13/A VGND VGND VPWR VPWR hold13/X sky130_fd_sc_hd__dlygate4sd3_1
X_6298_ _6298_/CLK _6298_/D VGND VGND VPWR VPWR _6298_/Q sky130_fd_sc_hd__dfxtp_1
XFILLER_0_449 VPWR VGND VPWR VGND sky130_ef_sc_hd__decap_40_12
XFILLER_130_697 VGND VGND VPWR VPWR sky130_fd_sc_hd__fill_2
Xhold24 hold24/A VGND VGND VPWR VPWR hold24/X sky130_fd_sc_hd__dlygate4sd3_1
X_5249_ _6254_/CLK _5249_/D VGND VGND VPWR VPWR _5249_/Q sky130_fd_sc_hd__dfxtp_1
XFILLER_69_770 VPWR VGND VPWR VGND sky130_ef_sc_hd__decap_40_12
Xhold35 hold35/A VGND VGND VPWR VPWR hold35/X sky130_fd_sc_hd__dlygate4sd3_1
Xhold46 hold46/A VGND VGND VPWR VPWR hold46/X sky130_fd_sc_hd__dlygate4sd3_1
Xhold1920 _3938_/X VGND VGND VPWR VPWR _5914_/D sky130_fd_sc_hd__dlygate4sd3_1
Xhold79 hold79/A VGND VGND VPWR VPWR hold79/X sky130_fd_sc_hd__dlygate4sd3_1
Xhold1953 _3149_/X VGND VGND VPWR VPWR _5330_/D sky130_fd_sc_hd__dlygate4sd3_1
XFILLER_68_280 VGND VGND VPWR VPWR sky130_fd_sc_hd__fill_1
Xhold1942 _6284_/Q VGND VGND VPWR VPWR _4949_/A1 sky130_fd_sc_hd__dlygate4sd3_1
Xhold68 hold68/A VGND VGND VPWR VPWR hold68/X sky130_fd_sc_hd__dlygate4sd3_1
Xhold1931 _5911_/Q VGND VGND VPWR VPWR _3935_/A1 sky130_fd_sc_hd__dlygate4sd3_1
Xhold57 hold57/A VGND VGND VPWR VPWR hold57/X sky130_fd_sc_hd__dlygate4sd3_1
Xhold1964 _5335_/Q VGND VGND VPWR VPWR _5065_/A0 sky130_fd_sc_hd__dlygate4sd3_1
Xhold1997 _4591_/X VGND VGND VPWR VPWR _6162_/D sky130_fd_sc_hd__dlygate4sd3_1
Xhold1975 _4677_/X VGND VGND VPWR VPWR _6165_/D sky130_fd_sc_hd__dlygate4sd3_1
XANTENNA__4934__S _4934_/S VGND VGND VPWR VPWR sky130_fd_sc_hd__diode_2
Xhold1986 _5338_/Q VGND VGND VPWR VPWR _5035_/A sky130_fd_sc_hd__dlygate4sd3_1
XFILLER_71_434 VGND VGND VPWR VPWR sky130_fd_sc_hd__fill_4
XFILLER_71_423 VGND VGND VPWR VPWR sky130_fd_sc_hd__fill_1
XFILLER_16_317 VGND VGND VPWR VPWR sky130_fd_sc_hd__fill_4
XFILLER_43_136 VGND VGND VPWR VPWR sky130_fd_sc_hd__fill_2
XFILLER_12_501 VPWR VGND VPWR VGND sky130_ef_sc_hd__decap_40_12
XTAP_TAPCELL_ROW_14_507 VGND VPWR sky130_fd_sc_hd__tapvpwrvgnd_1
XFILLER_12_545 VPWR VGND VPWR VGND sky130_ef_sc_hd__decap_40_12
XFILLER_12_589 VPWR VGND VPWR VGND sky130_ef_sc_hd__decap_40_12
XANTENNA__2807__S1 _3005_/A VGND VGND VPWR VPWR sky130_fd_sc_hd__diode_2
XANTENNA__3385__A1 _4929_/A1 VGND VGND VPWR VPWR sky130_fd_sc_hd__diode_2
XFILLER_138_797 VGND VGND VPWR VPWR sky130_fd_sc_hd__fill_4
XANTENNA__3285__S _3295_/S VGND VGND VPWR VPWR sky130_fd_sc_hd__diode_2
XFILLER_125_436 VGND VGND VPWR VPWR sky130_fd_sc_hd__fill_1
XTAP_TAPCELL_ROW_74_1409 VGND VPWR sky130_fd_sc_hd__tapvpwrvgnd_1
XFILLER_113_609 VGND VGND VPWR VPWR sky130_fd_sc_hd__fill_4
XFILLER_79_501 VGND VGND VPWR VPWR sky130_fd_sc_hd__fill_1
XFILLER_4_755 VGND VGND VPWR VPWR sky130_fd_sc_hd__fill_1
XANTENNA__4334__A0 _5046_/A1 VGND VGND VPWR VPWR sky130_fd_sc_hd__diode_2
XANTENNA__4885__A1 _5818_/Q VGND VGND VPWR VPWR sky130_fd_sc_hd__diode_2
XFILLER_126_70 VGND VGND VPWR VPWR sky130_fd_sc_hd__fill_2
XFILLER_121_653 VPWR VGND VPWR VGND sky130_ef_sc_hd__decap_40_12
XFILLER_105_193 VGND VGND VPWR VPWR sky130_fd_sc_hd__fill_2
XFILLER_67_707 VGND VGND VPWR VPWR sky130_fd_sc_hd__fill_2
XFILLER_121_697 VPWR VGND VPWR VGND sky130_ef_sc_hd__decap_40_12
XFILLER_120_141 VGND VGND VPWR VPWR sky130_fd_sc_hd__fill_2
XFILLER_67_729 VGND VGND VPWR VPWR sky130_fd_sc_hd__fill_2
XANTENNA__4637__A1 _4811_/A1 VGND VGND VPWR VPWR sky130_fd_sc_hd__diode_2
XTAP_TAPCELL_ROW_89_1641 VGND VPWR sky130_fd_sc_hd__tapvpwrvgnd_1
XTAP_TAPCELL_ROW_89_1630 VGND VPWR sky130_fd_sc_hd__tapvpwrvgnd_1
XFILLER_86_85 VGND VGND VPWR VPWR sky130_fd_sc_hd__fill_1
XANTENNA__3845__C1 _5176_/A VGND VGND VPWR VPWR sky130_fd_sc_hd__diode_2
XANTENNA__4844__S _4854_/S VGND VGND VPWR VPWR sky130_fd_sc_hd__diode_2
XFILLER_19_155 VGND VGND VPWR VPWR sky130_fd_sc_hd__fill_4
XANTENNA_clkload4_A clkload4/A VGND VGND VPWR VPWR sky130_fd_sc_hd__diode_2
XFILLER_74_272 VGND VGND VPWR VPWR sky130_fd_sc_hd__fill_4
XFILLER_35_615 VGND VGND VPWR VPWR sky130_fd_sc_hd__fill_1
XFILLER_34_158 VGND VGND VPWR VPWR sky130_fd_sc_hd__fill_2
X_2950_ _6177_/Q _6201_/Q _6189_/Q _5483_/Q _3062_/S _3005_/A VGND VGND VPWR VPWR
+ _2950_/X sky130_fd_sc_hd__mux4_1
XFILLER_31_821 VPWR VGND VPWR VGND sky130_ef_sc_hd__decap_40_12
X_2881_ _2874_/X _2880_/X _3083_/S VGND VGND VPWR VPWR _2881_/X sky130_fd_sc_hd__mux2_1
X_4620_ _4789_/A _4620_/B VGND VGND VPWR VPWR _4620_/X sky130_fd_sc_hd__or2_1
XANTENNA__4432__X _4432_/X VGND VGND VPWR VPWR sky130_fd_sc_hd__diode_2
XFILLER_30_353 VGND VGND VPWR VPWR sky130_fd_sc_hd__fill_2
XFILLER_129_753 VPWR VGND VPWR VGND sky130_ef_sc_hd__decap_40_12
XFILLER_129_797 VPWR VGND VPWR VGND sky130_ef_sc_hd__decap_40_12
XTAP_TAPCELL_ROW_116_2037 VGND VPWR sky130_fd_sc_hd__tapvpwrvgnd_1
X_4551_ hold224/X _4883_/A1 _4561_/S VGND VGND VPWR VPWR _4551_/X sky130_fd_sc_hd__mux2_1
Xhold505 _5503_/Q VGND VGND VPWR VPWR hold505/X sky130_fd_sc_hd__dlygate4sd3_1
X_3502_ _4905_/A0 _3502_/A1 _3503_/S VGND VGND VPWR VPWR _3502_/X sky130_fd_sc_hd__mux2_1
Xhold527 _3884_/X VGND VGND VPWR VPWR _5864_/D sky130_fd_sc_hd__dlygate4sd3_1
Xhold516 _5631_/Q VGND VGND VPWR VPWR hold516/X sky130_fd_sc_hd__dlygate4sd3_1
X_4482_ hold361/X _5202_/A1 _4482_/S VGND VGND VPWR VPWR _4482_/X sky130_fd_sc_hd__mux2_1
Xhold549 _5317_/Q VGND VGND VPWR VPWR hold549/X sky130_fd_sc_hd__dlygate4sd3_1
XANTENNA__3208__B _5069_/B VGND VGND VPWR VPWR sky130_fd_sc_hd__diode_2
X_6221_ _6233_/CLK _6221_/D VGND VGND VPWR VPWR _6221_/Q sky130_fd_sc_hd__dfxtp_1
X_3433_ _3433_/A0 _4889_/A1 _3437_/S VGND VGND VPWR VPWR _3433_/X sky130_fd_sc_hd__mux2_1
Xhold538 _5659_/Q VGND VGND VPWR VPWR hold538/X sky130_fd_sc_hd__dlygate4sd3_1
X_6152_ _6233_/CLK _6152_/D VGND VGND VPWR VPWR _6152_/Q sky130_fd_sc_hd__dfxtp_1
XANTENNA__4876__A1 _4889_/A1 VGND VGND VPWR VPWR sky130_fd_sc_hd__diode_2
XFILLER_106_29 VPWR VGND VPWR VGND sky130_ef_sc_hd__decap_40_12
X_5103_ _3972_/A _5100_/Y _5101_/Y _5102_/Y _5034_/B VGND VGND VPWR VPWR _5103_/X
+ sky130_fd_sc_hd__o311a_1
X_3364_ hold877/X _5035_/C _5201_/B _6343_/Q VGND VGND VPWR VPWR _3364_/X sky130_fd_sc_hd__a22o_1
Xhold1205 _5080_/X VGND VGND VPWR VPWR _6371_/D sky130_fd_sc_hd__dlygate4sd3_1
X_3295_ hold220/X _4906_/A0 _3295_/S VGND VGND VPWR VPWR _3295_/X sky130_fd_sc_hd__mux2_1
XTAP_TAPCELL_ROW_111_1970 VGND VPWR sky130_fd_sc_hd__tapvpwrvgnd_1
XFILLER_85_526 VGND VGND VPWR VPWR sky130_fd_sc_hd__fill_2
X_6083_ _6414_/CLK _6083_/D VGND VGND VPWR VPWR _6083_/Q sky130_fd_sc_hd__dfxtp_1
Xhold1216 _4363_/X VGND VGND VPWR VPWR _6005_/D sky130_fd_sc_hd__dlygate4sd3_1
XFILLER_112_697 VGND VGND VPWR VPWR sky130_fd_sc_hd__fill_2
XFILLER_100_837 VGND VGND VPWR VPWR sky130_fd_sc_hd__fill_4
Xhold1227 _5582_/Q VGND VGND VPWR VPWR _3539_/A0 sky130_fd_sc_hd__dlygate4sd3_1
X_5034_ _5034_/A _5034_/B _5034_/C VGND VGND VPWR VPWR _5034_/X sky130_fd_sc_hd__and3_1
Xhold1238 _5775_/Q VGND VGND VPWR VPWR _3764_/A0 sky130_fd_sc_hd__dlygate4sd3_1
Xhold1249 _4401_/X VGND VGND VPWR VPWR _6039_/D sky130_fd_sc_hd__dlygate4sd3_1
XANTENNA__3300__A1 _4846_/A0 VGND VGND VPWR VPWR sky130_fd_sc_hd__diode_2
XFILLER_66_751 VGND VGND VPWR VPWR sky130_fd_sc_hd__fill_4
XTAP_TAPCELL_ROW_127_2199 VGND VPWR sky130_fd_sc_hd__tapvpwrvgnd_1
XFILLER_65_283 VGND VGND VPWR VPWR sky130_fd_sc_hd__fill_2
XFILLER_38_475 VGND VGND VPWR VPWR sky130_fd_sc_hd__fill_1
XANTENNA__5053__A1 _5053_/A1 VGND VGND VPWR VPWR sky130_fd_sc_hd__diode_2
XTAP_TAPCELL_ROW_0_279 VGND VPWR sky130_fd_sc_hd__tapvpwrvgnd_1
X_5936_ _6342_/CLK _5936_/D VGND VGND VPWR VPWR _5936_/Q sky130_fd_sc_hd__dfxtp_1
XFILLER_15_15 VGND VGND VPWR VPWR sky130_fd_sc_hd__fill_4
XANTENNA__4055__A _4241_/A VGND VGND VPWR VPWR sky130_fd_sc_hd__diode_2
X_5867_ _5870_/CLK _5867_/D VGND VGND VPWR VPWR _5867_/Q sky130_fd_sc_hd__dfxtp_1
XANTENNA_fanout131_X _4889_/A1 VGND VGND VPWR VPWR sky130_fd_sc_hd__diode_2
X_4818_ _4883_/A1 _4818_/A1 _4828_/S VGND VGND VPWR VPWR _6172_/D sky130_fd_sc_hd__mux2_1
XFILLER_21_375 VPWR VGND VPWR VGND sky130_ef_sc_hd__decap_40_12
X_5798_ _6414_/CLK _5798_/D VGND VGND VPWR VPWR _5798_/Q sky130_fd_sc_hd__dfxtp_1
X_4749_ _4811_/C1 _4748_/X _4747_/X VGND VGND VPWR VPWR _4749_/Y sky130_fd_sc_hd__a21oi_1
XFILLER_107_436 VGND VGND VPWR VPWR sky130_fd_sc_hd__fill_4
XANTENNA__3119__A1 _4899_/A0 VGND VGND VPWR VPWR sky130_fd_sc_hd__diode_2
XTAP_TAPCELL_ROW_56_1139 VGND VPWR sky130_fd_sc_hd__tapvpwrvgnd_1
XANTENNA__4929__S _4934_/S VGND VGND VPWR VPWR sky130_fd_sc_hd__diode_2
X_6419_ _6420_/CLK input1/X VGND VGND VPWR VPWR _6419_/Q sky130_fd_sc_hd__dfxtp_1
XFILLER_122_439 VGND VGND VPWR VPWR sky130_fd_sc_hd__fill_4
Xoutput36 _6461_/A VGND VGND VPWR VPWR s_axil_awready sky130_fd_sc_hd__buf_2
XFILLER_89_821 VPWR VGND VPWR VGND sky130_ef_sc_hd__decap_40_12
Xoutput47 _6060_/Q VGND VGND VPWR VPWR s_axil_rdata[3] sky130_fd_sc_hd__buf_2
XFILLER_1_725 VGND VGND VPWR VPWR sky130_fd_sc_hd__fill_2
XANTENNA__2878__B1 _3094_/C1 VGND VGND VPWR VPWR sky130_fd_sc_hd__diode_2
XFILLER_103_653 VPWR VGND VPWR VGND sky130_ef_sc_hd__decap_40_12
XFILLER_0_213 VGND VGND VPWR VPWR sky130_fd_sc_hd__fill_2
XFILLER_103_697 VPWR VGND VPWR VGND sky130_ef_sc_hd__decap_40_12
XFILLER_102_174 VGND VGND VPWR VPWR sky130_fd_sc_hd__fill_1
XFILLER_76_548 VGND VGND VPWR VPWR sky130_fd_sc_hd__fill_2
XANTENNA__4714__S1 _4792_/A1 VGND VGND VPWR VPWR sky130_fd_sc_hd__diode_2
Xhold1750 _6092_/Q VGND VGND VPWR VPWR _4486_/A1 sky130_fd_sc_hd__dlygate4sd3_1
XFILLER_63_209 VGND VGND VPWR VPWR sky130_fd_sc_hd__fill_1
Xhold1761 _4404_/X VGND VGND VPWR VPWR _6042_/D sky130_fd_sc_hd__dlygate4sd3_1
XFILLER_57_762 VPWR VGND VPWR VGND sky130_ef_sc_hd__decap_40_12
XANTENNA__4664__S _4803_/S VGND VGND VPWR VPWR sky130_fd_sc_hd__diode_2
XFILLER_29_453 VGND VGND VPWR VPWR sky130_fd_sc_hd__fill_1
Xhold1772 _5405_/Q VGND VGND VPWR VPWR _3286_/A0 sky130_fd_sc_hd__dlygate4sd3_1
Xhold1783 _4828_/X VGND VGND VPWR VPWR _6182_/D sky130_fd_sc_hd__dlygate4sd3_1
Xhold1794 _5763_/Q VGND VGND VPWR VPWR _4107_/A0 sky130_fd_sc_hd__dlygate4sd3_1
XFILLER_17_615 VGND VGND VPWR VPWR sky130_fd_sc_hd__fill_1
XFILLER_72_765 VGND VGND VPWR VPWR sky130_fd_sc_hd__fill_8
XANTENNA__5044__A1 _5044_/A1 VGND VGND VPWR VPWR sky130_fd_sc_hd__diode_2
XFILLER_44_434 VGND VGND VPWR VPWR sky130_fd_sc_hd__fill_2
XTAP_TAPCELL_ROW_84_1560 VGND VPWR sky130_fd_sc_hd__tapvpwrvgnd_1
XFILLER_25_670 VGND VGND VPWR VPWR sky130_fd_sc_hd__fill_2
XFILLER_32_618 VGND VGND VPWR VPWR sky130_fd_sc_hd__fill_1
XFILLER_13_821 VPWR VGND VPWR VGND sky130_ef_sc_hd__decap_40_12
XTAP_TAPCELL_ROW_27_698 VGND VPWR sky130_fd_sc_hd__tapvpwrvgnd_1
XFILLER_31_128 VGND VGND VPWR VPWR sky130_fd_sc_hd__fill_2
XANTENNA__2912__S _2984_/S VGND VGND VPWR VPWR sky130_fd_sc_hd__diode_2
XANTENNA__2802__B1 _2995_/A VGND VGND VPWR VPWR sky130_fd_sc_hd__diode_2
XFILLER_12_331 VPWR VGND VPWR VGND sky130_ef_sc_hd__decap_40_12
XFILLER_12_353 VGND VGND VPWR VPWR sky130_fd_sc_hd__fill_8
XFILLER_138_561 VPWR VGND VPWR VGND sky130_ef_sc_hd__decap_40_12
XFILLER_126_701 VPWR VGND VPWR VGND sky130_ef_sc_hd__decap_40_12
XANTENNA__4839__S _4841_/S VGND VGND VPWR VPWR sky130_fd_sc_hd__diode_2
XFILLER_113_406 VGND VGND VPWR VPWR sky130_fd_sc_hd__fill_1
XFILLER_99_629 VPWR VGND VPWR VGND sky130_ef_sc_hd__decap_40_12
XANTENNA__3743__S _3745_/S VGND VGND VPWR VPWR sky130_fd_sc_hd__diode_2
XFILLER_4_585 VGND VGND VPWR VPWR sky130_fd_sc_hd__fill_2
XANTENNA__3530__A1 _4882_/A1 VGND VGND VPWR VPWR sky130_fd_sc_hd__diode_2
XANTENNA__3044__A _3044_/A VGND VGND VPWR VPWR sky130_fd_sc_hd__diode_2
X_3080_ _3050_/A _3077_/X _3078_/X _3079_/X _3094_/C1 VGND VGND VPWR VPWR _3080_/X
+ sky130_fd_sc_hd__o221a_1
XFILLER_79_397 VGND VGND VPWR VPWR sky130_fd_sc_hd__fill_2
XANTENNA__2883__A _3085_/A VGND VGND VPWR VPWR sky130_fd_sc_hd__diode_2
XFILLER_63_710 VGND VGND VPWR VPWR sky130_fd_sc_hd__fill_2
XFILLER_48_795 VPWR VGND VPWR VGND sky130_ef_sc_hd__decap_40_12
XFILLER_47_283 VGND VGND VPWR VPWR sky130_fd_sc_hd__fill_1
XFILLER_47_261 VGND VGND VPWR VPWR sky130_fd_sc_hd__fill_1
XFILLER_35_401 VGND VGND VPWR VPWR sky130_fd_sc_hd__fill_4
XANTENNA__3046__B1 _3075_/C1 VGND VGND VPWR VPWR sky130_fd_sc_hd__diode_2
X_3982_ _4013_/B _3988_/B _5117_/A VGND VGND VPWR VPWR _3982_/Y sky130_fd_sc_hd__o21ai_1
XTAP_TAPCELL_ROW_46_985 VGND VPWR sky130_fd_sc_hd__tapvpwrvgnd_1
X_2933_ _3020_/A _2933_/B VGND VGND VPWR VPWR _2933_/X sky130_fd_sc_hd__or2_1
XANTENNA__3597__A1 _5208_/A1 VGND VGND VPWR VPWR sky130_fd_sc_hd__diode_2
X_5721_ _6294_/CLK _5721_/D VGND VGND VPWR VPWR _5721_/Q sky130_fd_sc_hd__dfxtp_1
XTAP_TAPCELL_ROW_46_996 VGND VPWR sky130_fd_sc_hd__tapvpwrvgnd_1
XFILLER_16_681 VPWR VGND VPWR VGND sky130_ef_sc_hd__decap_40_12
XPHY_EDGE_ROW_99_Left_238 VGND VGND VPWR VPWR sky130_fd_sc_hd__decap_3
XFILLER_31_662 VGND VGND VPWR VPWR sky130_fd_sc_hd__fill_8
X_2864_ _6438_/Q _6246_/Q _5406_/Q _5504_/Q _3033_/S _3050_/A VGND VGND VPWR VPWR
+ _2864_/X sky130_fd_sc_hd__mux4_1
X_5652_ _5682_/CLK _5652_/D VGND VGND VPWR VPWR _5652_/Q sky130_fd_sc_hd__dfxtp_1
XFILLER_30_172 VGND VGND VPWR VPWR sky130_fd_sc_hd__fill_2
XFILLER_31_673 VGND VGND VPWR VPWR sky130_fd_sc_hd__fill_2
XFILLER_129_561 VPWR VGND VPWR VGND sky130_ef_sc_hd__decap_40_12
X_2795_ _2788_/X _2794_/X _3083_/S VGND VGND VPWR VPWR _2795_/X sky130_fd_sc_hd__mux2_1
X_5583_ _5583_/CLK _5583_/D VGND VGND VPWR VPWR _5583_/Q sky130_fd_sc_hd__dfxtp_1
X_4603_ _4663_/A _4598_/X _4600_/X _4602_/X VGND VGND VPWR VPWR _4603_/X sky130_fd_sc_hd__a22o_1
X_4534_ hold383/X _5080_/A0 _4535_/S VGND VGND VPWR VPWR _4534_/X sky130_fd_sc_hd__mux2_1
Xhold302 _3793_/X VGND VGND VPWR VPWR _5800_/D sky130_fd_sc_hd__dlygate4sd3_1
Xhold313 _6064_/Q VGND VGND VPWR VPWR hold313/X sky130_fd_sc_hd__dlygate4sd3_1
Xhold324 _3458_/X VGND VGND VPWR VPWR _5507_/D sky130_fd_sc_hd__dlygate4sd3_1
Xhold335 _5902_/Q VGND VGND VPWR VPWR hold335/X sky130_fd_sc_hd__dlygate4sd3_1
X_4465_ _5817_/Q hold564/X _4472_/S VGND VGND VPWR VPWR _4465_/X sky130_fd_sc_hd__mux2_1
XFILLER_132_737 VPWR VGND VPWR VGND sky130_ef_sc_hd__decap_40_12
Xhold368 _2674_/X VGND VGND VPWR VPWR _5247_/D sky130_fd_sc_hd__dlygate4sd3_1
XFILLER_117_39 VGND VGND VPWR VPWR sky130_fd_sc_hd__fill_8
XFILLER_89_128 VGND VGND VPWR VPWR sky130_fd_sc_hd__fill_2
Xhold346 _3622_/X VGND VGND VPWR VPWR _5651_/D sky130_fd_sc_hd__dlygate4sd3_1
Xhold357 _5668_/Q VGND VGND VPWR VPWR hold357/X sky130_fd_sc_hd__dlygate4sd3_1
X_6204_ _6241_/CLK _6204_/D VGND VGND VPWR VPWR _6204_/Q sky130_fd_sc_hd__dfxtp_1
Xhold379 _6131_/Q VGND VGND VPWR VPWR hold379/X sky130_fd_sc_hd__dlygate4sd3_1
X_3416_ _3416_/A0 _5209_/A1 _3423_/S VGND VGND VPWR VPWR _3416_/X sky130_fd_sc_hd__mux2_1
X_4396_ _4984_/A1 _4396_/A1 _4396_/S VGND VGND VPWR VPWR _4396_/X sky130_fd_sc_hd__mux2_1
XTAP_TAPCELL_ROW_129_2239 VGND VPWR sky130_fd_sc_hd__tapvpwrvgnd_1
XTAP_TAPCELL_ROW_129_2228 VGND VPWR sky130_fd_sc_hd__tapvpwrvgnd_1
XFILLER_100_601 VPWR VGND VPWR VGND sky130_ef_sc_hd__decap_40_12
X_6135_ _6137_/CLK _6135_/D VGND VGND VPWR VPWR _6135_/Q sky130_fd_sc_hd__dfxtp_1
XANTENNA__2955__S0 _3091_/S VGND VGND VPWR VPWR sky130_fd_sc_hd__diode_2
XFILLER_86_813 VPWR VGND VPWR VGND sky130_ef_sc_hd__decap_40_12
X_3347_ _3315_/X _5060_/A _5099_/B VGND VGND VPWR VPWR _4997_/B sky130_fd_sc_hd__o21ai_2
XFILLER_133_27 VPWR VGND VPWR VGND sky130_ef_sc_hd__decap_40_12
Xhold1013 _4536_/X VGND VGND VPWR VPWR _6138_/D sky130_fd_sc_hd__dlygate4sd3_1
XFILLER_100_645 VPWR VGND VPWR VGND sky130_ef_sc_hd__decap_40_12
Xhold1002 _4425_/X VGND VGND VPWR VPWR _6057_/D sky130_fd_sc_hd__dlygate4sd3_1
X_6066_ _6342_/CLK _6066_/D VGND VGND VPWR VPWR _6066_/Q sky130_fd_sc_hd__dfxtp_1
XTAP_TAPCELL_ROW_51_1069 VGND VPWR sky130_fd_sc_hd__tapvpwrvgnd_1
XTAP_TAPCELL_ROW_51_1058 VGND VPWR sky130_fd_sc_hd__tapvpwrvgnd_1
Xhold1024 _5788_/Q VGND VGND VPWR VPWR _4599_/A1 sky130_fd_sc_hd__dlygate4sd3_1
Xhold1035 _3485_/X VGND VGND VPWR VPWR _5531_/D sky130_fd_sc_hd__dlygate4sd3_1
XANTENNA__4484__S _4492_/S VGND VGND VPWR VPWR sky130_fd_sc_hd__diode_2
Xhold1057 _4414_/X VGND VGND VPWR VPWR _6051_/D sky130_fd_sc_hd__dlygate4sd3_1
X_3278_ _3278_/A _4813_/S _3278_/C VGND VGND VPWR VPWR _3279_/B sky130_fd_sc_hd__and3_1
Xhold1046 _6278_/Q VGND VGND VPWR VPWR _4942_/A1 sky130_fd_sc_hd__dlygate4sd3_1
X_5017_ _5433_/Q _5435_/Q _5436_/Q _5434_/Q _6328_/Q _6327_/Q VGND VGND VPWR VPWR
+ _5017_/X sky130_fd_sc_hd__mux4_1
Xhold1079 _3497_/X VGND VGND VPWR VPWR _5542_/D sky130_fd_sc_hd__dlygate4sd3_1
Xhold1068 _6080_/Q VGND VGND VPWR VPWR _4472_/A1 sky130_fd_sc_hd__dlygate4sd3_1
XANTENNA_fanout179_X _3094_/C1 VGND VGND VPWR VPWR sky130_fd_sc_hd__diode_2
XFILLER_26_401 VPWR VGND VPWR VGND sky130_ef_sc_hd__decap_40_12
XFILLER_54_765 VPWR VGND VPWR VGND sky130_ef_sc_hd__decap_40_12
XFILLER_53_220 VGND VGND VPWR VPWR sky130_fd_sc_hd__fill_2
XFILLER_26_445 VPWR VGND VPWR VGND sky130_ef_sc_hd__decap_40_12
XTAP_TAPCELL_ROW_66_1290 VGND VPWR sky130_fd_sc_hd__tapvpwrvgnd_1
XTAP_TAPCELL_ROW_24_657 VGND VPWR sky130_fd_sc_hd__tapvpwrvgnd_1
X_5919_ clkload9/A _5919_/D VGND VGND VPWR VPWR _5919_/Q sky130_fd_sc_hd__dfxtp_1
XFILLER_42_57 VGND VGND VPWR VPWR sky130_fd_sc_hd__fill_2
XFILLER_10_813 VPWR VGND VPWR VGND sky130_ef_sc_hd__decap_40_12
XFILLER_22_695 VGND VGND VPWR VPWR sky130_fd_sc_hd__fill_4
XFILLER_108_701 VPWR VGND VPWR VGND sky130_ef_sc_hd__decap_40_12
XANTENNA__3129__A _5085_/A VGND VGND VPWR VPWR sky130_fd_sc_hd__diode_2
XFILLER_135_553 VGND VGND VPWR VPWR sky130_fd_sc_hd__fill_4
XFILLER_5_349 VPWR VGND VPWR VGND sky130_ef_sc_hd__decap_40_12
XANTENNA__3760__A1 _4978_/A1 VGND VGND VPWR VPWR sky130_fd_sc_hd__diode_2
XFILLER_135_597 VPWR VGND VPWR VGND sky130_ef_sc_hd__decap_40_12
XFILLER_101_3 VPWR VGND VPWR VGND sky130_ef_sc_hd__decap_40_12
XFILLER_122_247 VGND VGND VPWR VPWR sky130_fd_sc_hd__fill_1
Xhold880 _5352_/Q VGND VGND VPWR VPWR hold880/X sky130_fd_sc_hd__dlygate4sd3_1
Xhold891 _3544_/X VGND VGND VPWR VPWR _5585_/D sky130_fd_sc_hd__dlygate4sd3_1
XFILLER_89_662 VGND VGND VPWR VPWR sky130_fd_sc_hd__fill_8
XFILLER_67_32 VGND VGND VPWR VPWR sky130_fd_sc_hd__fill_8
XFILLER_131_781 VGND VGND VPWR VPWR sky130_fd_sc_hd__fill_2
XFILLER_92_805 VGND VGND VPWR VPWR sky130_fd_sc_hd__fill_4
XANTENNA__3799__A _5176_/A VGND VGND VPWR VPWR sky130_fd_sc_hd__diode_2
XANTENNA_input21_A s_axil_wdata[3] VGND VGND VPWR VPWR sky130_fd_sc_hd__diode_2
XFILLER_49_559 VGND VGND VPWR VPWR sky130_fd_sc_hd__fill_1
XTAP_TAPCELL_ROW_4_360 VGND VPWR sky130_fd_sc_hd__tapvpwrvgnd_1
Xhold1580 _6047_/Q VGND VGND VPWR VPWR _4410_/A1 sky130_fd_sc_hd__dlygate4sd3_1
XFILLER_36_209 VGND VGND VPWR VPWR sky130_fd_sc_hd__fill_1
Xhold1591 _4854_/X VGND VGND VPWR VPWR _6206_/D sky130_fd_sc_hd__dlygate4sd3_1
XFILLER_83_20 VPWR VGND VPWR VGND sky130_ef_sc_hd__decap_40_12
XFILLER_45_743 VGND VGND VPWR VPWR sky130_fd_sc_hd__fill_2
XFILLER_17_445 VGND VGND VPWR VPWR sky130_fd_sc_hd__fill_2
XANTENNA__3579__A1 _5211_/A1 VGND VGND VPWR VPWR sky130_fd_sc_hd__diode_2
XFILLER_44_297 VGND VGND VPWR VPWR sky130_fd_sc_hd__fill_1
XTAP_TAPCELL_ROW_43_944 VGND VPWR sky130_fd_sc_hd__tapvpwrvgnd_1
XANTENNA__3738__S _3745_/S VGND VGND VPWR VPWR sky130_fd_sc_hd__diode_2
XANTENNA__4776__B1 _4791_/B1 VGND VGND VPWR VPWR sky130_fd_sc_hd__diode_2
XFILLER_80_8 VPWR VGND VPWR VGND sky130_ef_sc_hd__decap_40_12
XANTENNA__4423__A input5/X VGND VGND VPWR VPWR sky130_fd_sc_hd__diode_2
XFILLER_13_673 VPWR VGND VPWR VGND sky130_ef_sc_hd__decap_40_12
XTAP_TAPCELL_ROW_97_1751 VGND VPWR sky130_fd_sc_hd__tapvpwrvgnd_1
XANTENNA__6411__Q _6411_/Q VGND VGND VPWR VPWR sky130_fd_sc_hd__diode_2
XFILLER_126_531 VGND VGND VPWR VPWR sky130_fd_sc_hd__fill_1
XTAP_TAPCELL_ROW_97_1762 VGND VPWR sky130_fd_sc_hd__tapvpwrvgnd_1
XFILLER_114_737 VPWR VGND VPWR VGND sky130_ef_sc_hd__decap_40_12
XANTENNA__3473__S _3477_/S VGND VGND VPWR VPWR sky130_fd_sc_hd__diode_2
X_4250_ _5786_/Q _5914_/Q _4250_/S VGND VGND VPWR VPWR _4251_/B sky130_fd_sc_hd__mux2_1
X_3201_ hold303/X _5232_/A0 _3206_/S VGND VGND VPWR VPWR _3201_/X sky130_fd_sc_hd__mux2_1
XFILLER_68_813 VGND VGND VPWR VPWR sky130_fd_sc_hd__fill_4
XFILLER_68_802 VGND VGND VPWR VPWR sky130_fd_sc_hd__fill_8
X_4181_ _4149_/A _4176_/X _4178_/X _4180_/X VGND VGND VPWR VPWR _4181_/X sky130_fd_sc_hd__a22o_1
XFILLER_122_781 VPWR VGND VPWR VGND sky130_ef_sc_hd__decap_40_12
XFILLER_79_183 VGND VGND VPWR VPWR sky130_fd_sc_hd__fill_1
XFILLER_79_161 VGND VGND VPWR VPWR sky130_fd_sc_hd__fill_1
X_3132_ _5200_/A _3132_/B _5050_/B VGND VGND VPWR VPWR _5321_/D sky130_fd_sc_hd__and3_1
XFILLER_95_665 VGND VGND VPWR VPWR sky130_fd_sc_hd__fill_4
XFILLER_67_356 VPWR VGND VPWR VGND sky130_ef_sc_hd__decap_40_12
X_3063_ _3062_/S _5487_/Q _3034_/A VGND VGND VPWR VPWR _3063_/X sky130_fd_sc_hd__a21bo_1
XTAP_TAPCELL_ROW_124_2158 VGND VPWR sky130_fd_sc_hd__tapvpwrvgnd_1
XFILLER_36_798 VPWR VGND VPWR VGND sky130_ef_sc_hd__decap_40_12
XTAP_TAPCELL_ROW_106_1891 VGND VPWR sky130_fd_sc_hd__tapvpwrvgnd_1
X_3965_ _3965_/A _5201_/B _5019_/A VGND VGND VPWR VPWR _3965_/X sky130_fd_sc_hd__and3_1
X_2916_ _3076_/A1 _2911_/X _2913_/X _2915_/X VGND VGND VPWR VPWR _2916_/X sky130_fd_sc_hd__a22o_1
X_3896_ _3896_/A0 _4961_/A0 _3899_/S VGND VGND VPWR VPWR _3896_/X sky130_fd_sc_hd__mux2_1
XTAP_TAPCELL_ROW_21_616 VGND VPWR sky130_fd_sc_hd__tapvpwrvgnd_1
X_5704_ _5902_/CLK _5704_/D VGND VGND VPWR VPWR _5704_/Q sky130_fd_sc_hd__dfxtp_1
X_2847_ _5418_/Q _5492_/Q _2963_/S VGND VGND VPWR VPWR _2848_/B sky130_fd_sc_hd__mux2_1
X_5635_ _6290_/CLK _5635_/D VGND VGND VPWR VPWR _5635_/Q sky130_fd_sc_hd__dfxtp_1
XANTENNA_fanout139_A _2628_/A VGND VGND VPWR VPWR sky130_fd_sc_hd__diode_2
XFILLER_128_27 VGND VGND VPWR VPWR sky130_fd_sc_hd__fill_1
XANTENNA__4614__S0 _4778_/S VGND VGND VPWR VPWR sky130_fd_sc_hd__diode_2
X_5566_ _6437_/CLK _5566_/D VGND VGND VPWR VPWR _5566_/Q sky130_fd_sc_hd__dfxtp_1
XFILLER_117_553 VGND VGND VPWR VPWR sky130_fd_sc_hd__fill_4
X_2778_ _6171_/Q _6195_/Q _6183_/Q _5477_/Q _3091_/S _3005_/A VGND VGND VPWR VPWR
+ _2778_/X sky130_fd_sc_hd__mux4_1
Xhold110 _4279_/X VGND VGND VPWR VPWR _5931_/D sky130_fd_sc_hd__dlygate4sd3_1
XFILLER_3_809 VPWR VGND VPWR VGND sky130_ef_sc_hd__decap_40_12
XFILLER_132_501 VPWR VGND VPWR VGND sky130_ef_sc_hd__decap_40_12
XFILLER_117_597 VPWR VGND VPWR VGND sky130_ef_sc_hd__decap_40_12
XANTENNA__3742__A1 _5234_/A0 VGND VGND VPWR VPWR sky130_fd_sc_hd__diode_2
X_5497_ _5820_/CLK _5497_/D VGND VGND VPWR VPWR _5497_/Q sky130_fd_sc_hd__dfxtp_1
Xhold143 _5870_/Q VGND VGND VPWR VPWR hold143/X sky130_fd_sc_hd__dlygate4sd3_1
Xhold121 _6321_/Q VGND VGND VPWR VPWR hold121/X sky130_fd_sc_hd__dlygate4sd3_1
XANTENNA__3383__S _3390_/S VGND VGND VPWR VPWR sky130_fd_sc_hd__diode_2
XANTENNA_clkbuf_leaf_1_clk_A clkload0/A VGND VGND VPWR VPWR sky130_fd_sc_hd__diode_2
Xhold132 _4338_/X VGND VGND VPWR VPWR _5983_/D sky130_fd_sc_hd__dlygate4sd3_1
X_4517_ hold218/X _4517_/A1 _4522_/S VGND VGND VPWR VPWR _4517_/X sky130_fd_sc_hd__mux2_1
XFILLER_132_545 VPWR VGND VPWR VGND sky130_ef_sc_hd__decap_40_12
Xhold154 _5239_/X VGND VGND VPWR VPWR _6436_/D sky130_fd_sc_hd__dlygate4sd3_1
Xhold176 _3449_/X VGND VGND VPWR VPWR _5499_/D sky130_fd_sc_hd__dlygate4sd3_1
X_4448_ _5338_/Q _4451_/B VGND VGND VPWR VPWR _4448_/Y sky130_fd_sc_hd__nor2_1
Xhold165 _5991_/Q VGND VGND VPWR VPWR hold165/X sky130_fd_sc_hd__dlygate4sd3_1
XFILLER_132_589 VPWR VGND VPWR VGND sky130_ef_sc_hd__decap_40_12
XFILLER_104_269 VGND VGND VPWR VPWR sky130_fd_sc_hd__fill_2
Xhold198 _3655_/X VGND VGND VPWR VPWR _5681_/D sky130_fd_sc_hd__dlygate4sd3_1
Xhold187 _6025_/Q VGND VGND VPWR VPWR hold187/X sky130_fd_sc_hd__dlygate4sd3_1
XFILLER_113_781 VGND VGND VPWR VPWR sky130_fd_sc_hd__fill_2
X_4379_ hold43/X _5052_/A1 _4386_/S VGND VGND VPWR VPWR hold44/A sky130_fd_sc_hd__mux2_1
XFILLER_58_356 VGND VGND VPWR VPWR sky130_fd_sc_hd__fill_8
X_6118_ _6123_/CLK _6118_/D VGND VGND VPWR VPWR _6118_/Q sky130_fd_sc_hd__dfxtp_1
XFILLER_100_475 VGND VGND VPWR VPWR sky130_fd_sc_hd__fill_1
X_6049_ _6405_/CLK _6049_/D VGND VGND VPWR VPWR _6049_/Q sky130_fd_sc_hd__dfxtp_1
XFILLER_37_57 VGND VGND VPWR VPWR sky130_fd_sc_hd__fill_4
XFILLER_85_197 VGND VGND VPWR VPWR sky130_fd_sc_hd__fill_2
XFILLER_26_231 VGND VGND VPWR VPWR sky130_fd_sc_hd__fill_2
XTAP_TAPCELL_ROW_29_738 VGND VPWR sky130_fd_sc_hd__tapvpwrvgnd_1
XANTENNA__4942__S _4944_/S VGND VGND VPWR VPWR sky130_fd_sc_hd__diode_2
XFILLER_81_370 VGND VGND VPWR VPWR sky130_fd_sc_hd__fill_2
XFILLER_53_23 VGND VGND VPWR VPWR sky130_fd_sc_hd__fill_1
XFILLER_26_286 VGND VGND VPWR VPWR sky130_fd_sc_hd__fill_8
XTAP_TAPCELL_ROW_40_903 VGND VPWR sky130_fd_sc_hd__tapvpwrvgnd_1
XFILLER_41_234 VGND VGND VPWR VPWR sky130_fd_sc_hd__fill_1
XFILLER_10_643 VGND VGND VPWR VPWR sky130_fd_sc_hd__fill_1
XFILLER_127_339 VGND VGND VPWR VPWR sky130_fd_sc_hd__fill_1
XFILLER_6_625 VPWR VGND VPWR VGND sky130_ef_sc_hd__decap_40_12
XFILLER_5_113 VGND VGND VPWR VPWR sky130_fd_sc_hd__fill_1
XFILLER_108_531 VGND VGND VPWR VPWR sky130_fd_sc_hd__fill_1
XFILLER_6_669 VPWR VGND VPWR VGND sky130_ef_sc_hd__decap_40_12
XANTENNA__3293__S _3295_/S VGND VGND VPWR VPWR sky130_fd_sc_hd__diode_2
XTAP_TAPCELL_ROW_79_1492 VGND VPWR sky130_fd_sc_hd__tapvpwrvgnd_1
XTAP_TAPCELL_ROW_79_1481 VGND VPWR sky130_fd_sc_hd__tapvpwrvgnd_1
XANTENNA__2698__A _4262_/S VGND VGND VPWR VPWR sky130_fd_sc_hd__diode_2
XTAP_TAPCELL_ROW_9_441 VGND VPWR sky130_fd_sc_hd__tapvpwrvgnd_1
XTAP_TAPCELL_ROW_9_430 VGND VPWR sky130_fd_sc_hd__tapvpwrvgnd_1
XFILLER_111_729 VPWR VGND VPWR VGND sky130_ef_sc_hd__decap_40_12
XTAP_TAPCELL_ROW_92_1681 VGND VPWR sky130_fd_sc_hd__tapvpwrvgnd_1
XFILLER_78_53 VGND VGND VPWR VPWR sky130_fd_sc_hd__fill_4
XFILLER_1_330 VGND VGND VPWR VPWR sky130_fd_sc_hd__fill_4
XANTENNA__3497__A0 _4887_/A1 VGND VGND VPWR VPWR sky130_fd_sc_hd__diode_2
XFILLER_104_781 VPWR VGND VPWR VGND sky130_ef_sc_hd__decap_40_12
XFILLER_89_492 VGND VGND VPWR VPWR sky130_fd_sc_hd__fill_1
XFILLER_1_363 VGND VGND VPWR VPWR sky130_fd_sc_hd__fill_8
XFILLER_1_374 VGND VGND VPWR VPWR sky130_fd_sc_hd__fill_4
XANTENNA__5238__A1 _5238_/A1 VGND VGND VPWR VPWR sky130_fd_sc_hd__diode_2
XFILLER_92_613 VPWR VGND VPWR VGND sky130_ef_sc_hd__decap_40_12
XFILLER_65_827 VGND VGND VPWR VPWR sky130_fd_sc_hd__fill_1
XANTENNA__3249__B1 _3801_/A VGND VGND VPWR VPWR sky130_fd_sc_hd__diode_2
XFILLER_92_657 VPWR VGND VPWR VGND sky130_ef_sc_hd__decap_40_12
XANTENNA__4446__C1 _3801_/B VGND VGND VPWR VPWR sky130_fd_sc_hd__diode_2
XANTENNA__4852__S _4854_/S VGND VGND VPWR VPWR sky130_fd_sc_hd__diode_2
XANTENNA__6406__Q _6406_/Q VGND VGND VPWR VPWR sky130_fd_sc_hd__diode_2
XFILLER_72_381 VGND VGND VPWR VPWR sky130_fd_sc_hd__fill_1
XANTENNA__3468__S _3477_/S VGND VGND VPWR VPWR sky130_fd_sc_hd__diode_2
XFILLER_60_587 VGND VGND VPWR VPWR sky130_fd_sc_hd__fill_1
X_3750_ _4929_/A1 _4107_/A0 _3755_/S VGND VGND VPWR VPWR _3750_/X sky130_fd_sc_hd__mux2_1
XFILLER_9_441 VGND VGND VPWR VPWR sky130_fd_sc_hd__fill_4
X_2701_ _4272_/S _2701_/B VGND VGND VPWR VPWR _2701_/X sky130_fd_sc_hd__xor2_1
X_3681_ _6411_/Q _3681_/A1 _3688_/S VGND VGND VPWR VPWR _3681_/X sky130_fd_sc_hd__mux2_1
XFILLER_9_485 VPWR VGND VPWR VGND sky130_ef_sc_hd__decap_40_12
X_5420_ _5753_/CLK _5420_/D VGND VGND VPWR VPWR _5420_/Q sky130_fd_sc_hd__dfxtp_1
XANTENNA__4440__X _4440_/X VGND VGND VPWR VPWR sky130_fd_sc_hd__diode_2
X_2632_ _3236_/A VGND VGND VPWR VPWR _3606_/A sky130_fd_sc_hd__inv_2
X_5351_ _5820_/CLK _5351_/D VGND VGND VPWR VPWR _5351_/Q sky130_fd_sc_hd__dfxtp_1
XANTENNA__3724__A1 _5043_/A1 VGND VGND VPWR VPWR sky130_fd_sc_hd__diode_2
XFILLER_114_545 VPWR VGND VPWR VGND sky130_ef_sc_hd__decap_40_12
X_5282_ _6434_/CLK _5282_/D VGND VGND VPWR VPWR _5282_/Q sky130_fd_sc_hd__dfxtp_1
X_4302_ _4302_/A0 _5045_/A1 _4304_/S VGND VGND VPWR VPWR _4302_/X sky130_fd_sc_hd__mux2_1
XFILLER_99_267 VGND VGND VPWR VPWR sky130_fd_sc_hd__fill_4
X_4233_ _4272_/S _4225_/Y _4232_/Y _5343_/Q VGND VGND VPWR VPWR _4233_/X sky130_fd_sc_hd__o211a_1
XFILLER_114_589 VPWR VGND VPWR VGND sky130_ef_sc_hd__decap_40_12
XFILLER_99_289 VGND VGND VPWR VPWR sky130_fd_sc_hd__fill_2
XFILLER_4_83 VGND VGND VPWR VPWR sky130_fd_sc_hd__fill_1
XFILLER_114_29 VPWR VGND VPWR VGND sky130_ef_sc_hd__decap_40_12
X_4164_ hold681/X _6014_/Q _4213_/S VGND VGND VPWR VPWR _4165_/B sky130_fd_sc_hd__mux2_1
X_3115_ hold274/X _5238_/A1 _3126_/S VGND VGND VPWR VPWR _3115_/X sky130_fd_sc_hd__mux2_1
XFILLER_67_175 VGND VGND VPWR VPWR sky130_fd_sc_hd__fill_1
X_4095_ _6038_/Q _6346_/Q _4228_/S VGND VGND VPWR VPWR _4095_/X sky130_fd_sc_hd__mux2_1
X_3046_ _3052_/A1 _3045_/X _3075_/C1 VGND VGND VPWR VPWR _3046_/X sky130_fd_sc_hd__o21a_1
XTAP_TAPCELL_ROW_108_1920 VGND VPWR sky130_fd_sc_hd__tapvpwrvgnd_1
XFILLER_83_646 VGND VGND VPWR VPWR sky130_fd_sc_hd__fill_2
XFILLER_55_326 VGND VGND VPWR VPWR sky130_fd_sc_hd__fill_1
XANTENNA__4452__A2 _3366_/X VGND VGND VPWR VPWR sky130_fd_sc_hd__diode_2
XFILLER_24_757 VPWR VGND VPWR VGND sky130_ef_sc_hd__decap_40_12
X_4997_ _4997_/A _4997_/B _4997_/C VGND VGND VPWR VPWR _4997_/X sky130_fd_sc_hd__or3_2
XFILLER_11_429 VPWR VGND VPWR VGND sky130_ef_sc_hd__decap_40_12
XANTENNA__3412__A0 _4984_/A1 VGND VGND VPWR VPWR sky130_fd_sc_hd__diode_2
XFILLER_23_15 VPWR VGND VPWR VGND sky130_ef_sc_hd__decap_40_12
XFILLER_23_37 VGND VGND VPWR VPWR sky130_fd_sc_hd__fill_1
XANTENNA__4063__A _4149_/A VGND VGND VPWR VPWR sky130_fd_sc_hd__diode_2
XTAP_TAPCELL_ROW_137_2349 VGND VPWR sky130_fd_sc_hd__tapvpwrvgnd_1
X_3948_ _5173_/A _3948_/B _5162_/A _5162_/B VGND VGND VPWR VPWR _3952_/D sky130_fd_sc_hd__or4_1
XFILLER_137_615 VGND VGND VPWR VPWR sky130_fd_sc_hd__fill_1
XFILLER_109_317 VGND VGND VPWR VPWR sky130_fd_sc_hd__fill_2
X_3879_ _4964_/A0 _3879_/A1 _3879_/S VGND VGND VPWR VPWR _3879_/X sky130_fd_sc_hd__mux2_1
X_5618_ _6298_/CLK hold94/X VGND VGND VPWR VPWR hold93/A sky130_fd_sc_hd__dfxtp_1
XFILLER_133_821 VPWR VGND VPWR VGND sky130_ef_sc_hd__decap_40_12
X_5549_ _6399_/CLK _5549_/D VGND VGND VPWR VPWR _5549_/Q sky130_fd_sc_hd__dfxtp_1
XFILLER_3_617 VPWR VGND VPWR VGND sky130_ef_sc_hd__decap_40_12
XANTENNA__3715__A1 _4982_/A1 VGND VGND VPWR VPWR sky130_fd_sc_hd__diode_2
XFILLER_78_418 VGND VGND VPWR VPWR sky130_fd_sc_hd__fill_2
XFILLER_120_526 VGND VGND VPWR VPWR sky130_fd_sc_hd__fill_4
XFILLER_59_621 VGND VGND VPWR VPWR sky130_fd_sc_hd__fill_1
XANTENNA__4937__S _4944_/S VGND VGND VPWR VPWR sky130_fd_sc_hd__diode_2
XANTENNA_fanout71_A _2635_/Y VGND VGND VPWR VPWR sky130_fd_sc_hd__diode_2
XFILLER_19_529 VPWR VGND VPWR VGND sky130_ef_sc_hd__decap_40_12
XANTENNA__4428__C1 _3801_/B VGND VGND VPWR VPWR sky130_fd_sc_hd__diode_2
XFILLER_58_197 VGND VGND VPWR VPWR sky130_fd_sc_hd__fill_1
XANTENNA__4443__A2 _3366_/X VGND VGND VPWR VPWR sky130_fd_sc_hd__diode_2
XANTENNA__3288__S _3295_/S VGND VGND VPWR VPWR sky130_fd_sc_hd__diode_2
XFILLER_120_83 VGND VGND VPWR VPWR sky130_fd_sc_hd__fill_1
Xfanout71 _2635_/Y VGND VGND VPWR VPWR _4252_/B1 sky130_fd_sc_hd__buf_4
Xfanout82 _5212_/A1 VGND VGND VPWR VPWR _4488_/A0 sky130_fd_sc_hd__buf_4
XFILLER_128_637 VGND VGND VPWR VPWR sky130_fd_sc_hd__fill_4
Xfanout93 _6406_/Q VGND VGND VPWR VPWR _4964_/A0 sky130_fd_sc_hd__buf_4
XTAP_TAPCELL_ROW_12_479 VGND VPWR sky130_fd_sc_hd__tapvpwrvgnd_1
XFILLER_10_473 VGND VGND VPWR VPWR sky130_fd_sc_hd__fill_2
XFILLER_6_433 VPWR VGND VPWR VGND sky130_ef_sc_hd__decap_40_12
XANTENNA__4903__A0 _4903_/A0 VGND VGND VPWR VPWR sky130_fd_sc_hd__diode_2
XTAP_TAPCELL_ROW_94_1710 VGND VPWR sky130_fd_sc_hd__tapvpwrvgnd_1
XFILLER_6_477 VPWR VGND VPWR VGND sky130_ef_sc_hd__decap_40_12
XFILLER_136_681 VPWR VGND VPWR VGND sky130_ef_sc_hd__decap_40_12
XFILLER_135_180 VGND VGND VPWR VPWR sky130_fd_sc_hd__fill_1
XFILLER_89_85 VGND VGND VPWR VPWR sky130_fd_sc_hd__fill_4
XFILLER_97_727 VGND VGND VPWR VPWR sky130_fd_sc_hd__fill_1
XANTENNA__4847__S _4854_/S VGND VGND VPWR VPWR sky130_fd_sc_hd__diode_2
XANTENNA__4667__C1 _4811_/C1 VGND VGND VPWR VPWR sky130_fd_sc_hd__diode_2
XFILLER_111_559 VGND VGND VPWR VPWR sky130_fd_sc_hd__fill_1
XANTENNA__4131__A1 _4272_/S VGND VGND VPWR VPWR sky130_fd_sc_hd__diode_2
XTAP_TAPCELL_ROW_121_2117 VGND VPWR sky130_fd_sc_hd__tapvpwrvgnd_1
XFILLER_92_465 VGND VGND VPWR VPWR sky130_fd_sc_hd__fill_8
XANTENNA__4434__A2 _4994_/B VGND VGND VPWR VPWR sky130_fd_sc_hd__diode_2
XFILLER_80_649 VGND VGND VPWR VPWR sky130_fd_sc_hd__fill_2
X_4920_ _4920_/A _4922_/B _4922_/C VGND VGND VPWR VPWR _4920_/X sky130_fd_sc_hd__or3_1
X_4851_ _5813_/Q _4851_/A1 _4854_/S VGND VGND VPWR VPWR _4851_/X sky130_fd_sc_hd__mux2_1
XFILLER_61_841 VGND VGND VPWR VPWR sky130_fd_sc_hd__fill_1
XFILLER_21_705 VPWR VGND VPWR VGND sky130_ef_sc_hd__decap_40_12
XTAP_TAPCELL_ROW_103_1850 VGND VPWR sky130_fd_sc_hd__tapvpwrvgnd_1
X_3802_ _3237_/A _3802_/A2 _2655_/Y _5808_/D VGND VGND VPWR VPWR _5809_/D sky130_fd_sc_hd__a31o_1
XFILLER_21_727 VGND VGND VPWR VPWR sky130_fd_sc_hd__fill_1
X_4782_ _5610_/Q _5691_/Q _6097_/Q _5877_/Q _4778_/S _4600_/A VGND VGND VPWR VPWR
+ _4782_/X sky130_fd_sc_hd__mux4_1
XFILLER_119_615 VGND VGND VPWR VPWR sky130_fd_sc_hd__fill_1
X_3733_ _4523_/B _5225_/B VGND VGND VPWR VPWR _3745_/S sky130_fd_sc_hd__nor2_8
XTAP_TAPCELL_ROW_31_766 VGND VPWR sky130_fd_sc_hd__tapvpwrvgnd_1
XTAP_TAPCELL_ROW_119_2079 VGND VPWR sky130_fd_sc_hd__tapvpwrvgnd_1
X_3664_ _4961_/A0 _3664_/A1 _3667_/S VGND VGND VPWR VPWR _3664_/X sky130_fd_sc_hd__mux2_1
XANTENNA__4611__A _4794_/A VGND VGND VPWR VPWR sky130_fd_sc_hd__diode_2
X_5403_ _6435_/CLK _5403_/D VGND VGND VPWR VPWR _5403_/Q sky130_fd_sc_hd__dfxtp_1
Xclkload52 _6297_/CLK VGND VGND VPWR VPWR clkload52/Y sky130_fd_sc_hd__clkinv_8
Xclkload30 _6404_/CLK VGND VGND VPWR VPWR clkload30/Y sky130_fd_sc_hd__clkinvlp_4
Xclkload41 _5681_/CLK VGND VGND VPWR VPWR clkload41/Y sky130_fd_sc_hd__inv_8
XTAP_TAPCELL_ROW_132_2279 VGND VPWR sky130_fd_sc_hd__tapvpwrvgnd_1
Xclkload85 _5565_/CLK VGND VGND VPWR VPWR clkload85/Y sky130_fd_sc_hd__clkinvlp_4
XFILLER_115_821 VPWR VGND VPWR VGND sky130_ef_sc_hd__decap_40_12
Xclkload74 _6199_/CLK VGND VGND VPWR VPWR clkload74/Y sky130_fd_sc_hd__inv_6
Xclkload96 _6298_/CLK VGND VGND VPWR VPWR clkload96/Y sky130_fd_sc_hd__inv_6
X_3595_ hold916/X _4964_/A0 _3595_/S VGND VGND VPWR VPWR _3595_/X sky130_fd_sc_hd__mux2_1
Xclkload63 _6398_/CLK VGND VGND VPWR VPWR clkload63/Y sky130_fd_sc_hd__bufinv_16
X_6383_ _6409_/CLK _6383_/D VGND VGND VPWR VPWR _6383_/Q sky130_fd_sc_hd__dfxtp_1
XFILLER_130_813 VPWR VGND VPWR VGND sky130_ef_sc_hd__decap_40_12
X_5334_ _6172_/CLK _5334_/D VGND VGND VPWR VPWR _5334_/Q sky130_fd_sc_hd__dfxtp_1
XFILLER_125_39 VGND VGND VPWR VPWR sky130_fd_sc_hd__fill_8
XFILLER_102_515 VPWR VGND VPWR VGND sky130_ef_sc_hd__decap_40_12
XFILLER_88_749 VGND VGND VPWR VPWR sky130_fd_sc_hd__fill_4
X_5265_ _6172_/CLK _5265_/D VGND VGND VPWR VPWR _5265_/Q sky130_fd_sc_hd__dfxtp_1
XANTENNA__3661__S _3667_/S VGND VGND VPWR VPWR sky130_fd_sc_hd__diode_2
X_5196_ _3958_/A _5194_/X _5191_/Y _3955_/B VGND VGND VPWR VPWR _5196_/X sky130_fd_sc_hd__a2bb2o_1
X_4216_ _2635_/Y _4215_/X _4212_/Y _4214_/Y VGND VGND VPWR VPWR _4216_/X sky130_fd_sc_hd__o2bb2a_1
X_4147_ _4260_/S _4139_/X _4146_/Y _5343_/Q VGND VGND VPWR VPWR _4147_/X sky130_fd_sc_hd__a211o_1
XFILLER_110_581 VGND VGND VPWR VPWR sky130_fd_sc_hd__fill_4
XFILLER_96_793 VPWR VGND VPWR VGND sky130_ef_sc_hd__decap_40_12
XANTENNA__4425__A2 _4457_/S VGND VGND VPWR VPWR sky130_fd_sc_hd__diode_2
XTAP_TAPCELL_ROW_48_1019 VGND VPWR sky130_fd_sc_hd__tapvpwrvgnd_1
X_4078_ _5762_/Q _5740_/Q _4237_/S VGND VGND VPWR VPWR _4078_/X sky130_fd_sc_hd__mux2_1
X_3029_ _3029_/A _3029_/B VGND VGND VPWR VPWR _3029_/X sky130_fd_sc_hd__or2_1
XANTENNA__4492__S _4492_/S VGND VGND VPWR VPWR sky130_fd_sc_hd__diode_2
XFILLER_55_189 VGND VGND VPWR VPWR sky130_fd_sc_hd__fill_2
XANTENNA_fanout161_X _4241_/A VGND VGND VPWR VPWR sky130_fd_sc_hd__diode_2
XTAP_TAPCELL_ROW_39_888 VGND VPWR sky130_fd_sc_hd__tapvpwrvgnd_1
XFILLER_52_841 VGND VGND VPWR VPWR sky130_fd_sc_hd__fill_1
XTAP_TAPCELL_ROW_19_590 VGND VPWR sky130_fd_sc_hd__tapvpwrvgnd_1
XTAP_TAPCELL_ROW_61_1219 VGND VPWR sky130_fd_sc_hd__tapvpwrvgnd_1
XTAP_TAPCELL_ROW_61_1208 VGND VPWR sky130_fd_sc_hd__tapvpwrvgnd_1
XFILLER_11_204 VGND VGND VPWR VPWR sky130_fd_sc_hd__fill_1
XFILLER_12_749 VGND VGND VPWR VPWR sky130_fd_sc_hd__fill_4
Xclkload2 clkload2/A VGND VGND VPWR VPWR clkload2/Y sky130_fd_sc_hd__inv_12
XFILLER_7_219 VGND VGND VPWR VPWR sky130_fd_sc_hd__fill_1
XFILLER_20_793 VPWR VGND VPWR VGND sky130_ef_sc_hd__decap_40_12
XFILLER_125_629 VPWR VGND VPWR VGND sky130_ef_sc_hd__decap_40_12
XFILLER_118_681 VPWR VGND VPWR VGND sky130_ef_sc_hd__decap_40_12
XTAP_TAPCELL_ROW_76_1440 VGND VPWR sky130_fd_sc_hd__tapvpwrvgnd_1
XFILLER_3_425 VGND VGND VPWR VPWR sky130_fd_sc_hd__fill_2
XANTENNA__4361__A1 _5042_/A1 VGND VGND VPWR VPWR sky130_fd_sc_hd__diode_2
XFILLER_133_673 VPWR VGND VPWR VGND sky130_ef_sc_hd__decap_40_12
XFILLER_132_161 VGND VGND VPWR VPWR sky130_fd_sc_hd__fill_2
XFILLER_79_727 VGND VGND VPWR VPWR sky130_fd_sc_hd__fill_1
XANTENNA__3571__S _3574_/S VGND VGND VPWR VPWR sky130_fd_sc_hd__diode_2
XANTENNA__4113__A1 _4252_/A1 VGND VGND VPWR VPWR sky130_fd_sc_hd__diode_2
XANTENNA_fanout74_X _4811_/C1 VGND VGND VPWR VPWR sky130_fd_sc_hd__diode_2
XANTENNA__2675__A1 _4905_/A0 VGND VGND VPWR VPWR sky130_fd_sc_hd__diode_2
XFILLER_75_32 VPWR VGND VPWR VGND sky130_ef_sc_hd__decap_40_12
XFILLER_74_421 VPWR VGND VPWR VGND sky130_ef_sc_hd__decap_40_12
XFILLER_75_65 VGND VGND VPWR VPWR sky130_fd_sc_hd__fill_4
XFILLER_34_307 VGND VGND VPWR VPWR sky130_fd_sc_hd__fill_1
XFILLER_91_20 VGND VGND VPWR VPWR sky130_fd_sc_hd__fill_8
XANTENNA_clkbuf_3_4__f_clk_A clkbuf_0_clk/X VGND VGND VPWR VPWR sky130_fd_sc_hd__diode_2
XFILLER_43_841 VGND VGND VPWR VPWR sky130_fd_sc_hd__fill_1
XTAP_TAPCELL_ROW_17_549 VGND VPWR sky130_fd_sc_hd__tapvpwrvgnd_1
XFILLER_24_80 VGND VGND VPWR VPWR sky130_fd_sc_hd__fill_4
XANTENNA__3927__A1 _4521_/A1 VGND VGND VPWR VPWR sky130_fd_sc_hd__diode_2
XFILLER_30_557 VGND VGND VPWR VPWR sky130_fd_sc_hd__fill_1
XFILLER_30_568 VGND VGND VPWR VPWR sky130_fd_sc_hd__fill_1
XFILLER_7_753 VPWR VGND VPWR VGND sky130_ef_sc_hd__decap_40_12
Xhold709 _3715_/X VGND VGND VPWR VPWR _5735_/D sky130_fd_sc_hd__dlygate4sd3_1
XFILLER_7_797 VPWR VGND VPWR VGND sky130_ef_sc_hd__decap_40_12
X_3380_ _5090_/A0 _4994_/B _4445_/B _4904_/A0 _3801_/B VGND VGND VPWR VPWR _3380_/X
+ sky130_fd_sc_hd__a221o_1
XANTENNA__4352__A1 _4980_/A1 VGND VGND VPWR VPWR sky130_fd_sc_hd__diode_2
XANTENNA__3481__S _3490_/S VGND VGND VPWR VPWR sky130_fd_sc_hd__diode_2
XFILLER_112_813 VPWR VGND VPWR VGND sky130_ef_sc_hd__decap_40_12
XANTENNA_clkbuf_leaf_41_clk_A clkload4/A VGND VGND VPWR VPWR sky130_fd_sc_hd__diode_2
XANTENNA_hold2136_A _6460_/A VGND VGND VPWR VPWR sky130_fd_sc_hd__diode_2
X_5050_ _5050_/A _5050_/B VGND VGND VPWR VPWR _5059_/S sky130_fd_sc_hd__nor2_4
X_4001_ _5097_/B VGND VGND VPWR VPWR _4001_/Y sky130_fd_sc_hd__inv_2
XFILLER_27_3 VGND VGND VPWR VPWR sky130_fd_sc_hd__fill_4
Xhold1409 _3783_/X VGND VGND VPWR VPWR _5791_/D sky130_fd_sc_hd__dlygate4sd3_1
XFILLER_93_741 VPWR VGND VPWR VGND sky130_ef_sc_hd__decap_40_12
XANTENNA__3863__A0 _5210_/A1 VGND VGND VPWR VPWR sky130_fd_sc_hd__diode_2
XANTENNA_clkbuf_leaf_56_clk_A clkload6/A VGND VGND VPWR VPWR sky130_fd_sc_hd__diode_2
XFILLER_93_785 VPWR VGND VPWR VGND sky130_ef_sc_hd__decap_40_12
XFILLER_65_476 VGND VGND VPWR VPWR sky130_fd_sc_hd__fill_1
XANTENNA__4606__A _4789_/A VGND VGND VPWR VPWR sky130_fd_sc_hd__diode_2
X_5952_ _6351_/CLK _5952_/D VGND VGND VPWR VPWR _5952_/Q sky130_fd_sc_hd__dfxtp_1
XFILLER_1_95 VGND VGND VPWR VPWR sky130_fd_sc_hd__fill_1
XTAP_TAPCELL_ROW_36_836 VGND VPWR sky130_fd_sc_hd__tapvpwrvgnd_1
X_4903_ _4903_/A0 _4903_/A1 _4906_/S VGND VGND VPWR VPWR _4903_/X sky130_fd_sc_hd__mux2_1
XFILLER_80_457 VGND VGND VPWR VPWR sky130_fd_sc_hd__fill_1
XFILLER_52_159 VGND VGND VPWR VPWR sky130_fd_sc_hd__fill_1
XFILLER_34_841 VGND VGND VPWR VPWR sky130_fd_sc_hd__fill_1
XTAP_TAPCELL_ROW_36_847 VGND VPWR sky130_fd_sc_hd__tapvpwrvgnd_1
XTAP_TAPCELL_ROW_101_1809 VGND VPWR sky130_fd_sc_hd__tapvpwrvgnd_1
XFILLER_80_479 VGND VGND VPWR VPWR sky130_fd_sc_hd__fill_1
XPHY_EDGE_ROW_80_Left_219 VGND VGND VPWR VPWR sky130_fd_sc_hd__decap_3
X_5883_ _6121_/CLK _5883_/D VGND VGND VPWR VPWR _5883_/Q sky130_fd_sc_hd__dfxtp_1
X_4834_ _4886_/A1 hold993/X _4841_/S VGND VGND VPWR VPWR _6187_/D sky130_fd_sc_hd__mux2_1
XFILLER_21_557 VGND VGND VPWR VPWR sky130_fd_sc_hd__fill_2
X_4765_ _6106_/Q hold75/A _6088_/Q _5886_/Q _4801_/S _4802_/A VGND VGND VPWR VPWR
+ _4765_/X sky130_fd_sc_hd__mux4_1
XANTENNA__3918__A1 _5202_/A1 VGND VGND VPWR VPWR sky130_fd_sc_hd__diode_2
XTAP_TAPCELL_ROW_134_2308 VGND VPWR sky130_fd_sc_hd__tapvpwrvgnd_1
XFILLER_119_434 VGND VGND VPWR VPWR sky130_fd_sc_hd__fill_1
XANTENNA_fanout121_A _5817_/Q VGND VGND VPWR VPWR sky130_fd_sc_hd__diode_2
X_3716_ _3716_/A0 _4983_/A1 _3717_/S VGND VGND VPWR VPWR _3716_/X sky130_fd_sc_hd__mux2_1
XFILLER_107_629 VPWR VGND VPWR VGND sky130_ef_sc_hd__decap_40_12
X_4696_ _5715_/Q _5706_/Q _4808_/S VGND VGND VPWR VPWR _4697_/B sky130_fd_sc_hd__mux2_1
XFILLER_134_448 VGND VGND VPWR VPWR sky130_fd_sc_hd__fill_2
X_6435_ _6435_/CLK _6435_/D VGND VGND VPWR VPWR _6435_/Q sky130_fd_sc_hd__dfxtp_1
X_3647_ hold135/X _5202_/A1 _3647_/S VGND VGND VPWR VPWR _3647_/X sky130_fd_sc_hd__mux2_1
XFILLER_136_27 VGND VGND VPWR VPWR sky130_fd_sc_hd__fill_1
X_6366_ _6366_/CLK _6366_/D VGND VGND VPWR VPWR _6366_/Q sky130_fd_sc_hd__dfxtp_1
X_3578_ hold226/X _6412_/Q _3584_/S VGND VGND VPWR VPWR _3578_/X sky130_fd_sc_hd__mux2_1
XTAP_TAPCELL_ROW_58_1170 VGND VPWR sky130_fd_sc_hd__tapvpwrvgnd_1
XANTENNA__4343__A1 _4982_/A1 VGND VGND VPWR VPWR sky130_fd_sc_hd__diode_2
X_5317_ _6435_/CLK _5317_/D VGND VGND VPWR VPWR _5317_/Q sky130_fd_sc_hd__dfxtp_1
XFILLER_121_109 VGND VGND VPWR VPWR sky130_fd_sc_hd__fill_2
XFILLER_115_673 VPWR VGND VPWR VGND sky130_ef_sc_hd__decap_40_12
XANTENNA__4487__S _4492_/S VGND VGND VPWR VPWR sky130_fd_sc_hd__diode_2
XFILLER_130_643 VGND VGND VPWR VPWR sky130_fd_sc_hd__fill_1
X_6297_ _6297_/CLK _6297_/D VGND VGND VPWR VPWR _6297_/Q sky130_fd_sc_hd__dfxtp_1
Xhold14 hold14/A VGND VGND VPWR VPWR hold14/X sky130_fd_sc_hd__dlygate4sd3_1
X_5248_ _5565_/CLK hold24/X VGND VGND VPWR VPWR hold23/A sky130_fd_sc_hd__dfxtp_1
Xhold47 hold47/A VGND VGND VPWR VPWR hold47/X sky130_fd_sc_hd__dlygate4sd3_1
XTAP_TAPCELL_ROW_71_1370 VGND VPWR sky130_fd_sc_hd__tapvpwrvgnd_1
XFILLER_69_782 VGND VGND VPWR VPWR sky130_fd_sc_hd__fill_2
Xhold36 hold36/A VGND VGND VPWR VPWR hold36/X sky130_fd_sc_hd__dlygate4sd3_1
Xhold25 hold25/A VGND VGND VPWR VPWR hold25/X sky130_fd_sc_hd__dlygate4sd3_1
Xhold1910 _5980_/Q VGND VGND VPWR VPWR _4334_/A1 sky130_fd_sc_hd__dlygate4sd3_1
Xhold1921 _6362_/Q VGND VGND VPWR VPWR _5071_/A1 sky130_fd_sc_hd__dlygate4sd3_1
X_5179_ _3958_/A _5178_/X _5175_/S _3951_/Y VGND VGND VPWR VPWR _5179_/X sky130_fd_sc_hd__o211a_1
Xhold1954 _6381_/Q VGND VGND VPWR VPWR _5093_/A0 sky130_fd_sc_hd__dlygate4sd3_1
XFILLER_56_432 VGND VGND VPWR VPWR sky130_fd_sc_hd__fill_1
XFILLER_56_421 VGND VGND VPWR VPWR sky130_fd_sc_hd__fill_2
Xhold69 hold69/A VGND VGND VPWR VPWR hold69/X sky130_fd_sc_hd__dlygate4sd3_1
Xhold1943 _4949_/X VGND VGND VPWR VPWR _6284_/D sky130_fd_sc_hd__dlygate4sd3_1
Xhold1932 _3935_/X VGND VGND VPWR VPWR _5911_/D sky130_fd_sc_hd__dlygate4sd3_1
Xhold58 hold58/A VGND VGND VPWR VPWR hold58/X sky130_fd_sc_hd__dlygate4sd3_1
XFILLER_84_774 VPWR VGND VPWR VGND sky130_ef_sc_hd__decap_40_12
Xhold1965 _3154_/X VGND VGND VPWR VPWR _5335_/D sky130_fd_sc_hd__dlygate4sd3_1
Xhold1976 _6409_/Q VGND VGND VPWR VPWR _3965_/A sky130_fd_sc_hd__dlygate4sd3_1
Xhold1987 _3259_/S VGND VGND VPWR VPWR _3161_/B sky130_fd_sc_hd__dlygate4sd3_1
Xhold1998 _6168_/Q VGND VGND VPWR VPWR _4758_/A1 sky130_fd_sc_hd__dlygate4sd3_1
XPHY_EDGE_ROW_119_Left_258 VGND VGND VPWR VPWR sky130_fd_sc_hd__decap_3
XFILLER_25_841 VGND VGND VPWR VPWR sky130_fd_sc_hd__fill_1
XANTENNA__3082__A1 _2641_/Y VGND VGND VPWR VPWR sky130_fd_sc_hd__diode_2
XTAP_TAPCELL_ROW_14_508 VGND VPWR sky130_fd_sc_hd__tapvpwrvgnd_1
XFILLER_24_340 VGND VGND VPWR VPWR sky130_fd_sc_hd__fill_1
XFILLER_24_362 VGND VGND VPWR VPWR sky130_fd_sc_hd__fill_2
XFILLER_40_811 VGND VGND VPWR VPWR sky130_fd_sc_hd__fill_1
XFILLER_12_513 VPWR VGND VPWR VGND sky130_ef_sc_hd__decap_40_12
XANTENNA__4950__S _4954_/S VGND VGND VPWR VPWR sky130_fd_sc_hd__diode_2
XFILLER_131_3 VPWR VGND VPWR VGND sky130_ef_sc_hd__decap_40_12
XFILLER_12_557 VPWR VGND VPWR VGND sky130_ef_sc_hd__decap_40_12
XANTENNA__3566__S _3574_/S VGND VGND VPWR VPWR sky130_fd_sc_hd__diode_2
XANTENNA__4251__A _4251_/A VGND VGND VPWR VPWR sky130_fd_sc_hd__diode_2
XFILLER_138_776 VGND VGND VPWR VPWR sky130_fd_sc_hd__fill_8
XFILLER_125_404 VGND VGND VPWR VPWR sky130_fd_sc_hd__fill_4
XFILLER_6_29 VGND VGND VPWR VPWR sky130_fd_sc_hd__fill_4
XFILLER_4_701 VPWR VGND VPWR VGND sky130_ef_sc_hd__decap_40_12
XPHY_EDGE_ROW_128_Left_267 VGND VGND VPWR VPWR sky130_fd_sc_hd__decap_3
XFILLER_133_481 VPWR VGND VPWR VGND sky130_ef_sc_hd__decap_40_12
XFILLER_121_665 VGND VGND VPWR VPWR sky130_fd_sc_hd__fill_4
XFILLER_66_218 VGND VGND VPWR VPWR sky130_fd_sc_hd__fill_4
XANTENNA__4098__B1 _4271_/S1 VGND VGND VPWR VPWR sky130_fd_sc_hd__diode_2
XFILLER_120_197 VGND VGND VPWR VPWR sky130_fd_sc_hd__fill_1
XTAP_TAPCELL_ROW_89_1631 VGND VPWR sky130_fd_sc_hd__tapvpwrvgnd_1
XFILLER_59_281 VGND VGND VPWR VPWR sky130_fd_sc_hd__fill_4
XTAP_TAPCELL_ROW_89_1642 VGND VPWR sky130_fd_sc_hd__tapvpwrvgnd_1
XPHY_EDGE_ROW_137_Left_276 VGND VGND VPWR VPWR sky130_fd_sc_hd__decap_3
XFILLER_75_785 VPWR VGND VPWR VGND sky130_ef_sc_hd__decap_40_12
XFILLER_74_251 VGND VGND VPWR VPWR sky130_fd_sc_hd__fill_1
XFILLER_62_413 VGND VGND VPWR VPWR sky130_fd_sc_hd__fill_4
XFILLER_34_104 VGND VGND VPWR VPWR sky130_fd_sc_hd__fill_1
XFILLER_90_755 VGND VGND VPWR VPWR sky130_fd_sc_hd__fill_1
XFILLER_16_841 VGND VGND VPWR VPWR sky130_fd_sc_hd__fill_1
XFILLER_43_671 VGND VGND VPWR VPWR sky130_fd_sc_hd__fill_1
XANTENNA__6414__Q _6414_/Q VGND VGND VPWR VPWR sky130_fd_sc_hd__diode_2
X_2880_ _2876_/X _2878_/X _2879_/X _3096_/A1 VGND VGND VPWR VPWR _2880_/X sky130_fd_sc_hd__a22o_1
XANTENNA__4860__S _4867_/S VGND VGND VPWR VPWR sky130_fd_sc_hd__diode_2
XFILLER_31_833 VGND VGND VPWR VPWR sky130_fd_sc_hd__fill_4
XFILLER_129_721 VGND VGND VPWR VPWR sky130_fd_sc_hd__fill_4
XANTENNA__3476__S _3477_/S VGND VGND VPWR VPWR sky130_fd_sc_hd__diode_2
XANTENNA_hold2086_A _6411_/Q VGND VGND VPWR VPWR sky130_fd_sc_hd__diode_2
XFILLER_129_765 VPWR VGND VPWR VGND sky130_ef_sc_hd__decap_40_12
XTAP_TAPCELL_ROW_116_2038 VGND VPWR sky130_fd_sc_hd__tapvpwrvgnd_1
X_4550_ hold493/X _4882_/A1 _4561_/S VGND VGND VPWR VPWR _4550_/X sky130_fd_sc_hd__mux2_1
Xhold506 _3454_/X VGND VGND VPWR VPWR _5503_/D sky130_fd_sc_hd__dlygate4sd3_1
X_3501_ _4904_/A0 _3501_/A1 _3503_/S VGND VGND VPWR VPWR _3501_/X sky130_fd_sc_hd__mux2_1
Xhold517 _3598_/X VGND VGND VPWR VPWR _5631_/D sky130_fd_sc_hd__dlygate4sd3_1
XFILLER_7_561 VPWR VGND VPWR VGND sky130_ef_sc_hd__decap_40_12
X_4481_ hold614/X _5215_/A1 _4482_/S VGND VGND VPWR VPWR _4481_/X sky130_fd_sc_hd__mux2_1
XFILLER_116_459 VGND VGND VPWR VPWR sky130_fd_sc_hd__fill_1
X_6220_ _6232_/CLK _6220_/D VGND VGND VPWR VPWR _6220_/Q sky130_fd_sc_hd__dfxtp_1
X_3432_ _3432_/A0 _4901_/A0 _3437_/S VGND VGND VPWR VPWR _3432_/X sky130_fd_sc_hd__mux2_1
Xhold528 _5932_/Q VGND VGND VPWR VPWR hold528/X sky130_fd_sc_hd__dlygate4sd3_1
Xhold539 _3631_/X VGND VGND VPWR VPWR _5659_/D sky130_fd_sc_hd__dlygate4sd3_1
XANTENNA__4325__A1 _5047_/A1 VGND VGND VPWR VPWR sky130_fd_sc_hd__diode_2
XFILLER_98_811 VGND VGND VPWR VPWR sky130_fd_sc_hd__fill_1
XFILLER_97_310 VGND VGND VPWR VPWR sky130_fd_sc_hd__fill_2
X_6151_ _6232_/CLK _6151_/D VGND VGND VPWR VPWR _6151_/Q sky130_fd_sc_hd__dfxtp_1
X_3363_ _5210_/A0 _3362_/X _3365_/S VGND VGND VPWR VPWR _3363_/X sky130_fd_sc_hd__mux2_1
XFILLER_112_643 VGND VGND VPWR VPWR sky130_fd_sc_hd__fill_1
XANTENNA__2887__A1 _3031_/A1 VGND VGND VPWR VPWR sky130_fd_sc_hd__diode_2
X_5102_ _5102_/A _5112_/B VGND VGND VPWR VPWR _5102_/Y sky130_fd_sc_hd__nand2_1
Xhold1206 _5244_/Q VGND VGND VPWR VPWR _2671_/A0 sky130_fd_sc_hd__dlygate4sd3_1
X_3294_ _3294_/A0 _4905_/A0 _3295_/S VGND VGND VPWR VPWR _3294_/X sky130_fd_sc_hd__mux2_1
XTAP_TAPCELL_ROW_111_1971 VGND VPWR sky130_fd_sc_hd__tapvpwrvgnd_1
XTAP_TAPCELL_ROW_111_1960 VGND VPWR sky130_fd_sc_hd__tapvpwrvgnd_1
XFILLER_100_805 VGND VGND VPWR VPWR sky130_fd_sc_hd__fill_4
X_6082_ _6417_/CLK _6082_/D VGND VGND VPWR VPWR _6082_/Q sky130_fd_sc_hd__dfxtp_1
Xhold1217 _6221_/Q VGND VGND VPWR VPWR _4871_/A0 sky130_fd_sc_hd__dlygate4sd3_1
Xhold1228 _3539_/X VGND VGND VPWR VPWR _5582_/D sky130_fd_sc_hd__dlygate4sd3_1
X_5033_ _6460_/A _2653_/Y _6373_/Q VGND VGND VPWR VPWR _5034_/C sky130_fd_sc_hd__a21o_1
Xhold1239 _3764_/X VGND VGND VPWR VPWR _5775_/D sky130_fd_sc_hd__dlygate4sd3_1
XFILLER_38_421 VGND VGND VPWR VPWR sky130_fd_sc_hd__fill_4
XFILLER_122_29 VPWR VGND VPWR VGND sky130_ef_sc_hd__decap_40_12
XFILLER_66_741 VGND VGND VPWR VPWR sky130_fd_sc_hd__fill_1
XFILLER_53_413 VGND VGND VPWR VPWR sky130_fd_sc_hd__fill_1
XFILLER_80_243 VGND VGND VPWR VPWR sky130_fd_sc_hd__fill_2
XANTENNA_fanout169_A _4228_/S VGND VGND VPWR VPWR sky130_fd_sc_hd__diode_2
XANTENNA__3064__A1 _3092_/A VGND VGND VPWR VPWR sky130_fd_sc_hd__diode_2
X_5935_ _6339_/CLK _5935_/D VGND VGND VPWR VPWR _5935_/Q sky130_fd_sc_hd__dfxtp_1
XFILLER_22_811 VGND VGND VPWR VPWR sky130_fd_sc_hd__fill_1
X_5866_ _6095_/CLK _5866_/D VGND VGND VPWR VPWR _5866_/Q sky130_fd_sc_hd__dfxtp_1
Xclkbuf_leaf_60_clk clkload6/A VGND VGND VPWR VPWR _6437_/CLK sky130_fd_sc_hd__clkbuf_8
X_4817_ _4882_/A1 _4817_/A1 _4828_/S VGND VGND VPWR VPWR _6171_/D sky130_fd_sc_hd__mux2_1
X_5797_ _6114_/CLK _5797_/D VGND VGND VPWR VPWR _5797_/Q sky130_fd_sc_hd__dfxtp_1
XFILLER_21_387 VGND VGND VPWR VPWR sky130_fd_sc_hd__fill_4
XANTENNA__3386__S _3390_/S VGND VGND VPWR VPWR sky130_fd_sc_hd__diode_2
XFILLER_119_264 VGND VGND VPWR VPWR sky130_fd_sc_hd__fill_1
XANTENNA_fanout124_X _5080_/A0 VGND VGND VPWR VPWR sky130_fd_sc_hd__diode_2
X_4748_ _5802_/Q _5793_/Q _6123_/Q _6114_/Q _4803_/S _4802_/A VGND VGND VPWR VPWR
+ _4748_/X sky130_fd_sc_hd__mux4_1
X_4679_ _5616_/Q _6294_/Q _4773_/S VGND VGND VPWR VPWR _4680_/B sky130_fd_sc_hd__mux2_1
X_6418_ _6418_/CLK _6418_/D VGND VGND VPWR VPWR _6418_/Q sky130_fd_sc_hd__dfxtp_1
XPHY_EDGE_ROW_1_Right_1 VGND VGND VPWR VPWR sky130_fd_sc_hd__decap_3
Xoutput48 _5440_/Q VGND VGND VPWR VPWR s_axil_rdata[4] sky130_fd_sc_hd__buf_2
XFILLER_89_833 VGND VGND VPWR VPWR sky130_fd_sc_hd__fill_4
Xoutput37 _5807_/Q VGND VGND VPWR VPWR s_axil_bvalid sky130_fd_sc_hd__buf_2
XANTENNA__2878__A1 _3036_/A1 VGND VGND VPWR VPWR sky130_fd_sc_hd__diode_2
X_6349_ _6349_/CLK _6349_/D VGND VGND VPWR VPWR _6349_/Q sky130_fd_sc_hd__dfxtp_1
XFILLER_0_225 VGND VGND VPWR VPWR sky130_fd_sc_hd__fill_2
XFILLER_103_665 VGND VGND VPWR VPWR sky130_fd_sc_hd__fill_4
XFILLER_88_365 VGND VGND VPWR VPWR sky130_fd_sc_hd__fill_1
XFILLER_102_197 VGND VGND VPWR VPWR sky130_fd_sc_hd__fill_4
XFILLER_69_590 VGND VGND VPWR VPWR sky130_fd_sc_hd__fill_1
Xhold1762 _5781_/Q VGND VGND VPWR VPWR _4105_/A0 sky130_fd_sc_hd__dlygate4sd3_1
Xhold1740 _5459_/Q VGND VGND VPWR VPWR _3404_/A1 sky130_fd_sc_hd__dlygate4sd3_1
Xhold1751 _6289_/Q VGND VGND VPWR VPWR _4954_/A1 sky130_fd_sc_hd__dlygate4sd3_1
Xhold1773 _3286_/X VGND VGND VPWR VPWR _5405_/D sky130_fd_sc_hd__dlygate4sd3_1
XFILLER_57_785 VPWR VGND VPWR VGND sky130_ef_sc_hd__decap_40_12
XFILLER_57_774 VGND VGND VPWR VPWR sky130_fd_sc_hd__fill_8
Xhold1795 _3750_/X VGND VGND VPWR VPWR _5763_/D sky130_fd_sc_hd__dlygate4sd3_1
Xhold1784 _6309_/Q VGND VGND VPWR VPWR _4977_/A0 sky130_fd_sc_hd__dlygate4sd3_1
XFILLER_72_755 VGND VGND VPWR VPWR sky130_fd_sc_hd__fill_1
XFILLER_71_210 VGND VGND VPWR VPWR sky130_fd_sc_hd__fill_4
XTAP_TAPCELL_ROW_84_1561 VGND VPWR sky130_fd_sc_hd__tapvpwrvgnd_1
XFILLER_71_276 VGND VGND VPWR VPWR sky130_fd_sc_hd__fill_4
XANTENNA__4252__B1 _4252_/B1 VGND VGND VPWR VPWR sky130_fd_sc_hd__diode_2
XFILLER_25_660 VGND VGND VPWR VPWR sky130_fd_sc_hd__fill_1
XFILLER_12_321 VGND VGND VPWR VPWR sky130_fd_sc_hd__fill_1
XFILLER_13_833 VGND VGND VPWR VPWR sky130_fd_sc_hd__fill_4
XTAP_TAPCELL_ROW_27_699 VGND VPWR sky130_fd_sc_hd__tapvpwrvgnd_1
Xclkbuf_leaf_51_clk clkload6/A VGND VGND VPWR VPWR _6232_/CLK sky130_fd_sc_hd__clkbuf_8
XFILLER_12_343 VGND VGND VPWR VPWR sky130_fd_sc_hd__fill_1
XFILLER_9_837 VGND VGND VPWR VPWR sky130_fd_sc_hd__fill_2
XFILLER_12_365 VPWR VGND VPWR VGND sky130_ef_sc_hd__decap_40_12
XANTENNA__4555__A1 _4887_/A1 VGND VGND VPWR VPWR sky130_fd_sc_hd__diode_2
XANTENNA__3358__A2 _5035_/C VGND VGND VPWR VPWR sky130_fd_sc_hd__diode_2
XFILLER_138_573 VPWR VGND VPWR VGND sky130_ef_sc_hd__decap_40_12
XFILLER_126_713 VPWR VGND VPWR VGND sky130_ef_sc_hd__decap_40_12
XFILLER_126_757 VPWR VGND VPWR VGND sky130_ef_sc_hd__decap_40_12
XANTENNA__4307__A1 _5051_/A1 VGND VGND VPWR VPWR sky130_fd_sc_hd__diode_2
XFILLER_4_531 VGND VGND VPWR VPWR sky130_fd_sc_hd__fill_1
XFILLER_21_81 VGND VGND VPWR VPWR sky130_fd_sc_hd__fill_2
XFILLER_98_118 VGND VGND VPWR VPWR sky130_fd_sc_hd__fill_4
XFILLER_0_781 VGND VGND VPWR VPWR sky130_fd_sc_hd__fill_2
XANTENNA__3294__A1 _4905_/A0 VGND VGND VPWR VPWR sky130_fd_sc_hd__diode_2
XANTENNA__4491__A0 _5215_/A1 VGND VGND VPWR VPWR sky130_fd_sc_hd__diode_2
XANTENNA__4156__A _4212_/A VGND VGND VPWR VPWR sky130_fd_sc_hd__diode_2
X_3981_ _3988_/B _5117_/A VGND VGND VPWR VPWR _3987_/B sky130_fd_sc_hd__and2b_1
XTAP_TAPCELL_ROW_46_986 VGND VPWR sky130_fd_sc_hd__tapvpwrvgnd_1
XANTENNA__4243__B1 _3172_/B VGND VGND VPWR VPWR sky130_fd_sc_hd__diode_2
X_2932_ _5543_/Q _5567_/Q _3077_/S VGND VGND VPWR VPWR _2933_/B sky130_fd_sc_hd__mux2_1
XFILLER_90_585 VGND VGND VPWR VPWR sky130_fd_sc_hd__fill_2
XANTENNA__4443__X _4443_/X VGND VGND VPWR VPWR sky130_fd_sc_hd__diode_2
X_5720_ _6290_/CLK _5720_/D VGND VGND VPWR VPWR _5720_/Q sky130_fd_sc_hd__dfxtp_1
XFILLER_50_449 VGND VGND VPWR VPWR sky130_fd_sc_hd__fill_2
XFILLER_50_427 VGND VGND VPWR VPWR sky130_fd_sc_hd__fill_1
XTAP_TAPCELL_ROW_46_997 VGND VPWR sky130_fd_sc_hd__tapvpwrvgnd_1
XFILLER_16_693 VGND VGND VPWR VPWR sky130_fd_sc_hd__fill_4
Xclkbuf_leaf_42_clk clkload4/A VGND VGND VPWR VPWR _6432_/CLK sky130_fd_sc_hd__clkbuf_8
XFILLER_94_3 VPWR VGND VPWR VGND sky130_ef_sc_hd__decap_40_12
X_2863_ _3031_/A1 _2862_/X _3076_/A1 VGND VGND VPWR VPWR _2863_/X sky130_fd_sc_hd__o21a_1
X_5651_ _5898_/CLK _5651_/D VGND VGND VPWR VPWR _5651_/Q sky130_fd_sc_hd__dfxtp_1
X_2794_ _2790_/X _2792_/X _2793_/X _3075_/C1 VGND VGND VPWR VPWR _2794_/X sky130_fd_sc_hd__a22o_1
XANTENNA__4546__A1 _5080_/A0 VGND VGND VPWR VPWR sky130_fd_sc_hd__diode_2
X_5582_ _5583_/CLK _5582_/D VGND VGND VPWR VPWR _5582_/Q sky130_fd_sc_hd__dfxtp_1
X_4602_ _4811_/A1 _4601_/X _4811_/C1 VGND VGND VPWR VPWR _4602_/X sky130_fd_sc_hd__o21a_1
XFILLER_129_573 VPWR VGND VPWR VGND sky130_ef_sc_hd__decap_40_12
X_4533_ hold159/X _5235_/A0 _4535_/S VGND VGND VPWR VPWR _4533_/X sky130_fd_sc_hd__mux2_1
Xhold314 _4450_/X VGND VGND VPWR VPWR _6064_/D sky130_fd_sc_hd__dlygate4sd3_1
Xhold325 _6143_/Q VGND VGND VPWR VPWR hold325/X sky130_fd_sc_hd__dlygate4sd3_1
Xhold303 _5363_/Q VGND VGND VPWR VPWR hold303/X sky130_fd_sc_hd__dlygate4sd3_1
XFILLER_7_391 VGND VGND VPWR VPWR sky130_fd_sc_hd__fill_1
X_4464_ _5241_/A1 _4464_/A1 _4472_/S VGND VGND VPWR VPWR _6072_/D sky130_fd_sc_hd__mux2_1
Xhold347 _5751_/Q VGND VGND VPWR VPWR hold347/X sky130_fd_sc_hd__dlygate4sd3_1
X_6203_ _6239_/CLK _6203_/D VGND VGND VPWR VPWR _6203_/Q sky130_fd_sc_hd__dfxtp_1
Xhold336 _3925_/X VGND VGND VPWR VPWR _5902_/D sky130_fd_sc_hd__dlygate4sd3_1
Xhold369 _5655_/Q VGND VGND VPWR VPWR hold369/X sky130_fd_sc_hd__dlygate4sd3_1
Xhold358 _3641_/X VGND VGND VPWR VPWR _5668_/D sky130_fd_sc_hd__dlygate4sd3_1
XFILLER_132_749 VGND VGND VPWR VPWR sky130_fd_sc_hd__fill_4
XFILLER_98_641 VGND VGND VPWR VPWR sky130_fd_sc_hd__fill_2
X_3415_ hold928/X _5208_/A1 _3423_/S VGND VGND VPWR VPWR _3415_/X sky130_fd_sc_hd__mux2_1
X_4395_ _4983_/A1 _4395_/A1 _4396_/S VGND VGND VPWR VPWR _4395_/X sky130_fd_sc_hd__mux2_1
XTAP_TAPCELL_ROW_129_2229 VGND VPWR sky130_fd_sc_hd__tapvpwrvgnd_1
XANTENNA__2955__S1 _3005_/A VGND VGND VPWR VPWR sky130_fd_sc_hd__diode_2
XFILLER_86_825 VPWR VGND VPWR VGND sky130_ef_sc_hd__decap_40_12
X_6134_ _6398_/CLK _6134_/D VGND VGND VPWR VPWR hold22/A sky130_fd_sc_hd__dfxtp_1
X_3346_ _5034_/B _3346_/B _3346_/C _3798_/B VGND VGND VPWR VPWR _5428_/D sky130_fd_sc_hd__and4_1
XFILLER_133_39 VGND VGND VPWR VPWR sky130_fd_sc_hd__fill_8
XFILLER_100_613 VPWR VGND VPWR VGND sky130_ef_sc_hd__decap_40_12
Xhold1003 _6155_/Q VGND VGND VPWR VPWR _4555_/A0 sky130_fd_sc_hd__dlygate4sd3_1
XFILLER_85_335 VGND VGND VPWR VPWR sky130_fd_sc_hd__fill_1
X_6065_ _6065_/CLK _6065_/D VGND VGND VPWR VPWR _6065_/Q sky130_fd_sc_hd__dfxtp_1
XTAP_TAPCELL_ROW_51_1059 VGND VPWR sky130_fd_sc_hd__tapvpwrvgnd_1
Xhold1014 _5889_/Q VGND VGND VPWR VPWR _3911_/A0 sky130_fd_sc_hd__dlygate4sd3_1
Xhold1058 _6435_/Q VGND VGND VPWR VPWR _5238_/A0 sky130_fd_sc_hd__dlygate4sd3_1
XFILLER_100_657 VPWR VGND VPWR VGND sky130_ef_sc_hd__decap_40_12
X_3277_ _4813_/S _3278_/C _3276_/Y VGND VGND VPWR VPWR _5400_/D sky130_fd_sc_hd__o21a_1
Xhold1025 _3780_/X VGND VGND VPWR VPWR _5788_/D sky130_fd_sc_hd__dlygate4sd3_1
X_5016_ _6329_/Q _5429_/Q _5001_/B _5430_/Q _5015_/Y VGND VGND VPWR VPWR _5016_/X
+ sky130_fd_sc_hd__o221a_1
Xhold1036 _5746_/Q VGND VGND VPWR VPWR _3728_/A0 sky130_fd_sc_hd__dlygate4sd3_1
Xhold1047 _4942_/X VGND VGND VPWR VPWR _6278_/D sky130_fd_sc_hd__dlygate4sd3_1
XANTENNA__3285__A1 _5239_/A1 VGND VGND VPWR VPWR sky130_fd_sc_hd__diode_2
Xhold1069 _4472_/X VGND VGND VPWR VPWR _6080_/D sky130_fd_sc_hd__dlygate4sd3_1
XFILLER_54_711 VGND VGND VPWR VPWR sky130_fd_sc_hd__fill_4
XFILLER_26_15 VGND VGND VPWR VPWR sky130_fd_sc_hd__fill_2
XFILLER_26_413 VGND VGND VPWR VPWR sky130_fd_sc_hd__fill_4
XFILLER_39_785 VPWR VGND VPWR VGND sky130_ef_sc_hd__decap_40_12
XFILLER_81_541 VGND VGND VPWR VPWR sky130_fd_sc_hd__fill_2
XFILLER_54_777 VPWR VGND VPWR VGND sky130_ef_sc_hd__decap_40_12
XFILLER_26_457 VGND VGND VPWR VPWR sky130_fd_sc_hd__fill_8
X_5918_ _6421_/CLK _5918_/D VGND VGND VPWR VPWR _5918_/Q sky130_fd_sc_hd__dfxtp_2
Xclkbuf_leaf_33_clk clkload4/A VGND VGND VPWR VPWR _6146_/CLK sky130_fd_sc_hd__clkbuf_8
XTAP_TAPCELL_ROW_66_1291 VGND VPWR sky130_fd_sc_hd__tapvpwrvgnd_1
XTAP_TAPCELL_ROW_24_658 VGND VPWR sky130_fd_sc_hd__tapvpwrvgnd_1
X_5849_ _5849_/CLK _5849_/D VGND VGND VPWR VPWR _5849_/Q sky130_fd_sc_hd__dfxtp_1
XFILLER_10_825 VPWR VGND VPWR VGND sky130_ef_sc_hd__decap_40_12
XFILLER_21_140 VGND VGND VPWR VPWR sky130_fd_sc_hd__fill_2
XANTENNA__4537__A1 _5820_/Q VGND VGND VPWR VPWR sky130_fd_sc_hd__diode_2
XFILLER_108_713 VPWR VGND VPWR VGND sky130_ef_sc_hd__decap_40_12
XANTENNA__4632__S1 _4802_/A VGND VGND VPWR VPWR sky130_fd_sc_hd__diode_2
XFILLER_108_757 VPWR VGND VPWR VGND sky130_ef_sc_hd__decap_40_12
XFILLER_123_727 VGND VGND VPWR VPWR sky130_fd_sc_hd__fill_1
XFILLER_1_501 VGND VGND VPWR VPWR sky130_fd_sc_hd__fill_2
Xhold870 _4537_/X VGND VGND VPWR VPWR _6139_/D sky130_fd_sc_hd__dlygate4sd3_1
XFILLER_122_215 VGND VGND VPWR VPWR sky130_fd_sc_hd__fill_2
Xhold881 _3189_/X VGND VGND VPWR VPWR _5352_/D sky130_fd_sc_hd__dlygate4sd3_1
Xhold892 _5358_/Q VGND VGND VPWR VPWR hold892/X sky130_fd_sc_hd__dlygate4sd3_1
XFILLER_49_505 VGND VGND VPWR VPWR sky130_fd_sc_hd__fill_1
XFILLER_67_55 VGND VGND VPWR VPWR sky130_fd_sc_hd__fill_1
XANTENNA__4148__S0 _4228_/S VGND VGND VPWR VPWR sky130_fd_sc_hd__diode_2
XFILLER_49_549 VGND VGND VPWR VPWR sky130_fd_sc_hd__fill_1
XFILLER_49_538 VGND VGND VPWR VPWR sky130_fd_sc_hd__fill_1
XFILLER_49_516 VGND VGND VPWR VPWR sky130_fd_sc_hd__fill_1
XANTENNA__4699__S1 _4809_/A VGND VGND VPWR VPWR sky130_fd_sc_hd__diode_2
Xhold1570 _5541_/Q VGND VGND VPWR VPWR _3496_/A1 sky130_fd_sc_hd__dlygate4sd3_1
XTAP_TAPCELL_ROW_4_361 VGND VPWR sky130_fd_sc_hd__tapvpwrvgnd_1
Xhold1592 _6367_/Q VGND VGND VPWR VPWR _5076_/A1 sky130_fd_sc_hd__dlygate4sd3_1
XANTENNA_input14_A s_axil_wdata[11] VGND VGND VPWR VPWR sky130_fd_sc_hd__diode_2
XFILLER_83_32 VPWR VGND VPWR VGND sky130_ef_sc_hd__decap_40_12
Xhold1581 _4410_/X VGND VGND VPWR VPWR _6047_/D sky130_fd_sc_hd__dlygate4sd3_1
XFILLER_44_232 VGND VGND VPWR VPWR sky130_fd_sc_hd__fill_4
XANTENNA__4776__A1 _4791_/A1 VGND VGND VPWR VPWR sky130_fd_sc_hd__diode_2
XFILLER_44_276 VGND VGND VPWR VPWR sky130_fd_sc_hd__fill_1
XTAP_TAPCELL_ROW_43_945 VGND VPWR sky130_fd_sc_hd__tapvpwrvgnd_1
XANTENNA__2787__B1 _3075_/C1 VGND VGND VPWR VPWR sky130_fd_sc_hd__diode_2
Xclkbuf_leaf_24_clk clkload3/A VGND VGND VPWR VPWR _6402_/CLK sky130_fd_sc_hd__clkbuf_8
XFILLER_13_641 VPWR VGND VPWR VGND sky130_ef_sc_hd__decap_40_12
XFILLER_16_81 VGND VGND VPWR VPWR sky130_fd_sc_hd__fill_1
XANTENNA__2882__S0 _2963_/S VGND VGND VPWR VPWR sky130_fd_sc_hd__diode_2
XANTENNA__4423__B input4/X VGND VGND VPWR VPWR sky130_fd_sc_hd__diode_2
XFILLER_13_685 VPWR VGND VPWR VGND sky130_ef_sc_hd__decap_40_12
XANTENNA__4528__A1 _4886_/A1 VGND VGND VPWR VPWR sky130_fd_sc_hd__diode_2
XANTENNA__3200__A1 _5075_/A0 VGND VGND VPWR VPWR sky130_fd_sc_hd__diode_2
XTAP_TAPCELL_ROW_97_1752 VGND VPWR sky130_fd_sc_hd__tapvpwrvgnd_1
XFILLER_126_587 VGND VGND VPWR VPWR sky130_fd_sc_hd__fill_1
XFILLER_114_749 VGND VGND VPWR VPWR sky130_fd_sc_hd__fill_4
X_3200_ hold77/X _5075_/A0 _3206_/S VGND VGND VPWR VPWR hold78/A sky130_fd_sc_hd__mux2_1
XANTENNA__4161__C1 _5343_/Q VGND VGND VPWR VPWR sky130_fd_sc_hd__diode_2
X_4180_ _4252_/A1 _4179_/X _4252_/B1 VGND VGND VPWR VPWR _4180_/X sky130_fd_sc_hd__o21a_1
XANTENNA__4700__B2 _4663_/A VGND VGND VPWR VPWR sky130_fd_sc_hd__diode_2
XFILLER_122_793 VPWR VGND VPWR VGND sky130_ef_sc_hd__decap_40_12
X_3131_ _3131_/A _3402_/B VGND VGND VPWR VPWR _5050_/B sky130_fd_sc_hd__nand2_8
XANTENNA__2711__A0 _5042_/A1 VGND VGND VPWR VPWR sky130_fd_sc_hd__diode_2
XFILLER_121_292 VGND VGND VPWR VPWR sky130_fd_sc_hd__fill_1
XFILLER_121_281 VGND VGND VPWR VPWR sky130_fd_sc_hd__fill_1
XANTENNA__4464__A0 _5241_/A1 VGND VGND VPWR VPWR sky130_fd_sc_hd__diode_2
X_3062_ _6181_/Q _6205_/Q _3062_/S VGND VGND VPWR VPWR _3062_/X sky130_fd_sc_hd__mux2_1
XFILLER_83_839 VGND VGND VPWR VPWR sky130_fd_sc_hd__fill_1
XFILLER_67_368 VGND VGND VPWR VPWR sky130_fd_sc_hd__fill_1
XFILLER_48_560 VGND VGND VPWR VPWR sky130_fd_sc_hd__fill_1
XTAP_TAPCELL_ROW_124_2159 VGND VPWR sky130_fd_sc_hd__tapvpwrvgnd_1
XFILLER_63_563 VGND VGND VPWR VPWR sky130_fd_sc_hd__fill_4
XFILLER_23_405 VPWR VGND VPWR VGND sky130_ef_sc_hd__decap_40_12
XFILLER_35_276 VGND VGND VPWR VPWR sky130_fd_sc_hd__fill_1
XFILLER_35_287 VGND VGND VPWR VPWR sky130_fd_sc_hd__fill_2
XTAP_TAPCELL_ROW_106_1892 VGND VPWR sky130_fd_sc_hd__tapvpwrvgnd_1
Xclkbuf_leaf_15_clk clkbuf_leaf_9_clk/A VGND VGND VPWR VPWR _6405_/CLK sky130_fd_sc_hd__clkbuf_8
X_3964_ _3975_/A _3964_/B _6385_/Q _3975_/C VGND VGND VPWR VPWR _4010_/B sky130_fd_sc_hd__or4bb_2
XFILLER_23_449 VPWR VGND VPWR VGND sky130_ef_sc_hd__decap_40_12
X_2915_ _3031_/A1 _2914_/X _3075_/C1 VGND VGND VPWR VPWR _2915_/X sky130_fd_sc_hd__o21a_1
X_3895_ _3895_/A0 _4488_/A0 _3899_/S VGND VGND VPWR VPWR _3895_/X sky130_fd_sc_hd__mux2_1
X_5703_ _5898_/CLK _5703_/D VGND VGND VPWR VPWR _5703_/Q sky130_fd_sc_hd__dfxtp_1
XTAP_TAPCELL_ROW_21_617 VGND VPWR sky130_fd_sc_hd__tapvpwrvgnd_1
X_2846_ _3094_/C1 _2841_/X _2843_/X _2845_/X VGND VGND VPWR VPWR _2846_/X sky130_fd_sc_hd__a22o_1
X_5634_ _6382_/CLK _5634_/D VGND VGND VPWR VPWR _5634_/Q sky130_fd_sc_hd__dfxtp_1
XANTENNA__4519__A1 _5213_/A1 VGND VGND VPWR VPWR sky130_fd_sc_hd__diode_2
XANTENNA__5192__A1 _3958_/A VGND VGND VPWR VPWR sky130_fd_sc_hd__diode_2
XANTENNA__4614__S1 _4794_/A VGND VGND VPWR VPWR sky130_fd_sc_hd__diode_2
X_5565_ _5565_/CLK _5565_/D VGND VGND VPWR VPWR _5565_/Q sky130_fd_sc_hd__dfxtp_1
Xhold100 _3459_/X VGND VGND VPWR VPWR _5508_/D sky130_fd_sc_hd__dlygate4sd3_1
XANTENNA__3517__X _3529_/S VGND VGND VPWR VPWR sky130_fd_sc_hd__diode_2
X_2777_ _3036_/A1 _2776_/X _3094_/C1 VGND VGND VPWR VPWR _2777_/Y sky130_fd_sc_hd__o21ai_1
XANTENNA__3664__S _3667_/S VGND VGND VPWR VPWR sky130_fd_sc_hd__diode_2
XFILLER_132_513 VPWR VGND VPWR VGND sky130_ef_sc_hd__decap_40_12
Xhold133 _5491_/Q VGND VGND VPWR VPWR hold133/X sky130_fd_sc_hd__dlygate4sd3_1
XFILLER_105_727 VGND VGND VPWR VPWR sky130_fd_sc_hd__fill_1
X_5496_ _6399_/CLK _5496_/D VGND VGND VPWR VPWR _5496_/Q sky130_fd_sc_hd__dfxtp_1
Xhold144 _3891_/X VGND VGND VPWR VPWR _5870_/D sky130_fd_sc_hd__dlygate4sd3_1
XANTENNA_fanout201_A _2682_/A VGND VGND VPWR VPWR sky130_fd_sc_hd__diode_2
Xhold122 _4989_/X VGND VGND VPWR VPWR _6321_/D sky130_fd_sc_hd__dlygate4sd3_1
Xhold111 _5717_/Q VGND VGND VPWR VPWR hold111/X sky130_fd_sc_hd__dlygate4sd3_1
X_4516_ hold139/X _5210_/A1 _4522_/S VGND VGND VPWR VPWR _4516_/X sky130_fd_sc_hd__mux2_1
X_4447_ _4447_/A1 _4457_/S _4445_/X _4446_/X VGND VGND VPWR VPWR _4447_/X sky130_fd_sc_hd__o22a_1
Xhold155 _5364_/Q VGND VGND VPWR VPWR hold155/X sky130_fd_sc_hd__dlygate4sd3_1
Xhold166 _4348_/X VGND VGND VPWR VPWR _5991_/D sky130_fd_sc_hd__dlygate4sd3_1
Xhold177 _5795_/Q VGND VGND VPWR VPWR hold177/X sky130_fd_sc_hd__dlygate4sd3_1
XFILLER_132_557 VPWR VGND VPWR VGND sky130_ef_sc_hd__decap_40_12
Xhold188 _4385_/X VGND VGND VPWR VPWR _6025_/D sky130_fd_sc_hd__dlygate4sd3_1
Xhold199 _5452_/Q VGND VGND VPWR VPWR hold199/X sky130_fd_sc_hd__dlygate4sd3_1
XANTENNA_input6_A s_axil_arvalid VGND VGND VPWR VPWR sky130_fd_sc_hd__diode_2
X_4378_ hold602/X _5051_/A1 _4386_/S VGND VGND VPWR VPWR _4378_/X sky130_fd_sc_hd__mux2_1
X_6117_ _6125_/CLK _6117_/D VGND VGND VPWR VPWR _6117_/Q sky130_fd_sc_hd__dfxtp_1
XANTENNA_fanout191_X _3086_/S VGND VGND VPWR VPWR sky130_fd_sc_hd__diode_2
X_3329_ _3326_/X _3327_/Y _3328_/Y VGND VGND VPWR VPWR _5060_/A sky130_fd_sc_hd__a21oi_4
XFILLER_74_839 VGND VGND VPWR VPWR sky130_fd_sc_hd__fill_1
XFILLER_58_379 VGND VGND VPWR VPWR sky130_fd_sc_hd__fill_1
XTAP_TAPCELL_ROW_29_728 VGND VPWR sky130_fd_sc_hd__tapvpwrvgnd_1
X_6048_ _6349_/CLK _6048_/D VGND VGND VPWR VPWR _6048_/Q sky130_fd_sc_hd__dfxtp_1
XTAP_TAPCELL_ROW_68_1320 VGND VPWR sky130_fd_sc_hd__tapvpwrvgnd_1
XFILLER_66_390 VGND VGND VPWR VPWR sky130_fd_sc_hd__fill_1
XFILLER_54_530 VGND VGND VPWR VPWR sky130_fd_sc_hd__fill_2
XTAP_TAPCELL_ROW_1_320 VGND VPWR sky130_fd_sc_hd__tapvpwrvgnd_1
XTAP_TAPCELL_ROW_29_739 VGND VPWR sky130_fd_sc_hd__tapvpwrvgnd_1
XTAP_TAPCELL_ROW_81_1520 VGND VPWR sky130_fd_sc_hd__tapvpwrvgnd_1
XANTENNA__2864__S0 _3033_/S VGND VGND VPWR VPWR sky130_fd_sc_hd__diode_2
XANTENNA__3430__A1 _4886_/A1 VGND VGND VPWR VPWR sky130_fd_sc_hd__diode_2
XTAP_TAPCELL_ROW_40_904 VGND VPWR sky130_fd_sc_hd__tapvpwrvgnd_1
XFILLER_136_841 VGND VGND VPWR VPWR sky130_fd_sc_hd__fill_1
XFILLER_108_521 VGND VGND VPWR VPWR sky130_fd_sc_hd__fill_8
XANTENNA__3574__S _3574_/S VGND VGND VPWR VPWR sky130_fd_sc_hd__diode_2
XFILLER_10_699 VGND VGND VPWR VPWR sky130_fd_sc_hd__fill_1
XFILLER_6_637 VGND VGND VPWR VPWR sky130_fd_sc_hd__fill_4
XFILLER_5_125 VGND VGND VPWR VPWR sky130_fd_sc_hd__fill_2
XFILLER_108_587 VGND VGND VPWR VPWR sky130_fd_sc_hd__fill_1
XTAP_TAPCELL_ROW_79_1482 VGND VPWR sky130_fd_sc_hd__tapvpwrvgnd_1
XANTENNA__4930__A1 _4980_/A1 VGND VGND VPWR VPWR sky130_fd_sc_hd__diode_2
XTAP_TAPCELL_ROW_9_442 VGND VPWR sky130_fd_sc_hd__tapvpwrvgnd_1
XTAP_TAPCELL_ROW_9_431 VGND VPWR sky130_fd_sc_hd__tapvpwrvgnd_1
XFILLER_123_557 VGND VGND VPWR VPWR sky130_fd_sc_hd__fill_2
XTAP_TAPCELL_ROW_92_1682 VGND VPWR sky130_fd_sc_hd__tapvpwrvgnd_1
XFILLER_104_793 VPWR VGND VPWR VGND sky130_ef_sc_hd__decap_40_12
XFILLER_77_666 VGND VGND VPWR VPWR sky130_fd_sc_hd__fill_4
XFILLER_76_121 VGND VGND VPWR VPWR sky130_fd_sc_hd__fill_2
XFILLER_92_625 VPWR VGND VPWR VGND sky130_ef_sc_hd__decap_40_12
XFILLER_77_699 VGND VGND VPWR VPWR sky130_fd_sc_hd__fill_2
XANTENNA__4446__B1 _4427_/B VGND VGND VPWR VPWR sky130_fd_sc_hd__diode_2
XFILLER_76_176 VGND VGND VPWR VPWR sky130_fd_sc_hd__fill_4
Xhold2090 _6414_/Q VGND VGND VPWR VPWR hold2090/X sky130_fd_sc_hd__dlygate4sd3_1
XFILLER_94_75 VGND VGND VPWR VPWR sky130_fd_sc_hd__fill_1
XFILLER_91_113 VGND VGND VPWR VPWR sky130_fd_sc_hd__fill_2
XFILLER_92_669 VPWR VGND VPWR VGND sky130_ef_sc_hd__decap_40_12
XFILLER_91_157 VGND VGND VPWR VPWR sky130_fd_sc_hd__fill_1
XFILLER_18_755 VGND VGND VPWR VPWR sky130_fd_sc_hd__fill_1
XFILLER_45_585 VGND VGND VPWR VPWR sky130_fd_sc_hd__fill_4
XFILLER_27_91 VGND VGND VPWR VPWR sky130_fd_sc_hd__fill_1
XFILLER_33_714 VGND VGND VPWR VPWR sky130_fd_sc_hd__fill_2
XANTENNA__4749__A1 _4811_/C1 VGND VGND VPWR VPWR sky130_fd_sc_hd__diode_2
XANTENNA__3421__A1 _5214_/A1 VGND VGND VPWR VPWR sky130_fd_sc_hd__diode_2
XFILLER_20_419 VGND VGND VPWR VPWR sky130_fd_sc_hd__fill_1
X_2700_ _2634_/Y _3138_/B _2638_/A _2635_/Y VGND VGND VPWR VPWR _2704_/B sky130_fd_sc_hd__a22o_1
XFILLER_118_307 VGND VGND VPWR VPWR sky130_fd_sc_hd__fill_1
X_3680_ _4484_/A0 hold985/X _3688_/S VGND VGND VPWR VPWR _5702_/D sky130_fd_sc_hd__mux2_1
XANTENNA__3484__S _3490_/S VGND VGND VPWR VPWR sky130_fd_sc_hd__diode_2
XFILLER_127_841 VGND VGND VPWR VPWR sky130_fd_sc_hd__fill_1
XANTENNA__5174__A1 _3958_/A VGND VGND VPWR VPWR sky130_fd_sc_hd__diode_2
X_2631_ _3226_/B VGND VGND VPWR VPWR _3617_/C sky130_fd_sc_hd__inv_2
XFILLER_9_497 VGND VGND VPWR VPWR sky130_fd_sc_hd__fill_4
X_5350_ _5583_/CLK hold60/X VGND VGND VPWR VPWR hold59/A sky130_fd_sc_hd__dfxtp_1
XANTENNA_hold2166_A _6262_/Q VGND VGND VPWR VPWR sky130_fd_sc_hd__diode_2
X_5281_ _6137_/CLK _5281_/D VGND VGND VPWR VPWR _5281_/Q sky130_fd_sc_hd__dfxtp_1
X_4301_ hold137/X _5044_/A1 _4304_/S VGND VGND VPWR VPWR _4301_/X sky130_fd_sc_hd__mux2_1
XFILLER_114_557 VPWR VGND VPWR VGND sky130_ef_sc_hd__decap_40_12
X_4232_ _4272_/S _4232_/B VGND VGND VPWR VPWR _4232_/Y sky130_fd_sc_hd__nand2_1
XANTENNA__3488__A1 _4904_/A0 VGND VGND VPWR VPWR sky130_fd_sc_hd__diode_2
XFILLER_101_229 VGND VGND VPWR VPWR sky130_fd_sc_hd__fill_1
XFILLER_99_279 VGND VGND VPWR VPWR sky130_fd_sc_hd__fill_1
Xclkbuf_leaf_4_clk clkbuf_leaf_9_clk/A VGND VGND VPWR VPWR _5990_/CLK sky130_fd_sc_hd__clkbuf_8
XFILLER_67_121 VGND VGND VPWR VPWR sky130_fd_sc_hd__fill_2
X_4163_ _4163_/A1 _4218_/A _4147_/X _4162_/Y VGND VGND VPWR VPWR _4163_/X sky130_fd_sc_hd__a22o_1
X_3114_ _4868_/A _5225_/A VGND VGND VPWR VPWR _3126_/S sky130_fd_sc_hd__nor2_4
XFILLER_95_474 VGND VGND VPWR VPWR sky130_fd_sc_hd__fill_1
XFILLER_83_625 VGND VGND VPWR VPWR sky130_fd_sc_hd__fill_1
XANTENNA__4437__B1 _4434_/X VGND VGND VPWR VPWR sky130_fd_sc_hd__diode_2
XFILLER_67_154 VPWR VGND VPWR VGND sky130_ef_sc_hd__decap_40_12
X_4094_ _4090_/X _4091_/X _4093_/X _4092_/X _4264_/A1 _4149_/A VGND VGND VPWR VPWR
+ _4094_/X sky130_fd_sc_hd__mux4_1
X_3045_ _6433_/Q _5318_/Q _3072_/S VGND VGND VPWR VPWR _3045_/X sky130_fd_sc_hd__mux2_1
XTAP_TAPCELL_ROW_108_1921 VGND VPWR sky130_fd_sc_hd__tapvpwrvgnd_1
XANTENNA__4988__A1 _5042_/A1 VGND VGND VPWR VPWR sky130_fd_sc_hd__diode_2
XFILLER_24_703 VGND VGND VPWR VPWR sky130_fd_sc_hd__fill_1
XFILLER_130_29 VPWR VGND VPWR VGND sky130_ef_sc_hd__decap_40_12
XANTENNA__3659__S _3667_/S VGND VGND VPWR VPWR sky130_fd_sc_hd__diode_2
XANTENNA_fanout151_A _4713_/S VGND VGND VPWR VPWR sky130_fd_sc_hd__diode_2
X_4996_ _5060_/A _3976_/A _3969_/X _4995_/X VGND VGND VPWR VPWR _4997_/C sky130_fd_sc_hd__a2bb2o_1
XFILLER_24_769 VPWR VGND VPWR VGND sky130_ef_sc_hd__decap_40_12
X_3947_ _3948_/B _3947_/B VGND VGND VPWR VPWR _5173_/B sky130_fd_sc_hd__or2_1
XTAP_TAPCELL_ROW_63_1250 VGND VPWR sky130_fd_sc_hd__tapvpwrvgnd_1
XFILLER_23_27 VGND VGND VPWR VPWR sky130_fd_sc_hd__fill_8
XFILLER_23_49 VGND VGND VPWR VPWR sky130_fd_sc_hd__fill_4
X_3878_ _4521_/A1 _3878_/A1 _3879_/S VGND VGND VPWR VPWR _5859_/D sky130_fd_sc_hd__mux2_1
XFILLER_118_841 VGND VGND VPWR VPWR sky130_fd_sc_hd__fill_1
X_2829_ _5750_/Q _5274_/Q _3086_/S VGND VGND VPWR VPWR _2829_/X sky130_fd_sc_hd__mux2_1
X_5617_ _6292_/CLK _5617_/D VGND VGND VPWR VPWR _5617_/Q sky130_fd_sc_hd__dfxtp_1
XANTENNA_fanout204_X _2682_/A VGND VGND VPWR VPWR sky130_fd_sc_hd__diode_2
X_5548_ _6233_/CLK _5548_/D VGND VGND VPWR VPWR _5548_/Q sky130_fd_sc_hd__dfxtp_1
XFILLER_105_502 VGND VGND VPWR VPWR sky130_fd_sc_hd__fill_2
XANTENNA__3176__B1 _5200_/A VGND VGND VPWR VPWR sky130_fd_sc_hd__diode_2
XFILLER_133_833 VGND VGND VPWR VPWR sky130_fd_sc_hd__fill_4
XFILLER_3_629 VPWR VGND VPWR VGND sky130_ef_sc_hd__decap_40_12
X_5479_ _6233_/CLK _5479_/D VGND VGND VPWR VPWR _5479_/Q sky130_fd_sc_hd__dfxtp_1
XFILLER_2_139 VGND VGND VPWR VPWR sky130_fd_sc_hd__fill_1
XANTENNA__3023__S0 _3033_/S VGND VGND VPWR VPWR sky130_fd_sc_hd__diode_2
XANTENNA__3479__A1 _5238_/A1 VGND VGND VPWR VPWR sky130_fd_sc_hd__diode_2
XFILLER_101_741 VPWR VGND VPWR VGND sky130_ef_sc_hd__decap_40_12
XFILLER_86_430 VGND VGND VPWR VPWR sky130_fd_sc_hd__fill_2
XPHY_EDGE_ROW_122_Right_122 VGND VGND VPWR VPWR sky130_fd_sc_hd__decap_3
XFILLER_101_785 VPWR VGND VPWR VGND sky130_ef_sc_hd__decap_40_12
XFILLER_100_251 VGND VGND VPWR VPWR sky130_fd_sc_hd__fill_1
XFILLER_48_68 VGND VGND VPWR VPWR sky130_fd_sc_hd__fill_1
XFILLER_47_839 VGND VGND VPWR VPWR sky130_fd_sc_hd__fill_1
XANTENNA_fanout64_A _2642_/Y VGND VGND VPWR VPWR sky130_fd_sc_hd__diode_2
XFILLER_73_113 VGND VGND VPWR VPWR sky130_fd_sc_hd__fill_1
XANTENNA__4428__B1 _4445_/B VGND VGND VPWR VPWR sky130_fd_sc_hd__diode_2
XFILLER_46_349 VGND VGND VPWR VPWR sky130_fd_sc_hd__fill_8
XANTENNA__4953__S _4954_/S VGND VGND VPWR VPWR sky130_fd_sc_hd__diode_2
XANTENNA__4979__A1 _5042_/A1 VGND VGND VPWR VPWR sky130_fd_sc_hd__diode_2
XPHY_EDGE_ROW_100_Left_239 VGND VGND VPWR VPWR sky130_fd_sc_hd__decap_3
XANTENNA__3569__S _3574_/S VGND VGND VPWR VPWR sky130_fd_sc_hd__diode_2
XFILLER_64_56 VGND VGND VPWR VPWR sky130_fd_sc_hd__fill_1
XFILLER_15_725 VGND VGND VPWR VPWR sky130_fd_sc_hd__fill_2
XANTENNA__3651__A1 _4958_/A0 VGND VGND VPWR VPWR sky130_fd_sc_hd__diode_2
XANTENNA__5069__B _5069_/B VGND VGND VPWR VPWR sky130_fd_sc_hd__diode_2
Xfanout72 _2629_/Y VGND VGND VPWR VPWR _4811_/A1 sky130_fd_sc_hd__clkbuf_8
Xfanout83 hold2090/X VGND VGND VPWR VPWR _5212_/A1 sky130_fd_sc_hd__buf_4
Xfanout94 hold2218/X VGND VGND VPWR VPWR _5047_/A1 sky130_fd_sc_hd__buf_4
XFILLER_6_401 VPWR VGND VPWR VGND sky130_ef_sc_hd__decap_40_12
XFILLER_109_841 VGND VGND VPWR VPWR sky130_fd_sc_hd__fill_1
XANTENNA__5085__A _5085_/A VGND VGND VPWR VPWR sky130_fd_sc_hd__diode_2
XFILLER_6_445 VPWR VGND VPWR VGND sky130_ef_sc_hd__decap_40_12
XFILLER_129_93 VGND VGND VPWR VPWR sky130_fd_sc_hd__fill_1
XFILLER_124_811 VGND VGND VPWR VPWR sky130_fd_sc_hd__fill_1
XTAP_TAPCELL_ROW_94_1711 VGND VPWR sky130_fd_sc_hd__tapvpwrvgnd_1
XFILLER_89_31 VGND VGND VPWR VPWR sky130_fd_sc_hd__fill_4
XFILLER_136_693 VGND VGND VPWR VPWR sky130_fd_sc_hd__fill_4
XFILLER_6_489 VPWR VGND VPWR VGND sky130_ef_sc_hd__decap_40_12
XFILLER_135_192 VGND VGND VPWR VPWR sky130_fd_sc_hd__fill_1
XFILLER_89_97 VPWR VGND VPWR VGND sky130_ef_sc_hd__decap_40_12
XFILLER_111_505 VPWR VGND VPWR VGND sky130_ef_sc_hd__decap_40_12
XFILLER_89_290 VGND VGND VPWR VPWR sky130_fd_sc_hd__fill_4
XFILLER_49_165 VGND VGND VPWR VPWR sky130_fd_sc_hd__fill_1
XANTENNA__4863__S _4867_/S VGND VGND VPWR VPWR sky130_fd_sc_hd__diode_2
XANTENNA__2693__A2 _3541_/S VGND VGND VPWR VPWR sky130_fd_sc_hd__diode_2
XANTENNA__4419__B1 _3237_/A VGND VGND VPWR VPWR sky130_fd_sc_hd__diode_2
XFILLER_64_124 VGND VGND VPWR VPWR sky130_fd_sc_hd__fill_4
XANTENNA_output45_A _6058_/Q VGND VGND VPWR VPWR sky130_fd_sc_hd__diode_2
XANTENNA__6417__Q _6417_/Q VGND VGND VPWR VPWR sky130_fd_sc_hd__diode_2
XTAP_TAPCELL_ROW_121_2118 VGND VPWR sky130_fd_sc_hd__tapvpwrvgnd_1
Xclkbuf_3_7__f_clk clkbuf_0_clk/X VGND VGND VPWR VPWR clkload6/A sky130_fd_sc_hd__clkbuf_16
XFILLER_92_477 VGND VGND VPWR VPWR sky130_fd_sc_hd__fill_2
XFILLER_53_809 VPWR VGND VPWR VGND sky130_ef_sc_hd__decap_40_12
XANTENNA__3479__S _3490_/S VGND VGND VPWR VPWR sky130_fd_sc_hd__diode_2
XFILLER_64_179 VGND VGND VPWR VPWR sky130_fd_sc_hd__fill_1
XANTENNA__3642__A1 _4517_/A1 VGND VGND VPWR VPWR sky130_fd_sc_hd__diode_2
XFILLER_18_585 VGND VGND VPWR VPWR sky130_fd_sc_hd__fill_2
X_4850_ _4889_/A1 _4850_/A1 _4854_/S VGND VGND VPWR VPWR _4850_/X sky130_fd_sc_hd__mux2_1
XFILLER_45_393 VGND VGND VPWR VPWR sky130_fd_sc_hd__fill_1
XANTENNA_clkbuf_leaf_0_clk_A clkload0/A VGND VGND VPWR VPWR sky130_fd_sc_hd__diode_2
XFILLER_33_533 VGND VGND VPWR VPWR sky130_fd_sc_hd__fill_2
XTAP_TAPCELL_ROW_103_1851 VGND VPWR sky130_fd_sc_hd__tapvpwrvgnd_1
XTAP_TAPCELL_ROW_103_1840 VGND VPWR sky130_fd_sc_hd__tapvpwrvgnd_1
X_3801_ _3801_/A _3801_/B VGND VGND VPWR VPWR _5808_/D sky130_fd_sc_hd__nor2_2
XFILLER_21_717 VGND VGND VPWR VPWR sky130_fd_sc_hd__fill_8
XFILLER_60_385 VGND VGND VPWR VPWR sky130_fd_sc_hd__fill_8
X_4781_ _4811_/A1 _4780_/X _2628_/A VGND VGND VPWR VPWR _4781_/X sky130_fd_sc_hd__o21a_1
X_3732_ _3732_/A1 _3731_/X _5200_/A VGND VGND VPWR VPWR _3732_/X sky130_fd_sc_hd__o21a_1
XTAP_TAPCELL_ROW_31_767 VGND VPWR sky130_fd_sc_hd__tapvpwrvgnd_1
XFILLER_118_137 VGND VGND VPWR VPWR sky130_fd_sc_hd__fill_2
X_3663_ _4488_/A0 _3663_/A1 _3667_/S VGND VGND VPWR VPWR _5688_/D sky130_fd_sc_hd__mux2_1
Xclkload20 _6310_/CLK VGND VGND VPWR VPWR clkload20/Y sky130_fd_sc_hd__inv_6
XFILLER_118_159 VGND VGND VPWR VPWR sky130_fd_sc_hd__fill_1
X_6382_ _6382_/CLK _6382_/D VGND VGND VPWR VPWR _6382_/Q sky130_fd_sc_hd__dfxtp_1
Xclkload31 _6403_/CLK VGND VGND VPWR VPWR clkload31/Y sky130_fd_sc_hd__inv_8
Xclkload53 _6123_/CLK VGND VGND VPWR VPWR clkload53/Y sky130_fd_sc_hd__inv_8
X_5402_ _6418_/CLK _5402_/D VGND VGND VPWR VPWR _5402_/Q sky130_fd_sc_hd__dfxtp_1
Xclkload42 _5714_/CLK VGND VGND VPWR VPWR clkload42/Y sky130_fd_sc_hd__clkinv_4
Xclkload86 _6248_/CLK VGND VGND VPWR VPWR clkload86/Y sky130_fd_sc_hd__bufinv_16
XFILLER_127_671 VGND VGND VPWR VPWR sky130_fd_sc_hd__fill_1
XFILLER_115_833 VGND VGND VPWR VPWR sky130_fd_sc_hd__fill_4
Xclkload75 _6369_/CLK VGND VGND VPWR VPWR clkload75/Y sky130_fd_sc_hd__clkinv_2
Xclkload64 _6196_/CLK VGND VGND VPWR VPWR clkload64/Y sky130_fd_sc_hd__clkinv_8
X_5333_ _6172_/CLK _5333_/D VGND VGND VPWR VPWR _5333_/Q sky130_fd_sc_hd__dfxtp_1
X_3594_ hold973/X _4521_/A1 _3595_/S VGND VGND VPWR VPWR _3594_/X sky130_fd_sc_hd__mux2_1
Xclkload97 _6292_/CLK VGND VGND VPWR VPWR clkload97/Y sky130_fd_sc_hd__inv_6
XFILLER_130_825 VPWR VGND VPWR VGND sky130_ef_sc_hd__decap_40_12
XFILLER_102_527 VGND VGND VPWR VPWR sky130_fd_sc_hd__fill_4
X_5264_ _6351_/CLK _5264_/D VGND VGND VPWR VPWR _5264_/Q sky130_fd_sc_hd__dfxtp_1
X_5195_ _5175_/S _5191_/Y _3955_/B VGND VGND VPWR VPWR _5195_/Y sky130_fd_sc_hd__a21oi_1
X_4215_ _5262_/Q _6051_/Q _6042_/Q _6350_/Q _4270_/S _4212_/A VGND VGND VPWR VPWR
+ _4215_/X sky130_fd_sc_hd__mux4_1
XFILLER_56_614 VGND VGND VPWR VPWR sky130_fd_sc_hd__fill_1
X_4146_ _4260_/S _4146_/B VGND VGND VPWR VPWR _4146_/Y sky130_fd_sc_hd__nor2_1
XFILLER_28_305 VGND VGND VPWR VPWR sky130_fd_sc_hd__fill_2
XANTENNA__3881__A1 _4484_/A0 VGND VGND VPWR VPWR sky130_fd_sc_hd__diode_2
XANTENNA__4773__S _4773_/S VGND VGND VPWR VPWR sky130_fd_sc_hd__diode_2
XFILLER_55_113 VGND VGND VPWR VPWR sky130_fd_sc_hd__fill_4
XFILLER_28_338 VGND VGND VPWR VPWR sky130_fd_sc_hd__fill_2
XFILLER_29_839 VGND VGND VPWR VPWR sky130_fd_sc_hd__fill_1
XFILLER_71_617 VPWR VGND VPWR VGND sky130_ef_sc_hd__decap_40_12
XFILLER_44_809 VGND VGND VPWR VPWR sky130_fd_sc_hd__fill_2
X_4077_ _4077_/A1 _4218_/A _4061_/X _4076_/Y VGND VGND VPWR VPWR _4077_/X sky130_fd_sc_hd__a22o_1
XTAP_TAPCELL_ROW_39_878 VGND VPWR sky130_fd_sc_hd__tapvpwrvgnd_1
XANTENNA__3094__C1 _3094_/C1 VGND VGND VPWR VPWR sky130_fd_sc_hd__diode_2
X_3028_ hold159/X _5558_/Q _3086_/S VGND VGND VPWR VPWR _3029_/B sky130_fd_sc_hd__mux2_1
XANTENNA__4830__A0 _5238_/A1 VGND VGND VPWR VPWR sky130_fd_sc_hd__diode_2
XANTENNA__3389__S _3390_/S VGND VGND VPWR VPWR sky130_fd_sc_hd__diode_2
XANTENNA__3633__A1 _4488_/A0 VGND VGND VPWR VPWR sky130_fd_sc_hd__diode_2
XTAP_TAPCELL_ROW_39_889 VGND VPWR sky130_fd_sc_hd__tapvpwrvgnd_1
XFILLER_70_149 VGND VGND VPWR VPWR sky130_fd_sc_hd__fill_4
XANTENNA_fanout154_X _4713_/S VGND VGND VPWR VPWR sky130_fd_sc_hd__diode_2
XTAP_TAPCELL_ROW_19_580 VGND VPWR sky130_fd_sc_hd__tapvpwrvgnd_1
XTAP_TAPCELL_ROW_19_591 VGND VPWR sky130_fd_sc_hd__tapvpwrvgnd_1
XFILLER_24_533 VGND VGND VPWR VPWR sky130_fd_sc_hd__fill_2
XFILLER_34_15 VGND VGND VPWR VPWR sky130_fd_sc_hd__fill_1
XFILLER_36_382 VGND VGND VPWR VPWR sky130_fd_sc_hd__fill_1
XTAP_TAPCELL_ROW_61_1209 VGND VPWR sky130_fd_sc_hd__tapvpwrvgnd_1
XFILLER_11_238 VGND VGND VPWR VPWR sky130_fd_sc_hd__fill_1
X_4979_ hold236/X _5042_/A1 _4984_/S VGND VGND VPWR VPWR _4979_/X sky130_fd_sc_hd__mux2_1
Xclkload3 clkload3/A VGND VGND VPWR VPWR clkload3/Y sky130_fd_sc_hd__inv_6
XANTENNA__4802__A _4802_/A VGND VGND VPWR VPWR sky130_fd_sc_hd__diode_2
XFILLER_109_126 VGND VGND VPWR VPWR sky130_fd_sc_hd__fill_1
XANTENNA__4897__A0 _4445_/A VGND VGND VPWR VPWR sky130_fd_sc_hd__diode_2
XFILLER_118_693 VGND VGND VPWR VPWR sky130_fd_sc_hd__fill_4
XFILLER_106_811 VGND VGND VPWR VPWR sky130_fd_sc_hd__fill_1
XTAP_TAPCELL_ROW_76_1441 VGND VPWR sky130_fd_sc_hd__tapvpwrvgnd_1
XFILLER_133_641 VPWR VGND VPWR VGND sky130_ef_sc_hd__decap_40_12
XFILLER_105_354 VGND VGND VPWR VPWR sky130_fd_sc_hd__fill_4
XFILLER_105_321 VGND VGND VPWR VPWR sky130_fd_sc_hd__fill_2
XANTENNA__4948__S _4954_/S VGND VGND VPWR VPWR sky130_fd_sc_hd__diode_2
XFILLER_133_685 VPWR VGND VPWR VGND sky130_ef_sc_hd__decap_40_12
XFILLER_87_783 VGND VGND VPWR VPWR sky130_fd_sc_hd__fill_1
XANTENNA_fanout67_X _3096_/A1 VGND VGND VPWR VPWR sky130_fd_sc_hd__diode_2
XFILLER_75_44 VGND VGND VPWR VPWR sky130_fd_sc_hd__fill_4
XANTENNA__5074__A0 _5817_/Q VGND VGND VPWR VPWR sky130_fd_sc_hd__diode_2
XFILLER_35_809 VPWR VGND VPWR VGND sky130_ef_sc_hd__decap_40_12
XANTENNA__4821__A0 _4886_/A1 VGND VGND VPWR VPWR sky130_fd_sc_hd__diode_2
XANTENNA__3624__A1 _5213_/A1 VGND VGND VPWR VPWR sky130_fd_sc_hd__diode_2
XFILLER_131_72 VGND VGND VPWR VPWR sky130_fd_sc_hd__fill_2
XFILLER_61_127 VGND VGND VPWR VPWR sky130_fd_sc_hd__fill_1
XFILLER_27_393 VPWR VGND VPWR VGND sky130_ef_sc_hd__decap_40_12
XANTENNA__4431__B input5/X VGND VGND VPWR VPWR sky130_fd_sc_hd__diode_2
XFILLER_7_721 VGND VGND VPWR VPWR sky130_fd_sc_hd__fill_4
XFILLER_11_783 VGND VGND VPWR VPWR sky130_fd_sc_hd__fill_1
XFILLER_128_479 VPWR VGND VPWR VGND sky130_ef_sc_hd__decap_40_12
XFILLER_7_765 VPWR VGND VPWR VGND sky130_ef_sc_hd__decap_40_12
XFILLER_109_671 VGND VGND VPWR VPWR sky130_fd_sc_hd__fill_1
XFILLER_124_641 VGND VGND VPWR VPWR sky130_fd_sc_hd__fill_2
XANTENNA__4858__S _4867_/S VGND VGND VPWR VPWR sky130_fd_sc_hd__diode_2
XANTENNA__3560__A0 _4961_/A0 VGND VGND VPWR VPWR sky130_fd_sc_hd__diode_2
XANTENNA__3762__S _3766_/S VGND VGND VPWR VPWR sky130_fd_sc_hd__diode_2
XFILLER_112_825 VPWR VGND VPWR VGND sky130_ef_sc_hd__decap_40_12
XANTENNA_hold2129_A _5396_/Q VGND VGND VPWR VPWR sky130_fd_sc_hd__diode_2
X_4000_ _6387_/Q _6385_/Q _6388_/Q VGND VGND VPWR VPWR _5097_/B sky130_fd_sc_hd__nand3b_2
XFILLER_1_30 VPWR VGND VPWR VGND sky130_ef_sc_hd__decap_40_12
XFILLER_93_753 VPWR VGND VPWR VGND sky130_ef_sc_hd__decap_40_12
XANTENNA__4446__X _4446_/X VGND VGND VPWR VPWR sky130_fd_sc_hd__diode_2
XFILLER_26_809 VGND VGND VPWR VPWR sky130_fd_sc_hd__fill_2
XFILLER_93_797 VPWR VGND VPWR VGND sky130_ef_sc_hd__decap_40_12
XANTENNA__3615__A1 _5215_/A1 VGND VGND VPWR VPWR sky130_fd_sc_hd__diode_2
XFILLER_53_639 VGND VGND VPWR VPWR sky130_fd_sc_hd__fill_1
XFILLER_53_617 VGND VGND VPWR VPWR sky130_fd_sc_hd__fill_1
X_5951_ _6341_/CLK _5951_/D VGND VGND VPWR VPWR _5951_/Q sky130_fd_sc_hd__dfxtp_1
X_4902_ _5812_/Q _4902_/A1 _4906_/S VGND VGND VPWR VPWR _4902_/X sky130_fd_sc_hd__mux2_1
XTAP_TAPCELL_ROW_36_837 VGND VPWR sky130_fd_sc_hd__tapvpwrvgnd_1
X_5882_ _6417_/CLK _5882_/D VGND VGND VPWR VPWR _5882_/Q sky130_fd_sc_hd__dfxtp_1
XFILLER_21_503 VGND VGND VPWR VPWR sky130_fd_sc_hd__fill_1
X_4833_ _4846_/A0 hold906/X _4841_/S VGND VGND VPWR VPWR _4833_/X sky130_fd_sc_hd__mux2_1
XFILLER_33_374 VGND VGND VPWR VPWR sky130_fd_sc_hd__fill_1
X_4764_ _4760_/X _4762_/X _4763_/X _4811_/C1 VGND VGND VPWR VPWR _4764_/X sky130_fd_sc_hd__a22o_1
XTAP_TAPCELL_ROW_134_2309 VGND VPWR sky130_fd_sc_hd__tapvpwrvgnd_1
XFILLER_119_446 VGND VGND VPWR VPWR sky130_fd_sc_hd__fill_2
X_3715_ hold708/X _4982_/A1 _3717_/S VGND VGND VPWR VPWR _3715_/X sky130_fd_sc_hd__mux2_1
X_6434_ _6434_/CLK _6434_/D VGND VGND VPWR VPWR _6434_/Q sky130_fd_sc_hd__dfxtp_1
X_4695_ _5697_/Q _5901_/Q _4808_/S VGND VGND VPWR VPWR _4695_/X sky130_fd_sc_hd__mux2_1
XFILLER_106_107 VGND VGND VPWR VPWR sky130_fd_sc_hd__fill_8
XANTENNA_fanout114_A _5239_/A1 VGND VGND VPWR VPWR sky130_fd_sc_hd__diode_2
X_3646_ hold950/X _4521_/A1 _3647_/S VGND VGND VPWR VPWR _3646_/X sky130_fd_sc_hd__mux2_1
X_6365_ _6365_/CLK _6365_/D VGND VGND VPWR VPWR _6365_/Q sky130_fd_sc_hd__dfxtp_1
XFILLER_115_641 VPWR VGND VPWR VGND sky130_ef_sc_hd__decap_40_12
X_3577_ hold151/X _5209_/A1 _3584_/S VGND VGND VPWR VPWR _3577_/X sky130_fd_sc_hd__mux2_1
XTAP_TAPCELL_ROW_58_1171 VGND VPWR sky130_fd_sc_hd__tapvpwrvgnd_1
XFILLER_115_685 VPWR VGND VPWR VGND sky130_ef_sc_hd__decap_40_12
X_5316_ _6429_/CLK _5316_/D VGND VGND VPWR VPWR _5316_/Q sky130_fd_sc_hd__dfxtp_1
X_6296_ _6298_/CLK _6296_/D VGND VGND VPWR VPWR _6296_/Q sky130_fd_sc_hd__dfxtp_1
X_5247_ _6437_/CLK _5247_/D VGND VGND VPWR VPWR _5247_/Q sky130_fd_sc_hd__dfxtp_1
XANTENNA__4726__S0 _2629_/Y VGND VGND VPWR VPWR sky130_fd_sc_hd__diode_2
XFILLER_29_15 VGND VGND VPWR VPWR sky130_fd_sc_hd__fill_4
Xhold37 hold37/A VGND VGND VPWR VPWR hold37/X sky130_fd_sc_hd__dlygate4sd3_1
XTAP_TAPCELL_ROW_71_1371 VGND VPWR sky130_fd_sc_hd__tapvpwrvgnd_1
XTAP_TAPCELL_ROW_71_1360 VGND VPWR sky130_fd_sc_hd__tapvpwrvgnd_1
Xhold1900 _5722_/Q VGND VGND VPWR VPWR _4618_/A3 sky130_fd_sc_hd__dlygate4sd3_1
Xhold15 hold15/A VGND VGND VPWR VPWR hold15/X sky130_fd_sc_hd__dlygate4sd3_1
Xhold1911 _4334_/X VGND VGND VPWR VPWR _5980_/D sky130_fd_sc_hd__dlygate4sd3_1
Xhold26 hold26/A VGND VGND VPWR VPWR hold26/X sky130_fd_sc_hd__dlygate4sd3_1
XFILLER_130_699 VGND VGND VPWR VPWR sky130_fd_sc_hd__fill_1
Xhold1922 _5071_/X VGND VGND VPWR VPWR _6362_/D sky130_fd_sc_hd__dlygate4sd3_1
Xhold59 hold59/A VGND VGND VPWR VPWR hold59/X sky130_fd_sc_hd__dlygate4sd3_1
Xhold48 hold48/A VGND VGND VPWR VPWR hold48/X sky130_fd_sc_hd__dlygate4sd3_1
XANTENNA__3854__A1 _2665_/Y VGND VGND VPWR VPWR sky130_fd_sc_hd__diode_2
Xhold1944 _5857_/Q VGND VGND VPWR VPWR _3876_/A1 sky130_fd_sc_hd__dlygate4sd3_1
X_5178_ _6258_/Q _5178_/A1 _5194_/S VGND VGND VPWR VPWR _5178_/X sky130_fd_sc_hd__mux2_1
XFILLER_56_411 VGND VGND VPWR VPWR sky130_fd_sc_hd__fill_4
Xhold1933 _5976_/Q VGND VGND VPWR VPWR _4330_/A1 sky130_fd_sc_hd__dlygate4sd3_1
XFILLER_29_614 VGND VGND VPWR VPWR sky130_fd_sc_hd__fill_2
Xhold1966 _5334_/Q VGND VGND VPWR VPWR _2650_/A sky130_fd_sc_hd__dlygate4sd3_1
Xhold1955 _5093_/X VGND VGND VPWR VPWR _6381_/D sky130_fd_sc_hd__dlygate4sd3_1
Xhold1977 _5207_/X VGND VGND VPWR VPWR _6409_/D sky130_fd_sc_hd__dlygate4sd3_1
Xhold1988 _5401_/Q VGND VGND VPWR VPWR _3278_/A sky130_fd_sc_hd__dlygate4sd3_1
XFILLER_56_444 VGND VGND VPWR VPWR sky130_fd_sc_hd__fill_4
XFILLER_17_809 VPWR VGND VPWR VGND sky130_ef_sc_hd__decap_40_12
X_4129_ _5259_/Q _6048_/Q _6039_/Q _6347_/Q _4213_/S _4212_/A VGND VGND VPWR VPWR
+ _4129_/X sky130_fd_sc_hd__mux4_1
XFILLER_84_786 VPWR VGND VPWR VGND sky130_ef_sc_hd__decap_40_12
Xhold1999 _4758_/X VGND VGND VPWR VPWR _6168_/D sky130_fd_sc_hd__dlygate4sd3_1
XFILLER_56_477 VGND VGND VPWR VPWR sky130_fd_sc_hd__fill_1
XFILLER_45_36 VGND VGND VPWR VPWR sky130_fd_sc_hd__fill_4
XFILLER_28_168 VGND VGND VPWR VPWR sky130_fd_sc_hd__fill_1
XTAP_TAPCELL_ROW_14_509 VGND VPWR sky130_fd_sc_hd__tapvpwrvgnd_1
XFILLER_40_801 VGND VGND VPWR VPWR sky130_fd_sc_hd__fill_8
XFILLER_101_53 VGND VGND VPWR VPWR sky130_fd_sc_hd__fill_2
XFILLER_12_525 VGND VGND VPWR VPWR sky130_fd_sc_hd__fill_4
XFILLER_12_569 VPWR VGND VPWR VGND sky130_ef_sc_hd__decap_40_12
XFILLER_138_755 VGND VGND VPWR VPWR sky130_fd_sc_hd__fill_1
XFILLER_8_529 VGND VGND VPWR VPWR sky130_fd_sc_hd__fill_2
XFILLER_124_3 VPWR VGND VPWR VGND sky130_ef_sc_hd__decap_40_12
XFILLER_4_713 VPWR VGND VPWR VGND sky130_ef_sc_hd__decap_40_12
XFILLER_106_641 VGND VGND VPWR VPWR sky130_fd_sc_hd__fill_2
XANTENNA__4678__S _4773_/S VGND VGND VPWR VPWR sky130_fd_sc_hd__diode_2
XFILLER_4_757 VPWR VGND VPWR VGND sky130_ef_sc_hd__decap_40_12
XFILLER_3_212 VGND VGND VPWR VPWR sky130_fd_sc_hd__fill_4
XANTENNA__6459__A _6459_/A VGND VGND VPWR VPWR sky130_fd_sc_hd__diode_2
XFILLER_133_493 VGND VGND VPWR VPWR sky130_fd_sc_hd__fill_8
XFILLER_86_54 VGND VGND VPWR VPWR sky130_fd_sc_hd__fill_1
XFILLER_79_569 VGND VGND VPWR VPWR sky130_fd_sc_hd__fill_8
XFILLER_67_709 VGND VGND VPWR VPWR sky130_fd_sc_hd__fill_1
XANTENNA__4098__A1 _2636_/Y VGND VGND VPWR VPWR sky130_fd_sc_hd__diode_2
XTAP_TAPCELL_ROW_89_1632 VGND VPWR sky130_fd_sc_hd__tapvpwrvgnd_1
XFILLER_19_135 VGND VGND VPWR VPWR sky130_fd_sc_hd__fill_2
XFILLER_19_146 VGND VGND VPWR VPWR sky130_fd_sc_hd__fill_2
XFILLER_75_797 VPWR VGND VPWR VGND sky130_ef_sc_hd__decap_40_12
XFILLER_62_403 VGND VGND VPWR VPWR sky130_fd_sc_hd__fill_4
XANTENNA__4426__B input5/X VGND VGND VPWR VPWR sky130_fd_sc_hd__diode_2
XFILLER_129_777 VGND VGND VPWR VPWR sky130_fd_sc_hd__fill_4
XFILLER_128_232 VGND VGND VPWR VPWR sky130_fd_sc_hd__fill_1
XTAP_TAPCELL_ROW_116_2039 VGND VPWR sky130_fd_sc_hd__tapvpwrvgnd_1
X_3500_ _4903_/A0 _3500_/A1 _3503_/S VGND VGND VPWR VPWR _3500_/X sky130_fd_sc_hd__mux2_1
Xhold518 _5304_/Q VGND VGND VPWR VPWR hold518/X sky130_fd_sc_hd__dlygate4sd3_1
Xhold507 _5477_/Q VGND VGND VPWR VPWR hold507/X sky130_fd_sc_hd__dlygate4sd3_1
X_4480_ _4480_/A0 _5214_/A1 _4482_/S VGND VGND VPWR VPWR _4480_/X sky130_fd_sc_hd__mux2_1
XFILLER_7_573 VPWR VGND VPWR VGND sky130_ef_sc_hd__decap_40_12
XANTENNA__3492__S _3503_/S VGND VGND VPWR VPWR sky130_fd_sc_hd__diode_2
X_3431_ _3431_/A0 _4887_/A1 _3437_/S VGND VGND VPWR VPWR _3431_/X sky130_fd_sc_hd__mux2_1
Xhold529 _4280_/X VGND VGND VPWR VPWR _5932_/D sky130_fd_sc_hd__dlygate4sd3_1
XANTENNA_hold2246_A _4535_/S VGND VGND VPWR VPWR sky130_fd_sc_hd__diode_2
X_6150_ _6232_/CLK _6150_/D VGND VGND VPWR VPWR _6150_/Q sky130_fd_sc_hd__dfxtp_1
X_3362_ _3362_/A1 _5035_/C _5201_/B _5436_/Q VGND VGND VPWR VPWR _3362_/X sky130_fd_sc_hd__a22o_1
X_5101_ _2624_/A _3337_/A _3976_/A _3976_/C VGND VGND VPWR VPWR _5101_/Y sky130_fd_sc_hd__o31ai_1
Xhold1207 _2671_/X VGND VGND VPWR VPWR _5244_/D sky130_fd_sc_hd__dlygate4sd3_1
X_3293_ hold309/X _4904_/A0 _3295_/S VGND VGND VPWR VPWR _3293_/X sky130_fd_sc_hd__mux2_1
XTAP_TAPCELL_ROW_111_1972 VGND VPWR sky130_fd_sc_hd__tapvpwrvgnd_1
XTAP_TAPCELL_ROW_111_1961 VGND VPWR sky130_fd_sc_hd__tapvpwrvgnd_1
X_6081_ _6417_/CLK _6081_/D VGND VGND VPWR VPWR _6081_/Q sky130_fd_sc_hd__dfxtp_1
Xhold1229 _6072_/Q VGND VGND VPWR VPWR _4464_/A1 sky130_fd_sc_hd__dlygate4sd3_1
XFILLER_112_699 VGND VGND VPWR VPWR sky130_fd_sc_hd__fill_1
Xhold1218 _4871_/X VGND VGND VPWR VPWR _6221_/D sky130_fd_sc_hd__dlygate4sd3_1
XTAP_TAPCELL_ROW_53_1090 VGND VPWR sky130_fd_sc_hd__tapvpwrvgnd_1
X_5032_ _5032_/A1 _5012_/X _5031_/Y _3801_/A VGND VGND VPWR VPWR _5032_/X sky130_fd_sc_hd__a211o_1
XFILLER_93_561 VPWR VGND VPWR VGND sky130_ef_sc_hd__decap_40_12
XFILLER_66_797 VGND VGND VPWR VPWR sky130_fd_sc_hd__fill_1
XFILLER_81_734 VPWR VGND VPWR VGND sky130_ef_sc_hd__decap_40_12
X_5934_ _6404_/CLK _5934_/D VGND VGND VPWR VPWR _5934_/Q sky130_fd_sc_hd__dfxtp_1
X_5865_ _6097_/CLK _5865_/D VGND VGND VPWR VPWR _5865_/Q sky130_fd_sc_hd__dfxtp_1
X_4816_ _4881_/A _4842_/B VGND VGND VPWR VPWR _4828_/S sky130_fd_sc_hd__or2_4
XANTENNA__3667__S _3667_/S VGND VGND VPWR VPWR sky130_fd_sc_hd__diode_2
X_5796_ _6125_/CLK _5796_/D VGND VGND VPWR VPWR _5796_/Q sky130_fd_sc_hd__dfxtp_1
X_4747_ _4811_/A1 _4746_/X _4745_/X _4663_/A VGND VGND VPWR VPWR _4747_/X sky130_fd_sc_hd__o211a_1
XANTENNA__3772__A0 _5043_/A1 VGND VGND VPWR VPWR sky130_fd_sc_hd__diode_2
XFILLER_135_725 VGND VGND VPWR VPWR sky130_fd_sc_hd__fill_2
XANTENNA_fanout117_X _4445_/A VGND VGND VPWR VPWR sky130_fd_sc_hd__diode_2
X_4678_ _5598_/Q _5589_/Q _4773_/S VGND VGND VPWR VPWR _4678_/X sky130_fd_sc_hd__mux2_1
XTAP_TAPCELL_ROW_73_1400 VGND VPWR sky130_fd_sc_hd__tapvpwrvgnd_1
X_6417_ _6417_/CLK _6417_/D VGND VGND VPWR VPWR _6417_/Q sky130_fd_sc_hd__dfxtp_2
X_3629_ hold264/X _4484_/A0 _3637_/S VGND VGND VPWR VPWR _3629_/X sky130_fd_sc_hd__mux2_1
XFILLER_122_419 VGND VGND VPWR VPWR sky130_fd_sc_hd__fill_1
XANTENNA__3524__A0 _4901_/A0 VGND VGND VPWR VPWR sky130_fd_sc_hd__diode_2
XFILLER_115_460 VGND VGND VPWR VPWR sky130_fd_sc_hd__fill_2
Xoutput38 _6057_/Q VGND VGND VPWR VPWR s_axil_rdata[0] sky130_fd_sc_hd__buf_2
Xoutput49 _5439_/Q VGND VGND VPWR VPWR s_axil_rdata[5] sky130_fd_sc_hd__buf_2
X_6348_ _6405_/CLK hold17/X VGND VGND VPWR VPWR hold16/A sky130_fd_sc_hd__dfxtp_1
XFILLER_1_727 VGND VGND VPWR VPWR sky130_fd_sc_hd__fill_1
XFILLER_0_215 VGND VGND VPWR VPWR sky130_fd_sc_hd__fill_1
XFILLER_130_463 VGND VGND VPWR VPWR sky130_fd_sc_hd__fill_1
XFILLER_88_355 VGND VGND VPWR VPWR sky130_fd_sc_hd__fill_1
X_6279_ _6316_/CLK _6279_/D VGND VGND VPWR VPWR _6279_/Q sky130_fd_sc_hd__dfxtp_1
XANTENNA__3827__A1 _5042_/A1 VGND VGND VPWR VPWR sky130_fd_sc_hd__diode_2
Xhold1741 _3404_/X VGND VGND VPWR VPWR _5459_/D sky130_fd_sc_hd__dlygate4sd3_1
Xhold1752 _4954_/X VGND VGND VPWR VPWR _6289_/D sky130_fd_sc_hd__dlygate4sd3_1
Xhold1730 _4974_/X VGND VGND VPWR VPWR _6307_/D sky130_fd_sc_hd__dlygate4sd3_1
Xhold1796 _5689_/Q VGND VGND VPWR VPWR _3664_/A1 sky130_fd_sc_hd__dlygate4sd3_1
Xhold1774 _5590_/Q VGND VGND VPWR VPWR _3549_/A0 sky130_fd_sc_hd__dlygate4sd3_1
XFILLER_57_797 VPWR VGND VPWR VGND sky130_ef_sc_hd__decap_40_12
Xhold1763 _3771_/X VGND VGND VPWR VPWR _5781_/D sky130_fd_sc_hd__dlygate4sd3_1
Xhold1785 _4977_/X VGND VGND VPWR VPWR _6309_/D sky130_fd_sc_hd__dlygate4sd3_1
XFILLER_17_617 VPWR VGND VPWR VGND sky130_ef_sc_hd__decap_40_12
XFILLER_29_466 VGND VGND VPWR VPWR sky130_fd_sc_hd__fill_2
XFILLER_112_41 VGND VGND VPWR VPWR sky130_fd_sc_hd__fill_4
XFILLER_72_734 VGND VGND VPWR VPWR sky130_fd_sc_hd__fill_1
XFILLER_112_85 VGND VGND VPWR VPWR sky130_fd_sc_hd__fill_4
XTAP_TAPCELL_ROW_84_1562 VGND VPWR sky130_fd_sc_hd__tapvpwrvgnd_1
XANTENNA__4252__A1 _4252_/A1 VGND VGND VPWR VPWR sky130_fd_sc_hd__diode_2
XFILLER_72_56 VGND VGND VPWR VPWR sky130_fd_sc_hd__fill_1
XANTENNA_clkbuf_leaf_40_clk_A clkload4/A VGND VGND VPWR VPWR sky130_fd_sc_hd__diode_2
XFILLER_12_377 VPWR VGND VPWR VGND sky130_ef_sc_hd__decap_40_12
XFILLER_40_697 VGND VGND VPWR VPWR sky130_fd_sc_hd__fill_1
XFILLER_138_585 VGND VGND VPWR VPWR sky130_fd_sc_hd__fill_2
XFILLER_126_725 VPWR VGND VPWR VGND sky130_ef_sc_hd__decap_40_12
XFILLER_126_769 VPWR VGND VPWR VGND sky130_ef_sc_hd__decap_40_12
XFILLER_99_609 VGND VGND VPWR VPWR sky130_fd_sc_hd__fill_4
XANTENNA_clkbuf_leaf_55_clk_A clkload6/A VGND VGND VPWR VPWR sky130_fd_sc_hd__diode_2
XFILLER_125_257 VGND VGND VPWR VPWR sky130_fd_sc_hd__fill_2
XANTENNA__3515__A0 _5080_/A0 VGND VGND VPWR VPWR sky130_fd_sc_hd__diode_2
XFILLER_4_587 VGND VGND VPWR VPWR sky130_fd_sc_hd__fill_1
XFILLER_79_366 VGND VGND VPWR VPWR sky130_fd_sc_hd__fill_8
XFILLER_95_837 VGND VGND VPWR VPWR sky130_fd_sc_hd__fill_2
XANTENNA__3818__A1 _4882_/A1 VGND VGND VPWR VPWR sky130_fd_sc_hd__diode_2
XFILLER_82_509 VGND VGND VPWR VPWR sky130_fd_sc_hd__fill_1
XTAP_TAPCELL_ROW_126_2190 VGND VPWR sky130_fd_sc_hd__tapvpwrvgnd_1
XFILLER_90_531 VGND VGND VPWR VPWR sky130_fd_sc_hd__fill_1
XFILLER_62_233 VGND VGND VPWR VPWR sky130_fd_sc_hd__fill_1
XANTENNA__4871__S _4880_/S VGND VGND VPWR VPWR sky130_fd_sc_hd__diode_2
XFILLER_63_767 VPWR VGND VPWR VGND sky130_ef_sc_hd__decap_40_12
X_3980_ _5029_/B _5110_/A VGND VGND VPWR VPWR _3980_/Y sky130_fd_sc_hd__nor2_1
XANTENNA__4243__A1 _2636_/Y VGND VGND VPWR VPWR sky130_fd_sc_hd__diode_2
X_2931_ _3076_/A1 _2926_/X _2928_/X _2930_/X VGND VGND VPWR VPWR _2931_/X sky130_fd_sc_hd__a22o_1
XTAP_TAPCELL_ROW_46_987 VGND VPWR sky130_fd_sc_hd__tapvpwrvgnd_1
XANTENNA__3487__S _3490_/S VGND VGND VPWR VPWR sky130_fd_sc_hd__diode_2
Xclkbuf_0_clk clk VGND VGND VPWR VPWR clkbuf_0_clk/X sky130_fd_sc_hd__clkbuf_16
XANTENNA__4172__A _4251_/A VGND VGND VPWR VPWR sky130_fd_sc_hd__diode_2
X_5650_ _5902_/CLK hold26/X VGND VGND VPWR VPWR hold25/A sky130_fd_sc_hd__dfxtp_1
X_2862_ _5516_/Q _5528_/Q _3051_/S VGND VGND VPWR VPWR _2862_/X sky130_fd_sc_hd__mux2_1
X_4601_ _6118_/Q _6109_/Q _4803_/S VGND VGND VPWR VPWR _4601_/X sky130_fd_sc_hd__mux2_1
XFILLER_129_541 VPWR VGND VPWR VGND sky130_ef_sc_hd__decap_40_12
X_2793_ _6436_/Q _6244_/Q hold71/A _5502_/Q _3016_/S _3044_/A VGND VGND VPWR VPWR
+ _2793_/X sky130_fd_sc_hd__mux4_1
X_5581_ _5820_/CLK _5581_/D VGND VGND VPWR VPWR _5581_/Q sky130_fd_sc_hd__dfxtp_1
XANTENNA__3754__A0 _4983_/A1 VGND VGND VPWR VPWR sky130_fd_sc_hd__diode_2
XFILLER_30_174 VGND VGND VPWR VPWR sky130_fd_sc_hd__fill_1
XFILLER_129_585 VPWR VGND VPWR VGND sky130_ef_sc_hd__decap_40_12
XFILLER_117_725 VGND VGND VPWR VPWR sky130_fd_sc_hd__fill_2
X_4532_ hold22/X _5234_/A0 _4532_/S VGND VGND VPWR VPWR _6134_/D sky130_fd_sc_hd__mux2_1
X_4463_ _5228_/A0 hold667/X _4472_/S VGND VGND VPWR VPWR _4463_/X sky130_fd_sc_hd__mux2_1
Xhold326 _4541_/X VGND VGND VPWR VPWR _6143_/D sky130_fd_sc_hd__dlygate4sd3_1
Xhold315 _5314_/Q VGND VGND VPWR VPWR hold315/X sky130_fd_sc_hd__dlygate4sd3_1
Xhold304 _3201_/X VGND VGND VPWR VPWR _5363_/D sky130_fd_sc_hd__dlygate4sd3_1
Xhold337 _5526_/Q VGND VGND VPWR VPWR hold337/X sky130_fd_sc_hd__dlygate4sd3_1
Xhold348 _3737_/X VGND VGND VPWR VPWR _5751_/D sky130_fd_sc_hd__dlygate4sd3_1
XANTENNA__3506__A0 _4883_/A1 VGND VGND VPWR VPWR sky130_fd_sc_hd__diode_2
X_6202_ _6239_/CLK _6202_/D VGND VGND VPWR VPWR _6202_/Q sky130_fd_sc_hd__dfxtp_1
X_3414_ _3607_/A _4493_/B VGND VGND VPWR VPWR _3423_/S sky130_fd_sc_hd__nor2_4
Xhold359 _5890_/Q VGND VGND VPWR VPWR hold359/X sky130_fd_sc_hd__dlygate4sd3_1
XFILLER_131_216 VGND VGND VPWR VPWR sky130_fd_sc_hd__fill_1
XTAP_TAPCELL_ROW_55_1130 VGND VPWR sky130_fd_sc_hd__tapvpwrvgnd_1
XPHY_EDGE_ROW_15_Right_15 VGND VGND VPWR VPWR sky130_fd_sc_hd__decap_3
X_4394_ _4982_/A1 hold594/X _4396_/S VGND VGND VPWR VPWR _4394_/X sky130_fd_sc_hd__mux2_1
X_6133_ _6399_/CLK _6133_/D VGND VGND VPWR VPWR _6133_/Q sky130_fd_sc_hd__dfxtp_1
X_3345_ _6386_/Q _6385_/Q _5112_/B _6387_/Q _3975_/A VGND VGND VPWR VPWR _5060_/B
+ sky130_fd_sc_hd__a2111oi_4
X_6064_ _6248_/CLK _6064_/D VGND VGND VPWR VPWR _6064_/Q sky130_fd_sc_hd__dfxtp_1
XFILLER_112_463 VPWR VGND VPWR VGND sky130_ef_sc_hd__decap_40_12
XFILLER_100_625 VPWR VGND VPWR VGND sky130_ef_sc_hd__decap_40_12
XFILLER_98_697 VGND VGND VPWR VPWR sky130_fd_sc_hd__fill_2
Xhold1004 _4555_/X VGND VGND VPWR VPWR _6155_/D sky130_fd_sc_hd__dlygate4sd3_1
XFILLER_86_837 VGND VGND VPWR VPWR sky130_fd_sc_hd__fill_4
XANTENNA_clkbuf_3_6__f_clk_X clkload5/A VGND VGND VPWR VPWR sky130_fd_sc_hd__diode_2
XANTENNA__3809__A1 _5080_/A0 VGND VGND VPWR VPWR sky130_fd_sc_hd__diode_2
X_3276_ _3801_/A _3276_/B VGND VGND VPWR VPWR _3276_/Y sky130_fd_sc_hd__nor2_1
Xhold1015 _3911_/X VGND VGND VPWR VPWR _5889_/D sky130_fd_sc_hd__dlygate4sd3_1
XFILLER_100_669 VPWR VGND VPWR VGND sky130_ef_sc_hd__decap_40_12
Xhold1048 _6199_/Q VGND VGND VPWR VPWR _4847_/A1 sky130_fd_sc_hd__dlygate4sd3_1
X_5015_ _6329_/Q _5015_/B VGND VGND VPWR VPWR _5015_/Y sky130_fd_sc_hd__nand2_1
Xhold1026 _5937_/Q VGND VGND VPWR VPWR _4286_/A0 sky130_fd_sc_hd__dlygate4sd3_1
Xhold1037 _3728_/X VGND VGND VPWR VPWR _5746_/D sky130_fd_sc_hd__dlygate4sd3_1
Xhold1059 _5238_/X VGND VGND VPWR VPWR _6435_/D sky130_fd_sc_hd__dlygate4sd3_1
XANTENNA_fanout181_A _5267_/Q VGND VGND VPWR VPWR sky130_fd_sc_hd__diode_2
XANTENNA__4482__A1 _5202_/A1 VGND VGND VPWR VPWR sky130_fd_sc_hd__diode_2
XFILLER_39_797 VPWR VGND VPWR VGND sky130_ef_sc_hd__decap_40_12
XFILLER_93_391 VGND VGND VPWR VPWR sky130_fd_sc_hd__fill_1
XFILLER_26_38 VGND VGND VPWR VPWR sky130_fd_sc_hd__fill_4
XFILLER_54_789 VPWR VGND VPWR VGND sky130_ef_sc_hd__decap_40_12
XPHY_EDGE_ROW_24_Right_24 VGND VGND VPWR VPWR sky130_fd_sc_hd__decap_3
X_5917_ _6409_/CLK _5917_/D VGND VGND VPWR VPWR _5917_/Q sky130_fd_sc_hd__dfxtp_2
XTAP_TAPCELL_ROW_66_1292 VGND VPWR sky130_fd_sc_hd__tapvpwrvgnd_1
XFILLER_22_631 VGND VGND VPWR VPWR sky130_fd_sc_hd__fill_8
XTAP_TAPCELL_ROW_24_659 VGND VPWR sky130_fd_sc_hd__tapvpwrvgnd_1
X_5848_ _6095_/CLK _5848_/D VGND VGND VPWR VPWR _5848_/Q sky130_fd_sc_hd__dfxtp_1
XFILLER_42_59 VGND VGND VPWR VPWR sky130_fd_sc_hd__fill_1
XFILLER_10_837 VGND VGND VPWR VPWR sky130_fd_sc_hd__fill_4
X_5779_ _5908_/CLK _5779_/D VGND VGND VPWR VPWR _5779_/Q sky130_fd_sc_hd__dfxtp_1
XFILLER_108_725 VPWR VGND VPWR VGND sky130_ef_sc_hd__decap_40_12
XFILLER_108_769 VPWR VGND VPWR VGND sky130_ef_sc_hd__decap_40_12
XFILLER_107_279 VGND VGND VPWR VPWR sky130_fd_sc_hd__fill_1
XPHY_EDGE_ROW_33_Right_33 VGND VGND VPWR VPWR sky130_fd_sc_hd__decap_3
Xhold882 _6224_/Q VGND VGND VPWR VPWR hold882/X sky130_fd_sc_hd__dlygate4sd3_1
Xhold871 _6352_/Q VGND VGND VPWR VPWR hold871/X sky130_fd_sc_hd__dlygate4sd3_1
Xhold860 _4344_/X VGND VGND VPWR VPWR _5989_/D sky130_fd_sc_hd__dlygate4sd3_1
Xhold893 _3196_/X VGND VGND VPWR VPWR _5358_/D sky130_fd_sc_hd__dlygate4sd3_1
XFILLER_115_290 VGND VGND VPWR VPWR sky130_fd_sc_hd__fill_1
XFILLER_1_557 VGND VGND VPWR VPWR sky130_fd_sc_hd__fill_2
XFILLER_131_783 VGND VGND VPWR VPWR sky130_fd_sc_hd__fill_1
XFILLER_77_837 VGND VGND VPWR VPWR sky130_fd_sc_hd__fill_2
XANTENNA__4148__S1 _4263_/A VGND VGND VPWR VPWR sky130_fd_sc_hd__diode_2
XFILLER_130_282 VGND VGND VPWR VPWR sky130_fd_sc_hd__fill_1
Xhold2250 _3767_/B VGND VGND VPWR VPWR _3929_/B sky130_fd_sc_hd__dlygate4sd3_1
Xhold1571 _3496_/X VGND VGND VPWR VPWR _5541_/D sky130_fd_sc_hd__dlygate4sd3_1
XFILLER_91_306 VGND VGND VPWR VPWR sky130_fd_sc_hd__fill_1
Xhold1560 _3863_/X VGND VGND VPWR VPWR _5845_/D sky130_fd_sc_hd__dlygate4sd3_1
XTAP_TAPCELL_ROW_4_362 VGND VPWR sky130_fd_sc_hd__tapvpwrvgnd_1
Xhold1593 _5076_/X VGND VGND VPWR VPWR _6367_/D sky130_fd_sc_hd__dlygate4sd3_1
XFILLER_91_339 VGND VGND VPWR VPWR sky130_fd_sc_hd__fill_1
XFILLER_83_44 VPWR VGND VPWR VGND sky130_ef_sc_hd__decap_40_12
Xhold1582 _6091_/Q VGND VGND VPWR VPWR _4485_/A1 sky130_fd_sc_hd__dlygate4sd3_1
XFILLER_45_745 VGND VGND VPWR VPWR sky130_fd_sc_hd__fill_1
XFILLER_44_222 VGND VGND VPWR VPWR sky130_fd_sc_hd__fill_2
XPHY_EDGE_ROW_42_Right_42 VGND VGND VPWR VPWR sky130_fd_sc_hd__decap_3
XANTENNA__4225__A1 _4205_/A VGND VGND VPWR VPWR sky130_fd_sc_hd__diode_2
XFILLER_17_447 VGND VGND VPWR VPWR sky130_fd_sc_hd__fill_1
XTAP_TAPCELL_ROW_43_946 VGND VPWR sky130_fd_sc_hd__tapvpwrvgnd_1
XFILLER_13_653 VPWR VGND VPWR VGND sky130_ef_sc_hd__decap_40_12
XFILLER_25_480 VGND VGND VPWR VPWR sky130_fd_sc_hd__fill_1
XANTENNA__2882__S1 _2962_/A VGND VGND VPWR VPWR sky130_fd_sc_hd__diode_2
XFILLER_9_613 VGND VGND VPWR VPWR sky130_fd_sc_hd__fill_2
XFILLER_40_461 VGND VGND VPWR VPWR sky130_fd_sc_hd__fill_1
XFILLER_40_472 VGND VGND VPWR VPWR sky130_fd_sc_hd__fill_4
XFILLER_13_697 VPWR VGND VPWR VGND sky130_ef_sc_hd__decap_40_12
XPHY_EDGE_ROW_51_Right_51 VGND VGND VPWR VPWR sky130_fd_sc_hd__decap_3
XFILLER_138_393 VGND VGND VPWR VPWR sky130_fd_sc_hd__fill_1
XFILLER_126_533 VPWR VGND VPWR VGND sky130_ef_sc_hd__decap_40_12
XTAP_TAPCELL_ROW_97_1753 VGND VPWR sky130_fd_sc_hd__tapvpwrvgnd_1
XFILLER_5_841 VGND VGND VPWR VPWR sky130_fd_sc_hd__fill_1
XPHY_EDGE_ROW_136_Right_136 VGND VGND VPWR VPWR sky130_fd_sc_hd__decap_3
XANTENNA__4866__S _4867_/S VGND VGND VPWR VPWR sky130_fd_sc_hd__diode_2
XFILLER_79_130 VGND VGND VPWR VPWR sky130_fd_sc_hd__fill_1
XFILLER_67_314 VGND VGND VPWR VPWR sky130_fd_sc_hd__fill_4
X_3130_ _3131_/A _3402_/B VGND VGND VPWR VPWR _3132_/B sky130_fd_sc_hd__or2_1
X_3061_ _6241_/Q _6217_/Q _6160_/Q _6229_/Q _3033_/S _3034_/A VGND VGND VPWR VPWR
+ _3061_/X sky130_fd_sc_hd__mux4_1
XANTENNA_hold2111_A _5440_/Q VGND VGND VPWR VPWR sky130_fd_sc_hd__diode_2
XPHY_EDGE_ROW_60_Right_60 VGND VGND VPWR VPWR sky130_fd_sc_hd__decap_3
XFILLER_48_572 VGND VGND VPWR VPWR sky130_fd_sc_hd__fill_4
XFILLER_36_701 VGND VGND VPWR VPWR sky130_fd_sc_hd__fill_1
XFILLER_75_380 VGND VGND VPWR VPWR sky130_fd_sc_hd__fill_1
XFILLER_23_417 VPWR VGND VPWR VGND sky130_ef_sc_hd__decap_40_12
XTAP_TAPCELL_ROW_106_1893 VGND VPWR sky130_fd_sc_hd__tapvpwrvgnd_1
X_3963_ _5003_/A _5006_/A _5000_/A _5000_/B VGND VGND VPWR VPWR _4010_/A sky130_fd_sc_hd__or4_2
X_2914_ _6428_/Q _5313_/Q _3072_/S VGND VGND VPWR VPWR _2914_/X sky130_fd_sc_hd__mux2_1
X_3894_ hold419/X _6413_/Q _3899_/S VGND VGND VPWR VPWR _3894_/X sky130_fd_sc_hd__mux2_1
XTAP_TAPCELL_ROW_21_618 VGND VPWR sky130_fd_sc_hd__tapvpwrvgnd_1
X_5702_ _5902_/CLK _5702_/D VGND VGND VPWR VPWR _5702_/Q sky130_fd_sc_hd__dfxtp_1
XFILLER_137_809 VPWR VGND VPWR VGND sky130_ef_sc_hd__decap_40_12
X_2845_ _3036_/A1 _2844_/X _3096_/A1 VGND VGND VPWR VPWR _2845_/X sky130_fd_sc_hd__o21a_1
X_5633_ _6237_/CLK _5633_/D VGND VGND VPWR VPWR _5633_/Q sky130_fd_sc_hd__dfxtp_1
X_5564_ _5565_/CLK _5564_/D VGND VGND VPWR VPWR _5564_/Q sky130_fd_sc_hd__dfxtp_1
XFILLER_12_29 VGND VGND VPWR VPWR sky130_fd_sc_hd__fill_4
XFILLER_128_29 VPWR VGND VPWR VGND sky130_ef_sc_hd__decap_40_12
X_2776_ _6150_/Q _6219_/Q _3091_/S VGND VGND VPWR VPWR _2776_/X sky130_fd_sc_hd__mux2_1
Xhold101 _5639_/Q VGND VGND VPWR VPWR hold101/X sky130_fd_sc_hd__dlygate4sd3_1
X_4515_ hold447/X _4515_/A1 _4522_/S VGND VGND VPWR VPWR _4515_/X sky130_fd_sc_hd__mux2_1
Xhold134 _3441_/X VGND VGND VPWR VPWR _5491_/D sky130_fd_sc_hd__dlygate4sd3_1
XPHY_EDGE_ROW_103_Right_103 VGND VGND VPWR VPWR sky130_fd_sc_hd__decap_3
X_5495_ _5820_/CLK _5495_/D VGND VGND VPWR VPWR _5495_/Q sky130_fd_sc_hd__dfxtp_1
XANTENNA__3009__A1_N _3096_/A1 VGND VGND VPWR VPWR sky130_fd_sc_hd__diode_2
Xhold112 _3696_/X VGND VGND VPWR VPWR _5717_/D sky130_fd_sc_hd__dlygate4sd3_1
Xhold123 _5970_/Q VGND VGND VPWR VPWR hold123/X sky130_fd_sc_hd__dlygate4sd3_1
XFILLER_132_525 VGND VGND VPWR VPWR sky130_fd_sc_hd__fill_4
Xhold156 _3202_/X VGND VGND VPWR VPWR _5364_/D sky130_fd_sc_hd__dlygate4sd3_1
Xhold167 _6233_/Q VGND VGND VPWR VPWR hold167/X sky130_fd_sc_hd__dlygate4sd3_1
Xhold145 _5750_/Q VGND VGND VPWR VPWR hold145/X sky130_fd_sc_hd__dlygate4sd3_1
X_4446_ _6257_/Q _3366_/X _4427_/B _5841_/Q _3801_/B VGND VGND VPWR VPWR _4446_/X
+ sky130_fd_sc_hd__a221o_2
XFILLER_132_569 VPWR VGND VPWR VGND sky130_ef_sc_hd__decap_40_12
Xhold189 _6320_/Q VGND VGND VPWR VPWR hold189/X sky130_fd_sc_hd__dlygate4sd3_1
Xhold178 _3787_/X VGND VGND VPWR VPWR _5795_/D sky130_fd_sc_hd__dlygate4sd3_1
X_4377_ _4965_/A _4377_/B VGND VGND VPWR VPWR _4386_/S sky130_fd_sc_hd__nor2_4
XFILLER_113_783 VGND VGND VPWR VPWR sky130_fd_sc_hd__fill_1
X_3328_ _3328_/A _3328_/B VGND VGND VPWR VPWR _3328_/Y sky130_fd_sc_hd__nand2_2
XFILLER_59_837 VGND VGND VPWR VPWR sky130_fd_sc_hd__fill_2
XANTENNA__2702__A1 _5343_/Q VGND VGND VPWR VPWR sky130_fd_sc_hd__diode_2
XANTENNA__2702__B2 _4149_/A VGND VGND VPWR VPWR sky130_fd_sc_hd__diode_2
X_6116_ _6125_/CLK _6116_/D VGND VGND VPWR VPWR _6116_/Q sky130_fd_sc_hd__dfxtp_1
XFILLER_85_122 VGND VGND VPWR VPWR sky130_fd_sc_hd__fill_2
XPHY_EDGE_ROW_13_Left_152 VGND VGND VPWR VPWR sky130_fd_sc_hd__decap_3
XANTENNA_fanout184_X _3044_/A VGND VGND VPWR VPWR sky130_fd_sc_hd__diode_2
X_6047_ _6403_/CLK _6047_/D VGND VGND VPWR VPWR _6047_/Q sky130_fd_sc_hd__dfxtp_1
X_3259_ _4274_/A0 _3259_/A1 _3259_/S VGND VGND VPWR VPWR _3259_/X sky130_fd_sc_hd__mux2_1
XFILLER_85_199 VGND VGND VPWR VPWR sky130_fd_sc_hd__fill_1
XTAP_TAPCELL_ROW_68_1321 VGND VPWR sky130_fd_sc_hd__tapvpwrvgnd_1
XTAP_TAPCELL_ROW_1_310 VGND VPWR sky130_fd_sc_hd__tapvpwrvgnd_1
XTAP_TAPCELL_ROW_1_321 VGND VPWR sky130_fd_sc_hd__tapvpwrvgnd_1
XTAP_TAPCELL_ROW_29_729 VGND VPWR sky130_fd_sc_hd__tapvpwrvgnd_1
XFILLER_26_233 VGND VGND VPWR VPWR sky130_fd_sc_hd__fill_1
XTAP_TAPCELL_ROW_81_1510 VGND VPWR sky130_fd_sc_hd__tapvpwrvgnd_1
XFILLER_14_417 VGND VGND VPWR VPWR sky130_fd_sc_hd__fill_2
XFILLER_26_277 VGND VGND VPWR VPWR sky130_fd_sc_hd__fill_1
XTAP_TAPCELL_ROW_81_1521 VGND VPWR sky130_fd_sc_hd__tapvpwrvgnd_1
XFILLER_10_601 VPWR VGND VPWR VGND sky130_ef_sc_hd__decap_40_12
XPHY_EDGE_ROW_22_Left_161 VGND VGND VPWR VPWR sky130_fd_sc_hd__decap_3
XTAP_TAPCELL_ROW_40_905 VGND VPWR sky130_fd_sc_hd__tapvpwrvgnd_1
XANTENNA__2864__S1 _3050_/A VGND VGND VPWR VPWR sky130_fd_sc_hd__diode_2
XFILLER_128_809 VGND VGND VPWR VPWR sky130_fd_sc_hd__fill_2
XFILLER_50_781 VPWR VGND VPWR VGND sky130_ef_sc_hd__decap_40_12
XFILLER_10_645 VPWR VGND VPWR VGND sky130_ef_sc_hd__decap_40_12
XANTENNA__4915__C1 _5176_/A VGND VGND VPWR VPWR sky130_fd_sc_hd__diode_2
XFILLER_108_533 VPWR VGND VPWR VGND sky130_ef_sc_hd__decap_40_12
XANTENNA__4391__A0 _4929_/A1 VGND VGND VPWR VPWR sky130_fd_sc_hd__diode_2
XFILLER_123_503 VGND VGND VPWR VPWR sky130_fd_sc_hd__fill_1
XTAP_TAPCELL_ROW_79_1483 VGND VPWR sky130_fd_sc_hd__tapvpwrvgnd_1
XTAP_TAPCELL_ROW_9_432 VGND VPWR sky130_fd_sc_hd__tapvpwrvgnd_1
XFILLER_2_811 VGND VGND VPWR VPWR sky130_fd_sc_hd__fill_1
XFILLER_111_709 VPWR VGND VPWR VGND sky130_ef_sc_hd__decap_40_12
XANTENNA__2995__A _2995_/A VGND VGND VPWR VPWR sky130_fd_sc_hd__diode_2
XANTENNA__4686__S _4778_/S VGND VGND VPWR VPWR sky130_fd_sc_hd__diode_2
Xhold690 _5714_/Q VGND VGND VPWR VPWR hold690/X sky130_fd_sc_hd__dlygate4sd3_1
XANTENNA_fanout97_X _4983_/A1 VGND VGND VPWR VPWR sky130_fd_sc_hd__diode_2
XANTENNA__4143__B1 _3172_/B VGND VGND VPWR VPWR sky130_fd_sc_hd__diode_2
XFILLER_110_208 VGND VGND VPWR VPWR sky130_fd_sc_hd__fill_1
XTAP_TAPCELL_ROW_92_1683 VGND VPWR sky130_fd_sc_hd__tapvpwrvgnd_1
XANTENNA__3590__S _3595_/S VGND VGND VPWR VPWR sky130_fd_sc_hd__diode_2
XFILLER_77_612 VGND VGND VPWR VPWR sky130_fd_sc_hd__fill_4
XPHY_EDGE_ROW_31_Left_170 VGND VGND VPWR VPWR sky130_fd_sc_hd__decap_3
Xhold2080 _5224_/X VGND VGND VPWR VPWR _6422_/D sky130_fd_sc_hd__dlygate4sd3_1
XFILLER_18_701 VPWR VGND VPWR VGND sky130_ef_sc_hd__decap_40_12
XFILLER_37_509 VGND VGND VPWR VPWR sky130_fd_sc_hd__fill_1
XFILLER_92_637 VGND VGND VPWR VPWR sky130_fd_sc_hd__fill_4
Xhold2091 _5320_/Q VGND VGND VPWR VPWR _3128_/A sky130_fd_sc_hd__dlygate4sd3_1
XANTENNA__2934__S _3077_/S VGND VGND VPWR VPWR sky130_fd_sc_hd__diode_2
XFILLER_91_169 VGND VGND VPWR VPWR sky130_fd_sc_hd__fill_4
Xhold1390 _2925_/S VGND VGND VPWR VPWR _2982_/S sky130_fd_sc_hd__dlygate4sd3_1
XFILLER_72_361 VGND VGND VPWR VPWR sky130_fd_sc_hd__fill_2
XFILLER_32_214 VGND VGND VPWR VPWR sky130_fd_sc_hd__fill_1
XFILLER_13_461 VPWR VGND VPWR VGND sky130_ef_sc_hd__decap_40_12
XFILLER_119_809 VPWR VGND VPWR VGND sky130_ef_sc_hd__decap_40_12
X_2630_ _3244_/B VGND VGND VPWR VPWR _3777_/A sky130_fd_sc_hd__inv_2
XANTENNA__3765__S _3766_/S VGND VGND VPWR VPWR sky130_fd_sc_hd__diode_2
XANTENNA__3185__A1 _4846_/A0 VGND VGND VPWR VPWR sky130_fd_sc_hd__diode_2
XFILLER_99_203 VGND VGND VPWR VPWR sky130_fd_sc_hd__fill_1
X_5280_ _6196_/CLK _5280_/D VGND VGND VPWR VPWR _5280_/Q sky130_fd_sc_hd__dfxtp_1
X_4300_ hold41/X _5043_/A1 _4304_/S VGND VGND VPWR VPWR hold42/A sky130_fd_sc_hd__mux2_1
XFILLER_5_671 VGND VGND VPWR VPWR sky130_fd_sc_hd__fill_1
XFILLER_114_569 VPWR VGND VPWR VGND sky130_ef_sc_hd__decap_40_12
XANTENNA__4449__X _4449_/X VGND VGND VPWR VPWR sky130_fd_sc_hd__diode_2
X_4231_ _4227_/X _4229_/X _4230_/X _4271_/S1 VGND VGND VPWR VPWR _4232_/B sky130_fd_sc_hd__a22o_1
XFILLER_4_170 VGND VGND VPWR VPWR sky130_fd_sc_hd__fill_2
XFILLER_4_41 VPWR VGND VPWR VGND sky130_ef_sc_hd__decap_40_12
XFILLER_68_645 VGND VGND VPWR VPWR sky130_fd_sc_hd__fill_1
XFILLER_67_111 VGND VGND VPWR VPWR sky130_fd_sc_hd__fill_1
XFILLER_4_96 VGND VGND VPWR VPWR sky130_fd_sc_hd__fill_2
X_4162_ _4218_/A _4162_/B VGND VGND VPWR VPWR _4162_/Y sky130_fd_sc_hd__nor2_1
X_3113_ _3113_/A _3113_/B _3113_/C VGND VGND VPWR VPWR _5225_/A sky130_fd_sc_hd__or3_2
XFILLER_110_753 VGND VGND VPWR VPWR sky130_fd_sc_hd__fill_2
XFILLER_68_667 VGND VGND VPWR VPWR sky130_fd_sc_hd__fill_1
XFILLER_67_166 VGND VGND VPWR VPWR sky130_fd_sc_hd__fill_2
X_4093_ hold73/A _6319_/Q _4228_/S VGND VGND VPWR VPWR _4093_/X sky130_fd_sc_hd__mux2_1
X_3044_ _3044_/A _3044_/B VGND VGND VPWR VPWR _3044_/X sky130_fd_sc_hd__or2_1
XTAP_TAPCELL_ROW_108_1922 VGND VPWR sky130_fd_sc_hd__tapvpwrvgnd_1
XFILLER_82_125 VGND VGND VPWR VPWR sky130_fd_sc_hd__fill_2
XFILLER_82_114 VGND VGND VPWR VPWR sky130_fd_sc_hd__fill_1
XANTENNA__4437__B2 _4436_/X VGND VGND VPWR VPWR sky130_fd_sc_hd__diode_2
XANTENNA__2844__S _3091_/S VGND VGND VPWR VPWR sky130_fd_sc_hd__diode_2
XFILLER_70_309 VGND VGND VPWR VPWR sky130_fd_sc_hd__fill_2
XFILLER_36_531 VGND VGND VPWR VPWR sky130_fd_sc_hd__fill_1
XANTENNA__4625__A _4794_/A VGND VGND VPWR VPWR sky130_fd_sc_hd__diode_2
XFILLER_63_350 VGND VGND VPWR VPWR sky130_fd_sc_hd__fill_2
XFILLER_24_737 VGND VGND VPWR VPWR sky130_fd_sc_hd__fill_1
X_4995_ _6408_/Q _3973_/B _3315_/B _3974_/B _3975_/A VGND VGND VPWR VPWR _4995_/X
+ sky130_fd_sc_hd__a41o_1
X_3946_ _5162_/A _5162_/B VGND VGND VPWR VPWR _3947_/B sky130_fd_sc_hd__or2_1
XTAP_TAPCELL_ROW_63_1251 VGND VPWR sky130_fd_sc_hd__tapvpwrvgnd_1
XTAP_TAPCELL_ROW_63_1240 VGND VPWR sky130_fd_sc_hd__tapvpwrvgnd_1
XANTENNA_fanout144_A _4600_/A VGND VGND VPWR VPWR sky130_fd_sc_hd__diode_2
XFILLER_32_781 VPWR VGND VPWR VGND sky130_ef_sc_hd__decap_40_12
XFILLER_137_617 VPWR VGND VPWR VGND sky130_ef_sc_hd__decap_40_12
XFILLER_109_319 VGND VGND VPWR VPWR sky130_fd_sc_hd__fill_1
X_3877_ _3926_/A1 _3877_/A1 _3879_/S VGND VGND VPWR VPWR _5858_/D sky130_fd_sc_hd__mux2_1
XANTENNA__4048__S0 _4237_/S VGND VGND VPWR VPWR sky130_fd_sc_hd__diode_2
XFILLER_31_291 VGND VGND VPWR VPWR sky130_fd_sc_hd__fill_1
X_2828_ _2962_/A _2828_/B VGND VGND VPWR VPWR _2828_/X sky130_fd_sc_hd__or2_1
X_5616_ _6297_/CLK _5616_/D VGND VGND VPWR VPWR _5616_/Q sky130_fd_sc_hd__dfxtp_1
XANTENNA__4373__A0 _4981_/A1 VGND VGND VPWR VPWR sky130_fd_sc_hd__diode_2
X_2759_ _3076_/A1 _2754_/X _2756_/X _2758_/X VGND VGND VPWR VPWR _2759_/X sky130_fd_sc_hd__a22o_1
X_5547_ _5571_/CLK _5547_/D VGND VGND VPWR VPWR _5547_/Q sky130_fd_sc_hd__dfxtp_1
X_5478_ _6398_/CLK _5478_/D VGND VGND VPWR VPWR _5478_/Q sky130_fd_sc_hd__dfxtp_1
X_4429_ _4426_/X _4427_/X _4428_/X _4457_/S _4429_/B2 VGND VGND VPWR VPWR _4429_/X
+ sky130_fd_sc_hd__o32a_1
XANTENNA__3023__S1 _3020_/A VGND VGND VPWR VPWR sky130_fd_sc_hd__diode_2
XFILLER_99_781 VGND VGND VPWR VPWR sky130_fd_sc_hd__fill_2
XANTENNA__4220__S0 _4213_/S VGND VGND VPWR VPWR sky130_fd_sc_hd__diode_2
XFILLER_101_753 VPWR VGND VPWR VGND sky130_ef_sc_hd__decap_40_12
XFILLER_101_797 VPWR VGND VPWR VGND sky130_ef_sc_hd__decap_40_12
XANTENNA__4428__B2 _4901_/A0 VGND VGND VPWR VPWR sky130_fd_sc_hd__diode_2
XFILLER_27_542 VGND VGND VPWR VPWR sky130_fd_sc_hd__fill_2
XFILLER_39_391 VGND VGND VPWR VPWR sky130_fd_sc_hd__fill_1
XFILLER_54_350 VGND VGND VPWR VPWR sky130_fd_sc_hd__fill_1
XFILLER_42_512 VGND VGND VPWR VPWR sky130_fd_sc_hd__fill_1
Xfanout62 _2642_/Y VGND VGND VPWR VPWR _3031_/A1 sky130_fd_sc_hd__buf_4
XFILLER_120_85 VGND VGND VPWR VPWR sky130_fd_sc_hd__fill_1
Xfanout73 _2629_/Y VGND VGND VPWR VPWR _4791_/A1 sky130_fd_sc_hd__buf_4
XANTENNA__4061__C1 _5343_/Q VGND VGND VPWR VPWR sky130_fd_sc_hd__diode_2
Xfanout84 _5211_/A1 VGND VGND VPWR VPWR _4517_/A1 sky130_fd_sc_hd__buf_4
Xfanout95 _5832_/Q VGND VGND VPWR VPWR _4984_/A1 sky130_fd_sc_hd__clkbuf_4
XFILLER_10_475 VGND VGND VPWR VPWR sky130_fd_sc_hd__fill_1
XFILLER_6_413 VGND VGND VPWR VPWR sky130_fd_sc_hd__fill_4
XTAP_TAPCELL_ROW_94_1712 VGND VPWR sky130_fd_sc_hd__tapvpwrvgnd_1
XFILLER_6_457 VPWR VGND VPWR VGND sky130_ef_sc_hd__decap_40_12
XFILLER_135_160 VGND VGND VPWR VPWR sky130_fd_sc_hd__fill_1
XFILLER_108_363 VGND VGND VPWR VPWR sky130_fd_sc_hd__fill_1
XFILLER_2_641 VGND VGND VPWR VPWR sky130_fd_sc_hd__fill_2
XANTENNA__2929__S _3072_/S VGND VGND VPWR VPWR sky130_fd_sc_hd__diode_2
XFILLER_111_517 VPWR VGND VPWR VGND sky130_ef_sc_hd__decap_40_12
XFILLER_97_729 VPWR VGND VPWR VGND sky130_ef_sc_hd__decap_40_12
XANTENNA__4667__A1 _4811_/A1 VGND VGND VPWR VPWR sky130_fd_sc_hd__diode_2
XANTENNA__2678__B1 _5222_/A VGND VGND VPWR VPWR sky130_fd_sc_hd__diode_2
XFILLER_49_111 VGND VGND VPWR VPWR sky130_fd_sc_hd__fill_1
XFILLER_37_306 VGND VGND VPWR VPWR sky130_fd_sc_hd__fill_1
XTAP_TAPCELL_ROW_121_2108 VGND VPWR sky130_fd_sc_hd__tapvpwrvgnd_1
XFILLER_18_531 VGND VGND VPWR VPWR sky130_fd_sc_hd__fill_1
XTAP_TAPCELL_ROW_121_2119 VGND VPWR sky130_fd_sc_hd__tapvpwrvgnd_1
XANTENNA__4445__A _4445_/A VGND VGND VPWR VPWR sky130_fd_sc_hd__diode_2
XFILLER_61_821 VPWR VGND VPWR VGND sky130_ef_sc_hd__decap_40_12
XANTENNA__2850__B1 _3085_/A VGND VGND VPWR VPWR sky130_fd_sc_hd__diode_2
XTAP_TAPCELL_ROW_103_1852 VGND VPWR sky130_fd_sc_hd__tapvpwrvgnd_1
XTAP_TAPCELL_ROW_103_1841 VGND VPWR sky130_fd_sc_hd__tapvpwrvgnd_1
X_3800_ _5176_/A _3800_/A2 _2656_/Y _5806_/D VGND VGND VPWR VPWR _5807_/D sky130_fd_sc_hd__a31o_1
X_4780_ _5850_/Q _5628_/Q _4810_/S VGND VGND VPWR VPWR _4780_/X sky130_fd_sc_hd__mux2_1
XFILLER_21_729 VPWR VGND VPWR VGND sky130_ef_sc_hd__decap_40_12
X_3731_ _2625_/Y input7/X input8/X _3837_/A _5747_/Q VGND VGND VPWR VPWR _3731_/X
+ sky130_fd_sc_hd__o41a_1
XFILLER_14_781 VPWR VGND VPWR VGND sky130_ef_sc_hd__decap_40_12
XANTENNA__3495__S _3503_/S VGND VGND VPWR VPWR sky130_fd_sc_hd__diode_2
XFILLER_119_617 VPWR VGND VPWR VGND sky130_ef_sc_hd__decap_40_12
XTAP_TAPCELL_ROW_31_768 VGND VPWR sky130_fd_sc_hd__tapvpwrvgnd_1
XTAP_TAPCELL_ROW_136_2340 VGND VPWR sky130_fd_sc_hd__tapvpwrvgnd_1
X_3662_ _4517_/A1 _3662_/A1 _3667_/S VGND VGND VPWR VPWR _5687_/D sky130_fd_sc_hd__mux2_1
Xclkload10 _6312_/CLK VGND VGND VPWR VPWR clkload10/Y sky130_fd_sc_hd__inv_6
X_3593_ hold341/X _3926_/A1 _3595_/S VGND VGND VPWR VPWR _3593_/X sky130_fd_sc_hd__mux2_1
X_6381_ _6382_/CLK _6381_/D VGND VGND VPWR VPWR _6381_/Q sky130_fd_sc_hd__dfxtp_1
Xclkload32 _6351_/CLK VGND VGND VPWR VPWR clkload32/Y sky130_fd_sc_hd__clkinv_4
X_5401_ _6114_/CLK _5401_/D VGND VGND VPWR VPWR _5401_/Q sky130_fd_sc_hd__dfxtp_4
Xclkload21 _5731_/CLK VGND VGND VPWR VPWR clkload21/Y sky130_fd_sc_hd__inv_6
XTAP_TAPCELL_ROW_11_470 VGND VPWR sky130_fd_sc_hd__tapvpwrvgnd_1
Xclkload43 _5902_/CLK VGND VGND VPWR VPWR clkload43/Y sky130_fd_sc_hd__clkinvlp_4
Xclkload87 _6252_/CLK VGND VGND VPWR VPWR clkload87/Y sky130_fd_sc_hd__clkinvlp_4
Xclkload76 _6146_/CLK VGND VGND VPWR VPWR clkload76/Y sky130_fd_sc_hd__inv_6
Xclkload65 _6137_/CLK VGND VGND VPWR VPWR clkload65/Y sky130_fd_sc_hd__clkinv_2
X_5332_ _6239_/CLK _5332_/D VGND VGND VPWR VPWR _5332_/Q sky130_fd_sc_hd__dfxtp_1
Xclkload54 _5898_/CLK VGND VGND VPWR VPWR clkload54/Y sky130_fd_sc_hd__inv_6
Xclkload98 _6386_/CLK VGND VGND VPWR VPWR clkload98/Y sky130_fd_sc_hd__inv_8
XFILLER_130_837 VGND VGND VPWR VPWR sky130_fd_sc_hd__fill_4
X_5263_ _6351_/CLK _5263_/D VGND VGND VPWR VPWR _5263_/Q sky130_fd_sc_hd__dfxtp_1
X_5194_ _6262_/Q _6261_/Q _5194_/S VGND VGND VPWR VPWR _5194_/X sky130_fd_sc_hd__mux2_1
X_4214_ _4264_/A1 _4213_/X _4205_/A VGND VGND VPWR VPWR _4214_/Y sky130_fd_sc_hd__o21ai_1
X_4145_ _4252_/B1 _4144_/X _4141_/Y _4143_/Y VGND VGND VPWR VPWR _4146_/B sky130_fd_sc_hd__o2bb2a_1
XFILLER_68_475 VGND VGND VPWR VPWR sky130_fd_sc_hd__fill_1
XFILLER_28_317 VGND VGND VPWR VPWR sky130_fd_sc_hd__fill_4
X_4076_ _4218_/A _4076_/B VGND VGND VPWR VPWR _4076_/Y sky130_fd_sc_hd__nor2_1
X_3027_ _3027_/A _3027_/B VGND VGND VPWR VPWR _3027_/X sky130_fd_sc_hd__and2_1
XFILLER_71_629 VGND VGND VPWR VPWR sky130_fd_sc_hd__fill_2
XFILLER_43_309 VGND VGND VPWR VPWR sky130_fd_sc_hd__fill_2
XTAP_TAPCELL_ROW_39_879 VGND VPWR sky130_fd_sc_hd__tapvpwrvgnd_1
XTAP_TAPCELL_ROW_19_581 VGND VPWR sky130_fd_sc_hd__tapvpwrvgnd_1
XTAP_TAPCELL_ROW_19_592 VGND VPWR sky130_fd_sc_hd__tapvpwrvgnd_1
XANTENNA_fanout147_X _4803_/S VGND VGND VPWR VPWR sky130_fd_sc_hd__diode_2
X_4978_ hold753/X _4978_/A1 _4984_/S VGND VGND VPWR VPWR _4978_/X sky130_fd_sc_hd__mux2_1
XANTENNA__3397__A1 _5043_/A1 VGND VGND VPWR VPWR sky130_fd_sc_hd__diode_2
Xclkload4 clkload4/A VGND VGND VPWR VPWR clkload4/X sky130_fd_sc_hd__clkbuf_8
X_3929_ _5038_/B _3929_/B VGND VGND VPWR VPWR _3938_/S sky130_fd_sc_hd__or2_4
XFILLER_125_609 VGND VGND VPWR VPWR sky130_fd_sc_hd__fill_4
XTAP_TAPCELL_ROW_76_1442 VGND VPWR sky130_fd_sc_hd__tapvpwrvgnd_1
XFILLER_3_427 VGND VGND VPWR VPWR sky130_fd_sc_hd__fill_1
XFILLER_133_653 VPWR VGND VPWR VGND sky130_ef_sc_hd__decap_40_12
XFILLER_132_130 VGND VGND VPWR VPWR sky130_fd_sc_hd__fill_1
XFILLER_117_193 VGND VGND VPWR VPWR sky130_fd_sc_hd__fill_1
XFILLER_3_449 VPWR VGND VPWR VGND sky130_ef_sc_hd__decap_40_12
XFILLER_1_6 VPWR VGND VPWR VGND sky130_ef_sc_hd__decap_40_12
XFILLER_121_837 VGND VGND VPWR VPWR sky130_fd_sc_hd__fill_2
XFILLER_133_697 VPWR VGND VPWR VGND sky130_ef_sc_hd__decap_40_12
XFILLER_78_239 VPWR VGND VPWR VGND sky130_ef_sc_hd__decap_40_12
XFILLER_101_561 VPWR VGND VPWR VGND sky130_ef_sc_hd__decap_40_12
XFILLER_62_607 VGND VGND VPWR VPWR sky130_fd_sc_hd__fill_1
XFILLER_43_821 VPWR VGND VPWR VGND sky130_ef_sc_hd__decap_40_12
XFILLER_15_501 VGND VGND VPWR VPWR sky130_fd_sc_hd__fill_2
XFILLER_70_640 VGND VGND VPWR VPWR sky130_fd_sc_hd__fill_1
XFILLER_91_55 VGND VGND VPWR VPWR sky130_fd_sc_hd__fill_1
XANTENNA__3388__A1 _4982_/A1 VGND VGND VPWR VPWR sky130_fd_sc_hd__diode_2
XTAP_TAPCELL_ROW_118_2070 VGND VPWR sky130_fd_sc_hd__tapvpwrvgnd_1
XANTENNA__4431__C input4/X VGND VGND VPWR VPWR sky130_fd_sc_hd__diode_2
XFILLER_7_777 VGND VGND VPWR VPWR sky130_fd_sc_hd__fill_4
XANTENNA__4888__A1 _4901_/A0 VGND VGND VPWR VPWR sky130_fd_sc_hd__diode_2
XFILLER_6_287 VGND VGND VPWR VPWR sky130_fd_sc_hd__fill_1
XFILLER_6_276 VGND VGND VPWR VPWR sky130_fd_sc_hd__fill_1
XFILLER_108_193 VGND VGND VPWR VPWR sky130_fd_sc_hd__fill_1
XTAP_TAPCELL_ROW_131_2270 VGND VPWR sky130_fd_sc_hd__tapvpwrvgnd_1
XFILLER_41_7 VGND VGND VPWR VPWR sky130_fd_sc_hd__fill_1
XFILLER_124_697 VGND VGND VPWR VPWR sky130_fd_sc_hd__fill_2
XFILLER_112_837 VGND VGND VPWR VPWR sky130_fd_sc_hd__fill_4
XFILLER_111_314 VGND VGND VPWR VPWR sky130_fd_sc_hd__fill_1
XANTENNA__4874__S _4880_/S VGND VGND VPWR VPWR sky130_fd_sc_hd__diode_2
XFILLER_84_209 VGND VGND VPWR VPWR sky130_fd_sc_hd__fill_4
XFILLER_78_751 VGND VGND VPWR VPWR sky130_fd_sc_hd__fill_4
XFILLER_93_721 VGND VGND VPWR VPWR sky130_fd_sc_hd__fill_4
XFILLER_77_283 VGND VGND VPWR VPWR sky130_fd_sc_hd__fill_4
XFILLER_65_401 VGND VGND VPWR VPWR sky130_fd_sc_hd__fill_1
XANTENNA__4727__X _4727_/X VGND VGND VPWR VPWR sky130_fd_sc_hd__diode_2
XFILLER_93_765 VPWR VGND VPWR VGND sky130_ef_sc_hd__decap_40_12
XFILLER_1_42 VPWR VGND VPWR VGND sky130_ef_sc_hd__decap_40_12
XFILLER_92_253 VGND VGND VPWR VPWR sky130_fd_sc_hd__fill_4
X_5950_ _6338_/CLK hold42/X VGND VGND VPWR VPWR hold41/A sky130_fd_sc_hd__dfxtp_1
XFILLER_37_158 VGND VGND VPWR VPWR sky130_fd_sc_hd__fill_2
X_4901_ _4901_/A0 _4901_/A1 _4906_/S VGND VGND VPWR VPWR _4901_/X sky130_fd_sc_hd__mux2_1
XFILLER_80_437 VGND VGND VPWR VPWR sky130_fd_sc_hd__fill_2
XTAP_TAPCELL_ROW_47_1010 VGND VPWR sky130_fd_sc_hd__tapvpwrvgnd_1
XTAP_TAPCELL_ROW_36_838 VGND VPWR sky130_fd_sc_hd__tapvpwrvgnd_1
XANTENNA__4812__A1 _2628_/A VGND VGND VPWR VPWR sky130_fd_sc_hd__diode_2
XTAP_TAPCELL_ROW_16_540 VGND VPWR sky130_fd_sc_hd__tapvpwrvgnd_1
X_5881_ _6414_/CLK _5881_/D VGND VGND VPWR VPWR _5881_/Q sky130_fd_sc_hd__dfxtp_1
X_4832_ _4445_/A _4832_/A1 _4841_/S VGND VGND VPWR VPWR _4832_/X sky130_fd_sc_hd__mux2_1
XFILLER_21_559 VGND VGND VPWR VPWR sky130_fd_sc_hd__fill_1
X_4763_ _5718_/Q _5709_/Q _5700_/Q _5904_/Q _4808_/S _4809_/A VGND VGND VPWR VPWR
+ _4763_/X sky130_fd_sc_hd__mux4_1
X_3714_ hold787/X _5044_/A1 _3717_/S VGND VGND VPWR VPWR _3714_/X sky130_fd_sc_hd__mux2_1
X_4694_ _4690_/X _4691_/X _4693_/X _4692_/X _4811_/A1 _4663_/A VGND VGND VPWR VPWR
+ _4694_/X sky130_fd_sc_hd__mux4_1
X_6433_ _6435_/CLK _6433_/D VGND VGND VPWR VPWR _6433_/Q sky130_fd_sc_hd__dfxtp_1
XFILLER_107_609 VGND VGND VPWR VPWR sky130_fd_sc_hd__fill_4
XANTENNA__4328__A0 _5040_/A1 VGND VGND VPWR VPWR sky130_fd_sc_hd__diode_2
XANTENNA__4879__A1 _4905_/A0 VGND VGND VPWR VPWR sky130_fd_sc_hd__diode_2
X_3645_ hold268/X _3926_/A1 _3647_/S VGND VGND VPWR VPWR _3645_/X sky130_fd_sc_hd__mux2_1
XFILLER_20_29 VGND VGND VPWR VPWR sky130_fd_sc_hd__fill_1
X_6364_ _6365_/CLK _6364_/D VGND VGND VPWR VPWR _6364_/Q sky130_fd_sc_hd__dfxtp_1
XFILLER_136_29 VPWR VGND VPWR VGND sky130_ef_sc_hd__decap_40_12
XFILLER_115_653 VPWR VGND VPWR VGND sky130_ef_sc_hd__decap_40_12
X_3576_ hold948/X _5208_/A1 _3584_/S VGND VGND VPWR VPWR _3576_/X sky130_fd_sc_hd__mux2_1
XANTENNA_fanout107_A _5825_/Q VGND VGND VPWR VPWR sky130_fd_sc_hd__diode_2
XFILLER_130_601 VPWR VGND VPWR VGND sky130_ef_sc_hd__decap_40_12
X_5315_ _6435_/CLK _5315_/D VGND VGND VPWR VPWR _5315_/Q sky130_fd_sc_hd__dfxtp_1
X_6295_ _6298_/CLK _6295_/D VGND VGND VPWR VPWR _6295_/Q sky130_fd_sc_hd__dfxtp_1
XANTENNA__3551__A1 _4521_/A1 VGND VGND VPWR VPWR sky130_fd_sc_hd__diode_2
XTAP_TAPCELL_ROW_58_1172 VGND VPWR sky130_fd_sc_hd__tapvpwrvgnd_1
XFILLER_130_645 VPWR VGND VPWR VGND sky130_ef_sc_hd__decap_40_12
XFILLER_115_697 VPWR VGND VPWR VGND sky130_ef_sc_hd__decap_40_12
X_5246_ _5571_/CLK _5246_/D VGND VGND VPWR VPWR _5246_/Q sky130_fd_sc_hd__dfxtp_1
XFILLER_103_837 VGND VGND VPWR VPWR sky130_fd_sc_hd__fill_2
Xhold38 hold38/A VGND VGND VPWR VPWR hold38/X sky130_fd_sc_hd__dlygate4sd3_1
XANTENNA__3303__A1 _5232_/A0 VGND VGND VPWR VPWR sky130_fd_sc_hd__diode_2
XPHY_EDGE_ROW_89_Right_89 VGND VGND VPWR VPWR sky130_fd_sc_hd__decap_3
Xhold1901 _3701_/X VGND VGND VPWR VPWR _5722_/D sky130_fd_sc_hd__dlygate4sd3_1
XTAP_TAPCELL_ROW_71_1372 VGND VPWR sky130_fd_sc_hd__tapvpwrvgnd_1
XTAP_TAPCELL_ROW_71_1361 VGND VPWR sky130_fd_sc_hd__tapvpwrvgnd_1
Xhold16 hold16/A VGND VGND VPWR VPWR hold16/X sky130_fd_sc_hd__dlygate4sd3_1
XANTENNA__4726__S1 _4663_/A VGND VGND VPWR VPWR sky130_fd_sc_hd__diode_2
Xhold27 hold27/A VGND VGND VPWR VPWR hold27/X sky130_fd_sc_hd__dlygate4sd3_1
Xhold1923 _6372_/Q VGND VGND VPWR VPWR _5081_/A1 sky130_fd_sc_hd__dlygate4sd3_1
XFILLER_96_581 VGND VGND VPWR VPWR sky130_fd_sc_hd__fill_4
Xhold1912 _5270_/Q VGND VGND VPWR VPWR _2661_/A1 sky130_fd_sc_hd__dlygate4sd3_1
X_5177_ _3949_/Y _5175_/S _3952_/C VGND VGND VPWR VPWR _5177_/Y sky130_fd_sc_hd__a21boi_1
Xhold1945 _3876_/X VGND VGND VPWR VPWR _5857_/D sky130_fd_sc_hd__dlygate4sd3_1
Xhold1934 _5853_/Q VGND VGND VPWR VPWR _3872_/A1 sky130_fd_sc_hd__dlygate4sd3_1
Xhold49 hold49/A VGND VGND VPWR VPWR hold49/X sky130_fd_sc_hd__dlygate4sd3_1
XFILLER_83_231 VGND VGND VPWR VPWR sky130_fd_sc_hd__fill_8
Xhold1967 _3153_/X VGND VGND VPWR VPWR _5334_/D sky130_fd_sc_hd__dlygate4sd3_1
Xhold1978 _5328_/Q VGND VGND VPWR VPWR _4002_/B sky130_fd_sc_hd__dlygate4sd3_1
Xhold1956 _5739_/Q VGND VGND VPWR VPWR _4051_/A1 sky130_fd_sc_hd__dlygate4sd3_1
X_4128_ _4264_/A1 _4127_/X _3172_/B VGND VGND VPWR VPWR _4128_/Y sky130_fd_sc_hd__o21ai_1
XANTENNA__5056__A1 _5828_/Q VGND VGND VPWR VPWR sky130_fd_sc_hd__diode_2
XFILLER_84_798 VPWR VGND VPWR VGND sky130_ef_sc_hd__decap_40_12
Xhold1989 _4814_/Y VGND VGND VPWR VPWR _4815_/B2 sky130_fd_sc_hd__dlygate4sd3_1
X_4059_ _4252_/B1 _4058_/X _4055_/Y _4057_/Y VGND VGND VPWR VPWR _4060_/B sky130_fd_sc_hd__o2bb2a_1
XFILLER_71_426 VGND VGND VPWR VPWR sky130_fd_sc_hd__fill_1
XFILLER_25_821 VPWR VGND VPWR VGND sky130_ef_sc_hd__decap_40_12
XPHY_EDGE_ROW_98_Right_98 VGND VGND VPWR VPWR sky130_fd_sc_hd__decap_3
XFILLER_40_813 VPWR VGND VPWR VGND sky130_ef_sc_hd__decap_40_12
XFILLER_138_701 VPWR VGND VPWR VGND sky130_ef_sc_hd__decap_40_12
XFILLER_61_47 VGND VGND VPWR VPWR sky130_fd_sc_hd__fill_1
XANTENNA__4662__S0 _4803_/S VGND VGND VPWR VPWR sky130_fd_sc_hd__diode_2
XANTENNA__3790__A1 _5209_/A1 VGND VGND VPWR VPWR sky130_fd_sc_hd__diode_2
XFILLER_20_581 VGND VGND VPWR VPWR sky130_fd_sc_hd__fill_4
XFILLER_117_3 VPWR VGND VPWR VGND sky130_ef_sc_hd__decap_40_12
XANTENNA__3863__S _3869_/S VGND VGND VPWR VPWR sky130_fd_sc_hd__diode_2
XFILLER_4_725 VPWR VGND VPWR VGND sky130_ef_sc_hd__decap_40_12
XPHY_EDGE_ROW_5_Left_144 VGND VGND VPWR VPWR sky130_fd_sc_hd__decap_3
XFILLER_4_769 VPWR VGND VPWR VGND sky130_ef_sc_hd__decap_40_12
XFILLER_106_697 VGND VGND VPWR VPWR sky130_fd_sc_hd__fill_2
XFILLER_79_559 VGND VGND VPWR VPWR sky130_fd_sc_hd__fill_1
XFILLER_3_279 VGND VGND VPWR VPWR sky130_fd_sc_hd__fill_1
XFILLER_120_133 VGND VGND VPWR VPWR sky130_fd_sc_hd__fill_4
XFILLER_86_33 VGND VGND VPWR VPWR sky130_fd_sc_hd__fill_2
XFILLER_87_570 VGND VGND VPWR VPWR sky130_fd_sc_hd__fill_2
XTAP_TAPCELL_ROW_89_1633 VGND VPWR sky130_fd_sc_hd__tapvpwrvgnd_1
XFILLER_74_220 VGND VGND VPWR VPWR sky130_fd_sc_hd__fill_1
XANTENNA__5047__A1 _5047_/A1 VGND VGND VPWR VPWR sky130_fd_sc_hd__diode_2
XFILLER_47_445 VGND VGND VPWR VPWR sky130_fd_sc_hd__fill_1
XFILLER_74_253 VGND VGND VPWR VPWR sky130_fd_sc_hd__fill_2
XFILLER_90_757 VPWR VGND VPWR VGND sky130_ef_sc_hd__decap_40_12
XANTENNA__4426__C input4/X VGND VGND VPWR VPWR sky130_fd_sc_hd__diode_2
XFILLER_34_128 VGND VGND VPWR VPWR sky130_fd_sc_hd__fill_2
XTAP_TAPCELL_ROW_100_1800 VGND VPWR sky130_fd_sc_hd__tapvpwrvgnd_1
XFILLER_89_7 VPWR VGND VPWR VGND sky130_ef_sc_hd__decap_40_12
XFILLER_30_367 VGND VGND VPWR VPWR sky130_fd_sc_hd__fill_2
XFILLER_7_541 VPWR VGND VPWR VGND sky130_ef_sc_hd__decap_40_12
XANTENNA__3781__A1 _5210_/A1 VGND VGND VPWR VPWR sky130_fd_sc_hd__diode_2
XANTENNA__4869__S _4880_/S VGND VGND VPWR VPWR sky130_fd_sc_hd__diode_2
Xhold508 _3426_/X VGND VGND VPWR VPWR _5477_/D sky130_fd_sc_hd__dlygate4sd3_1
XFILLER_7_585 VPWR VGND VPWR VGND sky130_ef_sc_hd__decap_40_12
Xhold519 _3109_/X VGND VGND VPWR VPWR _5304_/D sky130_fd_sc_hd__dlygate4sd3_1
X_3430_ hold757/X _4886_/A1 _3437_/S VGND VGND VPWR VPWR _3430_/X sky130_fd_sc_hd__mux2_1
XFILLER_112_601 VPWR VGND VPWR VGND sky130_ef_sc_hd__decap_40_12
XANTENNA__3533__A1 _4846_/A0 VGND VGND VPWR VPWR sky130_fd_sc_hd__diode_2
XFILLER_98_813 VPWR VGND VPWR VGND sky130_ef_sc_hd__decap_40_12
X_3361_ _5211_/A0 _3360_/X _3365_/S VGND VGND VPWR VPWR _3361_/X sky130_fd_sc_hd__mux2_1
X_6080_ _6434_/CLK _6080_/D VGND VGND VPWR VPWR _6080_/Q sky130_fd_sc_hd__dfxtp_1
X_5100_ _5100_/A _5100_/B VGND VGND VPWR VPWR _5100_/Y sky130_fd_sc_hd__nand2_1
X_3292_ _3292_/A0 _4903_/A0 _3295_/S VGND VGND VPWR VPWR _3292_/X sky130_fd_sc_hd__mux2_1
XFILLER_112_645 VPWR VGND VPWR VGND sky130_ef_sc_hd__decap_40_12
XTAP_TAPCELL_ROW_111_1962 VGND VPWR sky130_fd_sc_hd__tapvpwrvgnd_1
XFILLER_97_345 VGND VGND VPWR VPWR sky130_fd_sc_hd__fill_1
XANTENNA__4708__S1 _4789_/A VGND VGND VPWR VPWR sky130_fd_sc_hd__diode_2
X_5031_ _5110_/A _3983_/Y _5012_/X _5030_/X VGND VGND VPWR VPWR _5031_/Y sky130_fd_sc_hd__a211oi_1
Xhold1219 _5243_/Q VGND VGND VPWR VPWR _2670_/A0 sky130_fd_sc_hd__dlygate4sd3_1
Xhold1208 _5469_/Q VGND VGND VPWR VPWR _3416_/A0 sky130_fd_sc_hd__dlygate4sd3_1
XTAP_TAPCELL_ROW_53_1091 VGND VPWR sky130_fd_sc_hd__tapvpwrvgnd_1
XFILLER_93_540 VPWR VGND VPWR VGND sky130_ef_sc_hd__decap_40_12
XFILLER_66_765 VPWR VGND VPWR VGND sky130_ef_sc_hd__decap_40_12
XFILLER_93_573 VPWR VGND VPWR VGND sky130_ef_sc_hd__decap_40_12
XFILLER_81_724 VGND VGND VPWR VPWR sky130_fd_sc_hd__fill_4
XFILLER_81_702 VGND VGND VPWR VPWR sky130_fd_sc_hd__fill_4
XFILLER_80_245 VGND VGND VPWR VPWR sky130_fd_sc_hd__fill_1
X_5933_ _6341_/CLK _5933_/D VGND VGND VPWR VPWR _5933_/Q sky130_fd_sc_hd__dfxtp_1
X_5864_ _5870_/CLK _5864_/D VGND VGND VPWR VPWR _5864_/Q sky130_fd_sc_hd__dfxtp_1
XFILLER_61_481 VGND VGND VPWR VPWR sky130_fd_sc_hd__fill_1
XFILLER_22_813 VPWR VGND VPWR VGND sky130_ef_sc_hd__decap_40_12
XANTENNA__4633__A _4663_/A VGND VGND VPWR VPWR sky130_fd_sc_hd__diode_2
X_4815_ _5094_/A1 _4676_/A _4800_/X _4815_/B2 VGND VGND VPWR VPWR _4815_/X sky130_fd_sc_hd__a22o_1
XANTENNA__5210__A1 _5210_/A1 VGND VGND VPWR VPWR sky130_fd_sc_hd__diode_2
X_5795_ _6125_/CLK _5795_/D VGND VGND VPWR VPWR _5795_/Q sky130_fd_sc_hd__dfxtp_1
XFILLER_119_255 VGND VGND VPWR VPWR sky130_fd_sc_hd__fill_1
X_4746_ _6087_/Q _5885_/Q _4803_/S VGND VGND VPWR VPWR _4746_/X sky130_fd_sc_hd__mux2_1
X_4677_ _4677_/A1 _4676_/A _4661_/X _4676_/Y VGND VGND VPWR VPWR _4677_/X sky130_fd_sc_hd__a22o_1
X_3628_ _4955_/B _3648_/B VGND VGND VPWR VPWR _3637_/S sky130_fd_sc_hd__nor2_4
X_6416_ _6417_/CLK _6416_/D VGND VGND VPWR VPWR _6416_/Q sky130_fd_sc_hd__dfxtp_2
Xoutput39 _6063_/Q VGND VGND VPWR VPWR s_axil_rdata[10] sky130_fd_sc_hd__buf_2
XTAP_TAPCELL_ROW_73_1401 VGND VPWR sky130_fd_sc_hd__tapvpwrvgnd_1
X_6347_ _6347_/CLK _6347_/D VGND VGND VPWR VPWR _6347_/Q sky130_fd_sc_hd__dfxtp_1
XFILLER_88_301 VGND VGND VPWR VPWR sky130_fd_sc_hd__fill_1
X_3559_ _4488_/A0 _3559_/A1 _3562_/S VGND VGND VPWR VPWR _5598_/D sky130_fd_sc_hd__mux2_1
XFILLER_0_227 VGND VGND VPWR VPWR sky130_fd_sc_hd__fill_1
X_6278_ _6300_/CLK _6278_/D VGND VGND VPWR VPWR _6278_/Q sky130_fd_sc_hd__dfxtp_1
X_5229_ _5241_/A1 _5229_/A1 _5237_/S VGND VGND VPWR VPWR _6426_/D sky130_fd_sc_hd__mux2_1
Xhold1720 _3431_/X VGND VGND VPWR VPWR _5482_/D sky130_fd_sc_hd__dlygate4sd3_1
XFILLER_76_518 VGND VGND VPWR VPWR sky130_fd_sc_hd__fill_1
XFILLER_57_721 VGND VGND VPWR VPWR sky130_fd_sc_hd__fill_1
Xhold1742 _5564_/Q VGND VGND VPWR VPWR _3521_/A1 sky130_fd_sc_hd__dlygate4sd3_1
Xhold1753 _6090_/Q VGND VGND VPWR VPWR _4484_/A1 sky130_fd_sc_hd__dlygate4sd3_1
Xhold1731 _6288_/Q VGND VGND VPWR VPWR _4953_/A1 sky130_fd_sc_hd__dlygate4sd3_1
Xhold1775 _3549_/X VGND VGND VPWR VPWR _5590_/D sky130_fd_sc_hd__dlygate4sd3_1
XFILLER_56_253 VGND VGND VPWR VPWR sky130_fd_sc_hd__fill_4
XFILLER_56_58 VGND VGND VPWR VPWR sky130_fd_sc_hd__fill_1
Xhold1786 _6030_/Q VGND VGND VPWR VPWR _4391_/A1 sky130_fd_sc_hd__dlygate4sd3_1
XFILLER_17_629 VPWR VGND VPWR VGND sky130_ef_sc_hd__decap_40_12
Xhold1764 _5696_/Q VGND VGND VPWR VPWR _3673_/A1 sky130_fd_sc_hd__dlygate4sd3_1
Xhold1797 _3664_/X VGND VGND VPWR VPWR _5689_/D sky130_fd_sc_hd__dlygate4sd3_1
XFILLER_71_223 VGND VGND VPWR VPWR sky130_fd_sc_hd__fill_1
XFILLER_16_139 VGND VGND VPWR VPWR sky130_fd_sc_hd__fill_1
XFILLER_112_75 VGND VGND VPWR VPWR sky130_fd_sc_hd__fill_1
XFILLER_25_651 VGND VGND VPWR VPWR sky130_fd_sc_hd__fill_1
XTAP_TAPCELL_ROW_84_1563 VGND VPWR sky130_fd_sc_hd__tapvpwrvgnd_1
XFILLER_40_643 VGND VGND VPWR VPWR sky130_fd_sc_hd__fill_1
XANTENNA__3212__A0 _5241_/A1 VGND VGND VPWR VPWR sky130_fd_sc_hd__diode_2
XPHY_EDGE_ROW_117_Right_117 VGND VGND VPWR VPWR sky130_fd_sc_hd__decap_3
XFILLER_9_839 VGND VGND VPWR VPWR sky130_fd_sc_hd__fill_1
XFILLER_138_531 VGND VGND VPWR VPWR sky130_fd_sc_hd__fill_1
XFILLER_12_389 VPWR VGND VPWR VGND sky130_ef_sc_hd__decap_40_12
XFILLER_126_737 VPWR VGND VPWR VGND sky130_ef_sc_hd__decap_40_12
XANTENNA__2998__A _3085_/A VGND VGND VPWR VPWR sky130_fd_sc_hd__diode_2
XANTENNA__3593__S _3595_/S VGND VGND VPWR VPWR sky130_fd_sc_hd__diode_2
XANTENNA__4960__A0 _5212_/A1 VGND VGND VPWR VPWR sky130_fd_sc_hd__diode_2
XANTENNA__3763__A1 _4981_/A1 VGND VGND VPWR VPWR sky130_fd_sc_hd__diode_2
XFILLER_4_533 VPWR VGND VPWR VGND sky130_ef_sc_hd__decap_40_12
XFILLER_134_781 VPWR VGND VPWR VGND sky130_ef_sc_hd__decap_40_12
XFILLER_79_345 VGND VGND VPWR VPWR sky130_fd_sc_hd__fill_4
XFILLER_67_507 VGND VGND VPWR VPWR sky130_fd_sc_hd__fill_1
XFILLER_48_710 VGND VGND VPWR VPWR sky130_fd_sc_hd__fill_4
XFILLER_0_783 VGND VGND VPWR VPWR sky130_fd_sc_hd__fill_1
XANTENNA__4718__A _4802_/A VGND VGND VPWR VPWR sky130_fd_sc_hd__diode_2
XFILLER_75_540 VGND VGND VPWR VPWR sky130_fd_sc_hd__fill_1
XTAP_TAPCELL_ROW_126_2191 VGND VPWR sky130_fd_sc_hd__tapvpwrvgnd_1
XFILLER_75_584 VGND VGND VPWR VPWR sky130_fd_sc_hd__fill_2
XANTENNA_clkload2_A clkload2/A VGND VGND VPWR VPWR sky130_fd_sc_hd__diode_2
XFILLER_63_779 VGND VGND VPWR VPWR sky130_fd_sc_hd__fill_4
X_2930_ _3052_/A1 _2929_/X _3075_/C1 VGND VGND VPWR VPWR _2930_/X sky130_fd_sc_hd__o21a_1
XANTENNA__2672__S _5241_/S VGND VGND VPWR VPWR sky130_fd_sc_hd__diode_2
XFILLER_90_587 VGND VGND VPWR VPWR sky130_fd_sc_hd__fill_1
XTAP_TAPCELL_ROW_46_988 VGND VPWR sky130_fd_sc_hd__tapvpwrvgnd_1
XFILLER_43_470 VGND VGND VPWR VPWR sky130_fd_sc_hd__fill_1
XTAP_TAPCELL_ROW_26_690 VGND VPWR sky130_fd_sc_hd__tapvpwrvgnd_1
X_2861_ _3050_/A _2861_/B VGND VGND VPWR VPWR _2861_/X sky130_fd_sc_hd__or2_1
X_4600_ _4600_/A _4600_/B VGND VGND VPWR VPWR _4600_/X sky130_fd_sc_hd__or2_1
XFILLER_30_153 VGND VGND VPWR VPWR sky130_fd_sc_hd__fill_2
X_2792_ _3036_/A1 _2791_/X _3076_/A1 VGND VGND VPWR VPWR _2792_/X sky130_fd_sc_hd__o21a_1
XFILLER_129_553 VGND VGND VPWR VPWR sky130_fd_sc_hd__fill_4
X_5580_ _6399_/CLK _5580_/D VGND VGND VPWR VPWR _5580_/Q sky130_fd_sc_hd__dfxtp_1
X_4531_ hold795/X _5233_/A0 _4535_/S VGND VGND VPWR VPWR _4531_/X sky130_fd_sc_hd__mux2_1
XPHY_EDGE_ROW_68_Left_207 VGND VGND VPWR VPWR sky130_fd_sc_hd__decap_3
XANTENNA__4599__S _4803_/S VGND VGND VPWR VPWR sky130_fd_sc_hd__diode_2
XANTENNA__4951__A0 _4981_/A1 VGND VGND VPWR VPWR sky130_fd_sc_hd__diode_2
XFILLER_129_597 VPWR VGND VPWR VGND sky130_ef_sc_hd__decap_40_12
X_4462_ _5239_/A1 hold641/X _4472_/S VGND VGND VPWR VPWR _4462_/X sky130_fd_sc_hd__mux2_1
Xhold316 _3121_/X VGND VGND VPWR VPWR _5314_/D sky130_fd_sc_hd__dlygate4sd3_1
XFILLER_7_393 VPWR VGND VPWR VGND sky130_ef_sc_hd__decap_40_12
Xhold305 _6085_/Q VGND VGND VPWR VPWR hold305/X sky130_fd_sc_hd__dlygate4sd3_1
XANTENNA__2701__A _4272_/S VGND VGND VPWR VPWR sky130_fd_sc_hd__diode_2
Xhold327 _5310_/Q VGND VGND VPWR VPWR hold327/X sky130_fd_sc_hd__dlygate4sd3_1
Xhold338 _3480_/X VGND VGND VPWR VPWR _5526_/D sky130_fd_sc_hd__dlygate4sd3_1
XFILLER_89_109 VGND VGND VPWR VPWR sky130_fd_sc_hd__fill_2
X_6201_ _6380_/CLK _6201_/D VGND VGND VPWR VPWR _6201_/Q sky130_fd_sc_hd__dfxtp_1
X_3413_ _5382_/Q _5381_/Q _3553_/C VGND VGND VPWR VPWR _4493_/B sky130_fd_sc_hd__or3_4
Xhold349 _6308_/Q VGND VGND VPWR VPWR hold349/X sky130_fd_sc_hd__dlygate4sd3_1
XFILLER_125_781 VGND VGND VPWR VPWR sky130_fd_sc_hd__fill_2
XTAP_TAPCELL_ROW_55_1131 VGND VPWR sky130_fd_sc_hd__tapvpwrvgnd_1
XTAP_TAPCELL_ROW_55_1120 VGND VPWR sky130_fd_sc_hd__tapvpwrvgnd_1
X_4393_ _4981_/A1 _4393_/A1 _4396_/S VGND VGND VPWR VPWR _4393_/X sky130_fd_sc_hd__mux2_1
XFILLER_98_643 VGND VGND VPWR VPWR sky130_fd_sc_hd__fill_1
XFILLER_86_805 VGND VGND VPWR VPWR sky130_fd_sc_hd__fill_4
X_6132_ _6402_/CLK _6132_/D VGND VGND VPWR VPWR _6132_/Q sky130_fd_sc_hd__dfxtp_1
X_3344_ _3964_/B _5216_/A VGND VGND VPWR VPWR _3346_/C sky130_fd_sc_hd__nand2_1
X_6063_ _6248_/CLK _6063_/D VGND VGND VPWR VPWR _6063_/Q sky130_fd_sc_hd__dfxtp_1
Xhold1005 _6248_/Q VGND VGND VPWR VPWR _4900_/A1 sky130_fd_sc_hd__dlygate4sd3_1
XFILLER_112_475 VGND VGND VPWR VPWR sky130_fd_sc_hd__fill_1
XANTENNA__2847__S _2963_/S VGND VGND VPWR VPWR sky130_fd_sc_hd__diode_2
X_3275_ _4813_/S _3278_/C VGND VGND VPWR VPWR _3276_/B sky130_fd_sc_hd__and2_1
Xhold1038 _5249_/Q VGND VGND VPWR VPWR _2676_/A0 sky130_fd_sc_hd__dlygate4sd3_1
XFILLER_100_637 VGND VGND VPWR VPWR sky130_fd_sc_hd__fill_4
Xhold1049 _4847_/X VGND VGND VPWR VPWR _6199_/D sky130_fd_sc_hd__dlygate4sd3_1
Xhold1016 _5992_/Q VGND VGND VPWR VPWR _4349_/A0 sky130_fd_sc_hd__dlygate4sd3_1
Xhold1027 _4286_/X VGND VGND VPWR VPWR _5937_/D sky130_fd_sc_hd__dlygate4sd3_1
X_5014_ _5431_/Q _6327_/Q _6328_/Q _5432_/Q VGND VGND VPWR VPWR _5015_/B sky130_fd_sc_hd__o22ai_1
XPHY_EDGE_ROW_77_Left_216 VGND VGND VPWR VPWR sky130_fd_sc_hd__decap_3
XFILLER_66_562 VGND VGND VPWR VPWR sky130_fd_sc_hd__fill_1
XFILLER_54_724 VGND VGND VPWR VPWR sky130_fd_sc_hd__fill_4
XFILLER_26_17 VGND VGND VPWR VPWR sky130_fd_sc_hd__fill_1
XFILLER_81_543 VGND VGND VPWR VPWR sky130_fd_sc_hd__fill_1
XFILLER_53_289 VGND VGND VPWR VPWR sky130_fd_sc_hd__fill_1
X_5916_ _6421_/CLK _5916_/D VGND VGND VPWR VPWR _5916_/Q sky130_fd_sc_hd__dfxtp_2
XTAP_TAPCELL_ROW_66_1293 VGND VPWR sky130_fd_sc_hd__tapvpwrvgnd_1
XFILLER_22_643 VGND VGND VPWR VPWR sky130_fd_sc_hd__fill_1
X_5847_ _6097_/CLK _5847_/D VGND VGND VPWR VPWR _5847_/Q sky130_fd_sc_hd__dfxtp_1
XFILLER_42_27 VGND VGND VPWR VPWR sky130_fd_sc_hd__fill_1
XFILLER_10_805 VGND VGND VPWR VPWR sky130_fd_sc_hd__fill_4
XPHY_EDGE_ROW_86_Left_225 VGND VGND VPWR VPWR sky130_fd_sc_hd__decap_3
XFILLER_6_809 VGND VGND VPWR VPWR sky130_fd_sc_hd__fill_2
X_5778_ _5908_/CLK _5778_/D VGND VGND VPWR VPWR _5778_/Q sky130_fd_sc_hd__dfxtp_1
XANTENNA__3745__A1 _5237_/A0 VGND VGND VPWR VPWR sky130_fd_sc_hd__diode_2
X_4729_ hold987/X _4728_/X _4786_/S VGND VGND VPWR VPWR _4729_/X sky130_fd_sc_hd__mux2_1
XANTENNA__4942__A0 _5045_/A1 VGND VGND VPWR VPWR sky130_fd_sc_hd__diode_2
XFILLER_108_737 VPWR VGND VPWR VGND sky130_ef_sc_hd__decap_40_12
Xclkbuf_leaf_110_clk clkload0/A VGND VGND VPWR VPWR _5731_/CLK sky130_fd_sc_hd__clkbuf_8
XFILLER_123_729 VPWR VGND VPWR VGND sky130_ef_sc_hd__decap_40_12
XFILLER_122_217 VGND VGND VPWR VPWR sky130_fd_sc_hd__fill_1
XFILLER_116_781 VPWR VGND VPWR VGND sky130_ef_sc_hd__decap_40_12
Xhold861 _5351_/Q VGND VGND VPWR VPWR hold861/X sky130_fd_sc_hd__dlygate4sd3_1
XFILLER_89_610 VGND VGND VPWR VPWR sky130_fd_sc_hd__fill_2
Xhold850 _2750_/X VGND VGND VPWR VPWR _5280_/D sky130_fd_sc_hd__dlygate4sd3_1
Xhold872 _5059_/X VGND VGND VPWR VPWR _6352_/D sky130_fd_sc_hd__dlygate4sd3_1
XFILLER_1_503 VGND VGND VPWR VPWR sky130_fd_sc_hd__fill_1
Xhold894 _5368_/Q VGND VGND VPWR VPWR hold894/X sky130_fd_sc_hd__dlygate4sd3_1
Xhold883 _4874_/X VGND VGND VPWR VPWR _6224_/D sky130_fd_sc_hd__dlygate4sd3_1
XANTENNA_fanout87_A _6412_/Q VGND VGND VPWR VPWR sky130_fd_sc_hd__diode_2
XANTENNA__2757__S _3016_/S VGND VGND VPWR VPWR sky130_fd_sc_hd__diode_2
XFILLER_88_164 VGND VGND VPWR VPWR sky130_fd_sc_hd__fill_1
XPHY_EDGE_ROW_95_Left_234 VGND VGND VPWR VPWR sky130_fd_sc_hd__decap_3
XANTENNA__4458__C1 _3801_/B VGND VGND VPWR VPWR sky130_fd_sc_hd__diode_2
Xhold2240 _5342_/Q VGND VGND VPWR VPWR hold2240/X sky130_fd_sc_hd__dlygate4sd3_1
Xhold2251 _5320_/Q VGND VGND VPWR VPWR _2706_/B sky130_fd_sc_hd__dlygate4sd3_1
Xhold1550 _3667_/X VGND VGND VPWR VPWR _5692_/D sky130_fd_sc_hd__dlygate4sd3_1
Xhold1561 _6292_/Q VGND VGND VPWR VPWR _4958_/A1 sky130_fd_sc_hd__dlygate4sd3_1
XTAP_TAPCELL_ROW_4_363 VGND VPWR sky130_fd_sc_hd__tapvpwrvgnd_1
Xhold1594 _6293_/Q VGND VGND VPWR VPWR _4959_/A1 sky130_fd_sc_hd__dlygate4sd3_1
Xhold1572 _5872_/Q VGND VGND VPWR VPWR _3893_/A0 sky130_fd_sc_hd__dlygate4sd3_1
XANTENNA__3681__A0 _6411_/Q VGND VGND VPWR VPWR sky130_fd_sc_hd__diode_2
Xhold1583 _5460_/Q VGND VGND VPWR VPWR _4048_/A1 sky130_fd_sc_hd__dlygate4sd3_1
XANTENNA__4972__S _4974_/S VGND VGND VPWR VPWR sky130_fd_sc_hd__diode_2
XFILLER_83_89 VGND VGND VPWR VPWR sky130_fd_sc_hd__fill_1
XANTENNA__3588__S _3595_/S VGND VGND VPWR VPWR sky130_fd_sc_hd__diode_2
XFILLER_32_418 VGND VGND VPWR VPWR sky130_fd_sc_hd__fill_2
XFILLER_32_429 VGND VGND VPWR VPWR sky130_fd_sc_hd__fill_2
XTAP_TAPCELL_ROW_43_947 VGND VPWR sky130_fd_sc_hd__tapvpwrvgnd_1
XFILLER_13_665 VGND VGND VPWR VPWR sky130_fd_sc_hd__fill_4
XFILLER_9_669 VGND VGND VPWR VPWR sky130_fd_sc_hd__fill_2
XFILLER_126_501 VPWR VGND VPWR VGND sky130_ef_sc_hd__decap_40_12
XANTENNA__3736__A1 _5228_/A0 VGND VGND VPWR VPWR sky130_fd_sc_hd__diode_2
XFILLER_32_71 VGND VGND VPWR VPWR sky130_fd_sc_hd__fill_1
XFILLER_126_545 VPWR VGND VPWR VGND sky130_ef_sc_hd__decap_40_12
XTAP_TAPCELL_ROW_97_1754 VGND VPWR sky130_fd_sc_hd__tapvpwrvgnd_1
XANTENNA__2944__C1 _3089_/C1 VGND VGND VPWR VPWR sky130_fd_sc_hd__diode_2
Xclkbuf_leaf_101_clk clkload0/A VGND VGND VPWR VPWR _6068_/CLK sky130_fd_sc_hd__clkbuf_8
XFILLER_126_589 VPWR VGND VPWR VGND sky130_ef_sc_hd__decap_40_12
XFILLER_107_781 VGND VGND VPWR VPWR sky130_fd_sc_hd__fill_2
XFILLER_99_429 VGND VGND VPWR VPWR sky130_fd_sc_hd__fill_1
XFILLER_4_363 VGND VGND VPWR VPWR sky130_fd_sc_hd__fill_1
XANTENNA__4161__A1 _4272_/S VGND VGND VPWR VPWR sky130_fd_sc_hd__diode_2
XTAP_TAPCELL_ROW_128_2220 VGND VPWR sky130_fd_sc_hd__tapvpwrvgnd_1
XFILLER_121_250 VGND VGND VPWR VPWR sky130_fd_sc_hd__fill_1
XFILLER_95_613 VGND VGND VPWR VPWR sky130_fd_sc_hd__fill_2
XFILLER_79_164 VGND VGND VPWR VPWR sky130_fd_sc_hd__fill_4
X_3060_ _3085_/A _3055_/X _3058_/X _3059_/X VGND VGND VPWR VPWR _3060_/X sky130_fd_sc_hd__a22o_1
XFILLER_67_337 VPWR VGND VPWR VGND sky130_ef_sc_hd__decap_40_12
XFILLER_94_145 VGND VGND VPWR VPWR sky130_fd_sc_hd__fill_1
XTAP_TAPCELL_ROW_50_1050 VGND VPWR sky130_fd_sc_hd__tapvpwrvgnd_1
XANTENNA__4882__S _4893_/S VGND VGND VPWR VPWR sky130_fd_sc_hd__diode_2
XFILLER_63_521 VGND VGND VPWR VPWR sky130_fd_sc_hd__fill_1
XANTENNA__3672__A0 _4958_/A0 VGND VGND VPWR VPWR sky130_fd_sc_hd__diode_2
XFILLER_91_841 VGND VGND VPWR VPWR sky130_fd_sc_hd__fill_1
XFILLER_35_223 VGND VGND VPWR VPWR sky130_fd_sc_hd__fill_1
XANTENNA__3498__S _3503_/S VGND VGND VPWR VPWR sky130_fd_sc_hd__diode_2
XFILLER_90_384 VGND VGND VPWR VPWR sky130_fd_sc_hd__fill_1
XFILLER_63_576 VGND VGND VPWR VPWR sky130_fd_sc_hd__fill_4
XFILLER_23_429 VPWR VGND VPWR VGND sky130_ef_sc_hd__decap_40_12
XANTENNA__4183__A _4241_/A VGND VGND VPWR VPWR sky130_fd_sc_hd__diode_2
XFILLER_35_289 VGND VGND VPWR VPWR sky130_fd_sc_hd__fill_1
XTAP_TAPCELL_ROW_106_1894 VGND VPWR sky130_fd_sc_hd__tapvpwrvgnd_1
XTAP_TAPCELL_ROW_106_1883 VGND VPWR sky130_fd_sc_hd__tapvpwrvgnd_1
X_3962_ _6329_/Q _5006_/A _6327_/Q _5000_/B VGND VGND VPWR VPWR _3962_/Y sky130_fd_sc_hd__nor4_2
X_5701_ _6120_/CLK _5701_/D VGND VGND VPWR VPWR _5701_/Q sky130_fd_sc_hd__dfxtp_1
X_2913_ _2985_/A _2913_/B VGND VGND VPWR VPWR _2913_/X sky130_fd_sc_hd__or2_1
X_3893_ _3893_/A0 _5210_/A1 _3899_/S VGND VGND VPWR VPWR _3893_/X sky130_fd_sc_hd__mux2_1
XTAP_TAPCELL_ROW_21_608 VGND VPWR sky130_fd_sc_hd__tapvpwrvgnd_1
XTAP_TAPCELL_ROW_21_619 VGND VPWR sky130_fd_sc_hd__tapvpwrvgnd_1
X_2844_ _6186_/Q _5480_/Q _3091_/S VGND VGND VPWR VPWR _2844_/X sky130_fd_sc_hd__mux2_1
X_5632_ _6290_/CLK _5632_/D VGND VGND VPWR VPWR _5632_/Q sky130_fd_sc_hd__dfxtp_1
X_5563_ _6437_/CLK _5563_/D VGND VGND VPWR VPWR _5563_/Q sky130_fd_sc_hd__dfxtp_1
XANTENNA__3727__A1 _4983_/A1 VGND VGND VPWR VPWR sky130_fd_sc_hd__diode_2
XFILLER_12_19 VGND VGND VPWR VPWR sky130_fd_sc_hd__fill_1
XFILLER_129_383 VGND VGND VPWR VPWR sky130_fd_sc_hd__fill_1
X_2775_ _3005_/A _2775_/B VGND VGND VPWR VPWR _2775_/Y sky130_fd_sc_hd__nor2_1
XANTENNA__4122__S _4262_/S VGND VGND VPWR VPWR sky130_fd_sc_hd__diode_2
X_4514_ hold643/X _5208_/A1 _4522_/S VGND VGND VPWR VPWR _4514_/X sky130_fd_sc_hd__mux2_1
X_5494_ _5753_/CLK _5494_/D VGND VGND VPWR VPWR _5494_/Q sky130_fd_sc_hd__dfxtp_1
Xhold102 _3608_/X VGND VGND VPWR VPWR _5639_/D sky130_fd_sc_hd__dlygate4sd3_1
Xhold124 _4323_/X VGND VGND VPWR VPWR _5970_/D sky130_fd_sc_hd__dlygate4sd3_1
Xhold135 _5674_/Q VGND VGND VPWR VPWR hold135/X sky130_fd_sc_hd__dlygate4sd3_1
Xhold113 _5665_/Q VGND VGND VPWR VPWR hold113/X sky130_fd_sc_hd__dlygate4sd3_1
Xhold168 _4884_/X VGND VGND VPWR VPWR _6233_/D sky130_fd_sc_hd__dlygate4sd3_1
XFILLER_105_729 VPWR VGND VPWR VGND sky130_ef_sc_hd__decap_40_12
Xhold146 _3736_/X VGND VGND VPWR VPWR _5750_/D sky130_fd_sc_hd__dlygate4sd3_1
X_4445_ _4445_/A _4445_/B VGND VGND VPWR VPWR _4445_/X sky130_fd_sc_hd__and2_1
Xhold157 _5946_/Q VGND VGND VPWR VPWR hold157/X sky130_fd_sc_hd__dlygate4sd3_1
X_4376_ _5047_/A1 _4376_/A1 _4376_/S VGND VGND VPWR VPWR _4376_/X sky130_fd_sc_hd__mux2_1
Xhold179 _5953_/Q VGND VGND VPWR VPWR hold179/X sky130_fd_sc_hd__dlygate4sd3_1
X_3327_ _4002_/A _4002_/B _5329_/Q VGND VGND VPWR VPWR _3327_/Y sky130_fd_sc_hd__o21bai_2
X_6115_ _6125_/CLK _6115_/D VGND VGND VPWR VPWR _6115_/Q sky130_fd_sc_hd__dfxtp_1
XANTENNA__4455__A2 _4457_/S VGND VGND VPWR VPWR sky130_fd_sc_hd__diode_2
X_6046_ _6345_/CLK _6046_/D VGND VGND VPWR VPWR _6046_/Q sky130_fd_sc_hd__dfxtp_1
X_3258_ hold946/X _5926_/Q _3258_/S VGND VGND VPWR VPWR _3258_/X sky130_fd_sc_hd__mux2_1
XFILLER_37_38 VGND VGND VPWR VPWR sky130_fd_sc_hd__fill_1
X_3189_ hold880/X _5233_/A0 _3193_/S VGND VGND VPWR VPWR _3189_/X sky130_fd_sc_hd__mux2_1
XANTENNA_fanout177_X _3085_/A VGND VGND VPWR VPWR sky130_fd_sc_hd__diode_2
XTAP_TAPCELL_ROW_68_1322 VGND VPWR sky130_fd_sc_hd__tapvpwrvgnd_1
XFILLER_66_381 VGND VGND VPWR VPWR sky130_fd_sc_hd__fill_1
XANTENNA__3663__A0 _4488_/A0 VGND VGND VPWR VPWR sky130_fd_sc_hd__diode_2
XTAP_TAPCELL_ROW_1_311 VGND VPWR sky130_fd_sc_hd__tapvpwrvgnd_1
XTAP_TAPCELL_ROW_1_322 VGND VPWR sky130_fd_sc_hd__tapvpwrvgnd_1
XFILLER_82_841 VGND VGND VPWR VPWR sky130_fd_sc_hd__fill_1
XANTENNA_clkbuf_leaf_54_clk_A clkload6/A VGND VGND VPWR VPWR sky130_fd_sc_hd__diode_2
XFILLER_54_587 VGND VGND VPWR VPWR sky130_fd_sc_hd__fill_1
XFILLER_42_738 VGND VGND VPWR VPWR sky130_fd_sc_hd__fill_1
XTAP_TAPCELL_ROW_81_1522 VGND VPWR sky130_fd_sc_hd__tapvpwrvgnd_1
XTAP_TAPCELL_ROW_81_1511 VGND VPWR sky130_fd_sc_hd__tapvpwrvgnd_1
XTAP_TAPCELL_ROW_40_906 VGND VPWR sky130_fd_sc_hd__tapvpwrvgnd_1
XANTENNA_clkbuf_leaf_69_clk_A clkload5/A VGND VGND VPWR VPWR sky130_fd_sc_hd__diode_2
XFILLER_50_793 VPWR VGND VPWR VGND sky130_ef_sc_hd__decap_40_12
XFILLER_10_613 VPWR VGND VPWR VGND sky130_ef_sc_hd__decap_40_12
XFILLER_22_473 VGND VGND VPWR VPWR sky130_fd_sc_hd__fill_2
XFILLER_10_657 VPWR VGND VPWR VGND sky130_ef_sc_hd__decap_40_12
XFILLER_5_127 VGND VGND VPWR VPWR sky130_fd_sc_hd__fill_1
XFILLER_118_41 VGND VGND VPWR VPWR sky130_fd_sc_hd__fill_1
XFILLER_108_545 VPWR VGND VPWR VGND sky130_ef_sc_hd__decap_40_12
XTAP_TAPCELL_ROW_79_1484 VGND VPWR sky130_fd_sc_hd__tapvpwrvgnd_1
XFILLER_108_589 VPWR VGND VPWR VGND sky130_ef_sc_hd__decap_40_12
XTAP_TAPCELL_ROW_9_433 VGND VPWR sky130_fd_sc_hd__tapvpwrvgnd_1
XANTENNA__4967__S _4974_/S VGND VGND VPWR VPWR sky130_fd_sc_hd__diode_2
Xhold680 _5241_/X VGND VGND VPWR VPWR _6438_/D sky130_fd_sc_hd__dlygate4sd3_1
XFILLER_123_559 VGND VGND VPWR VPWR sky130_fd_sc_hd__fill_1
XFILLER_118_85 VGND VGND VPWR VPWR sky130_fd_sc_hd__fill_1
XTAP_TAPCELL_ROW_92_1673 VGND VPWR sky130_fd_sc_hd__tapvpwrvgnd_1
XANTENNA__4143__A1 _4252_/A1 VGND VGND VPWR VPWR sky130_fd_sc_hd__diode_2
XTAP_TAPCELL_ROW_92_1684 VGND VPWR sky130_fd_sc_hd__tapvpwrvgnd_1
Xhold691 _3693_/X VGND VGND VPWR VPWR _5714_/D sky130_fd_sc_hd__dlygate4sd3_1
XANTENNA__3172__A _4272_/S VGND VGND VPWR VPWR sky130_fd_sc_hd__diode_2
XANTENNA__4446__A2 _3366_/X VGND VGND VPWR VPWR sky130_fd_sc_hd__diode_2
Xhold2070 _6356_/Q VGND VGND VPWR VPWR _5064_/A1 sky130_fd_sc_hd__dlygate4sd3_1
Xhold2081 _6328_/Q VGND VGND VPWR VPWR _5000_/B sky130_fd_sc_hd__dlygate4sd3_1
Xhold2092 _3127_/Y VGND VGND VPWR VPWR _3129_/B sky130_fd_sc_hd__dlygate4sd3_1
XFILLER_18_713 VPWR VGND VPWR VGND sky130_ef_sc_hd__decap_40_12
Xhold1380 _4896_/X VGND VGND VPWR VPWR _6244_/D sky130_fd_sc_hd__dlygate4sd3_1
XTAP_TAPCELL_ROW_123_2150 VGND VPWR sky130_fd_sc_hd__tapvpwrvgnd_1
XFILLER_91_148 VGND VGND VPWR VPWR sky130_fd_sc_hd__fill_1
XFILLER_73_841 VGND VGND VPWR VPWR sky130_fd_sc_hd__fill_1
Xhold1391 _2868_/X VGND VGND VPWR VPWR _5287_/D sky130_fd_sc_hd__dlygate4sd3_1
XFILLER_45_543 VGND VGND VPWR VPWR sky130_fd_sc_hd__fill_1
XFILLER_18_757 VPWR VGND VPWR VGND sky130_ef_sc_hd__decap_40_12
XFILLER_45_565 VGND VGND VPWR VPWR sky130_fd_sc_hd__fill_1
XANTENNA__3406__A0 _4978_/A1 VGND VGND VPWR VPWR sky130_fd_sc_hd__diode_2
XFILLER_17_256 VGND VGND VPWR VPWR sky130_fd_sc_hd__fill_4
XFILLER_33_716 VGND VGND VPWR VPWR sky130_fd_sc_hd__fill_1
XFILLER_33_727 VGND VGND VPWR VPWR sky130_fd_sc_hd__fill_1
XFILLER_17_289 VGND VGND VPWR VPWR sky130_fd_sc_hd__fill_1
XFILLER_43_81 VGND VGND VPWR VPWR sky130_fd_sc_hd__fill_1
XFILLER_13_473 VPWR VGND VPWR VGND sky130_ef_sc_hd__decap_40_12
XFILLER_41_782 VGND VGND VPWR VPWR sky130_fd_sc_hd__fill_2
XANTENNA__4906__A0 _4906_/A0 VGND VGND VPWR VPWR sky130_fd_sc_hd__diode_2
XANTENNA__3709__A1 _4976_/A1 VGND VGND VPWR VPWR sky130_fd_sc_hd__diode_2
XFILLER_127_821 VPWR VGND VPWR VGND sky130_ef_sc_hd__decap_40_12
XANTENNA__4382__A1 _4980_/A1 VGND VGND VPWR VPWR sky130_fd_sc_hd__diode_2
XANTENNA__4877__S _4880_/S VGND VGND VPWR VPWR sky130_fd_sc_hd__diode_2
XFILLER_99_248 VGND VGND VPWR VPWR sky130_fd_sc_hd__fill_2
X_4230_ _5989_/Q _5980_/Q _5971_/Q _5962_/Q _4262_/S _4263_/A VGND VGND VPWR VPWR
+ _4230_/X sky130_fd_sc_hd__mux4_1
X_4161_ _4272_/S _4160_/X _4154_/Y _5343_/Q VGND VGND VPWR VPWR _4162_/B sky130_fd_sc_hd__o211a_1
XFILLER_4_53 VPWR VGND VPWR VGND sky130_ef_sc_hd__decap_40_12
XFILLER_122_581 VGND VGND VPWR VPWR sky130_fd_sc_hd__fill_4
XFILLER_67_123 VGND VGND VPWR VPWR sky130_fd_sc_hd__fill_1
XANTENNA_hold2221_A _5830_/Q VGND VGND VPWR VPWR sky130_fd_sc_hd__diode_2
XANTENNA__4178__A _4178_/A VGND VGND VPWR VPWR sky130_fd_sc_hd__diode_2
X_3112_ hold91/X _5237_/A0 _3112_/S VGND VGND VPWR VPWR hold92/A sky130_fd_sc_hd__mux2_1
XANTENNA__4437__A2 _4457_/S VGND VGND VPWR VPWR sky130_fd_sc_hd__diode_2
X_4092_ _5948_/Q _6336_/Q _4228_/S VGND VGND VPWR VPWR _4092_/X sky130_fd_sc_hd__mux2_1
X_3043_ _6079_/Q _6371_/Q _3072_/S VGND VGND VPWR VPWR _3044_/B sky130_fd_sc_hd__mux2_1
XTAP_TAPCELL_ROW_108_1923 VGND VPWR sky130_fd_sc_hd__tapvpwrvgnd_1
XFILLER_91_671 VGND VGND VPWR VPWR sky130_fd_sc_hd__fill_1
XFILLER_36_587 VGND VGND VPWR VPWR sky130_fd_sc_hd__fill_1
XANTENNA__3021__S _3077_/S VGND VGND VPWR VPWR sky130_fd_sc_hd__diode_2
X_4994_ _4994_/A _4994_/B _5808_/D VGND VGND VPWR VPWR _6326_/D sky130_fd_sc_hd__and3_1
XFILLER_63_384 VGND VGND VPWR VPWR sky130_fd_sc_hd__fill_2
X_3945_ _3945_/A _5142_/A _5142_/B _3945_/D VGND VGND VPWR VPWR _5162_/B sky130_fd_sc_hd__or4_2
XTAP_TAPCELL_ROW_63_1252 VGND VPWR sky130_fd_sc_hd__tapvpwrvgnd_1
XTAP_TAPCELL_ROW_63_1241 VGND VPWR sky130_fd_sc_hd__tapvpwrvgnd_1
XFILLER_51_557 VGND VGND VPWR VPWR sky130_fd_sc_hd__fill_2
XFILLER_32_793 VPWR VGND VPWR VGND sky130_ef_sc_hd__decap_40_12
XFILLER_137_629 VPWR VGND VPWR VGND sky130_ef_sc_hd__decap_40_12
X_5615_ _6298_/CLK hold48/X VGND VGND VPWR VPWR hold47/A sky130_fd_sc_hd__dfxtp_1
X_3876_ _6415_/Q _3876_/A1 _3879_/S VGND VGND VPWR VPWR _3876_/X sky130_fd_sc_hd__mux2_1
XANTENNA__4048__S1 _4251_/A VGND VGND VPWR VPWR sky130_fd_sc_hd__diode_2
XFILLER_31_281 VGND VGND VPWR VPWR sky130_fd_sc_hd__fill_4
XFILLER_136_139 VGND VGND VPWR VPWR sky130_fd_sc_hd__fill_1
X_2827_ _6128_/Q _5551_/Q _2984_/S VGND VGND VPWR VPWR _2828_/B sky130_fd_sc_hd__mux2_1
X_5546_ _5571_/CLK _5546_/D VGND VGND VPWR VPWR _5546_/Q sky130_fd_sc_hd__dfxtp_1
X_2758_ _3052_/A1 _2757_/X _3075_/C1 VGND VGND VPWR VPWR _2758_/X sky130_fd_sc_hd__o21a_1
XFILLER_3_609 VGND VGND VPWR VPWR sky130_fd_sc_hd__fill_4
X_5477_ _6239_/CLK _5477_/D VGND VGND VPWR VPWR _5477_/Q sky130_fd_sc_hd__dfxtp_1
XANTENNA__3691__S _3698_/S VGND VGND VPWR VPWR sky130_fd_sc_hd__diode_2
XFILLER_2_119 VGND VGND VPWR VPWR sky130_fd_sc_hd__fill_2
X_2689_ _4868_/A _3208_/A VGND VGND VPWR VPWR _4547_/S sky130_fd_sc_hd__nor2_8
XFILLER_105_559 VGND VGND VPWR VPWR sky130_fd_sc_hd__fill_1
X_4428_ _5087_/A0 _4994_/B _4445_/B _4901_/A0 _3801_/B VGND VGND VPWR VPWR _4428_/X
+ sky130_fd_sc_hd__a221o_1
XANTENNA__4220__S1 _4212_/A VGND VGND VPWR VPWR sky130_fd_sc_hd__diode_2
XFILLER_101_721 VGND VGND VPWR VPWR sky130_fd_sc_hd__fill_4
XFILLER_86_421 VGND VGND VPWR VPWR sky130_fd_sc_hd__fill_1
X_4359_ hold195/X _5052_/A1 _4366_/S VGND VGND VPWR VPWR _4359_/X sky130_fd_sc_hd__mux2_1
XFILLER_101_765 VPWR VGND VPWR VGND sky130_ef_sc_hd__decap_40_12
XANTENNA__4816__A _4881_/A VGND VGND VPWR VPWR sky130_fd_sc_hd__diode_2
XANTENNA__4428__A2 _4994_/B VGND VGND VPWR VPWR sky130_fd_sc_hd__diode_2
X_6029_ _6315_/CLK _6029_/D VGND VGND VPWR VPWR _6029_/Q sky130_fd_sc_hd__dfxtp_1
XFILLER_55_841 VGND VGND VPWR VPWR sky130_fd_sc_hd__fill_1
XFILLER_70_811 VGND VGND VPWR VPWR sky130_fd_sc_hd__fill_1
XFILLER_15_727 VGND VGND VPWR VPWR sky130_fd_sc_hd__fill_1
XANTENNA__4027__S _4228_/S VGND VGND VPWR VPWR sky130_fd_sc_hd__diode_2
Xfanout63 _2642_/Y VGND VGND VPWR VPWR _3052_/A1 sky130_fd_sc_hd__buf_2
XANTENNA__3866__S _3869_/S VGND VGND VPWR VPWR sky130_fd_sc_hd__diode_2
XFILLER_23_782 VGND VGND VPWR VPWR sky130_fd_sc_hd__fill_2
Xfanout74 _2628_/Y VGND VGND VPWR VPWR _4811_/C1 sky130_fd_sc_hd__buf_4
XANTENNA__3438__Y _3450_/S VGND VGND VPWR VPWR sky130_fd_sc_hd__diode_2
Xfanout96 hold2221/X VGND VGND VPWR VPWR _5046_/A1 sky130_fd_sc_hd__clkbuf_4
XFILLER_10_421 VPWR VGND VPWR VGND sky130_ef_sc_hd__decap_40_12
Xfanout85 hold2089/X VGND VGND VPWR VPWR _5211_/A1 sky130_fd_sc_hd__buf_4
XFILLER_109_821 VPWR VGND VPWR VGND sky130_ef_sc_hd__decap_40_12
XANTENNA__3167__A _4178_/A VGND VGND VPWR VPWR sky130_fd_sc_hd__diode_2
XTAP_TAPCELL_ROW_94_1713 VGND VPWR sky130_fd_sc_hd__tapvpwrvgnd_1
XFILLER_6_469 VGND VGND VPWR VPWR sky130_fd_sc_hd__fill_4
XANTENNA__4364__A1 _5045_/A1 VGND VGND VPWR VPWR sky130_fd_sc_hd__diode_2
XFILLER_124_813 VPWR VGND VPWR VGND sky130_ef_sc_hd__decap_40_12
XFILLER_111_529 VPWR VGND VPWR VGND sky130_ef_sc_hd__decap_40_12
XFILLER_1_141 VGND VGND VPWR VPWR sky130_fd_sc_hd__fill_2
XFILLER_123_389 VGND VGND VPWR VPWR sky130_fd_sc_hd__fill_1
XFILLER_104_581 VGND VGND VPWR VPWR sky130_fd_sc_hd__fill_4
XFILLER_96_229 VGND VGND VPWR VPWR sky130_fd_sc_hd__fill_1
XFILLER_89_281 VGND VGND VPWR VPWR sky130_fd_sc_hd__fill_1
XANTENNA__3875__A0 _6414_/Q VGND VGND VPWR VPWR sky130_fd_sc_hd__diode_2
XFILLER_2_697 VGND VGND VPWR VPWR sky130_fd_sc_hd__fill_2
XTAP_TAPCELL_ROW_121_2109 VGND VPWR sky130_fd_sc_hd__tapvpwrvgnd_1
XFILLER_46_841 VGND VGND VPWR VPWR sky130_fd_sc_hd__fill_1
XFILLER_38_92 VGND VGND VPWR VPWR sky130_fd_sc_hd__fill_1
XFILLER_92_479 VGND VGND VPWR VPWR sky130_fd_sc_hd__fill_1
XANTENNA__4445__B _4445_/B VGND VGND VPWR VPWR sky130_fd_sc_hd__diode_2
XFILLER_45_362 VGND VGND VPWR VPWR sky130_fd_sc_hd__fill_2
XFILLER_18_587 VGND VGND VPWR VPWR sky130_fd_sc_hd__fill_1
XANTENNA__2850__A1 _3031_/A1 VGND VGND VPWR VPWR sky130_fd_sc_hd__diode_2
XFILLER_61_833 VGND VGND VPWR VPWR sky130_fd_sc_hd__fill_4
XFILLER_33_535 VGND VGND VPWR VPWR sky130_fd_sc_hd__fill_1
XTAP_TAPCELL_ROW_103_1842 VGND VPWR sky130_fd_sc_hd__tapvpwrvgnd_1
XANTENNA__4052__B1 _4252_/B1 VGND VGND VPWR VPWR sky130_fd_sc_hd__diode_2
X_3730_ _3730_/A _3811_/B VGND VGND VPWR VPWR _3837_/A sky130_fd_sc_hd__nand2_4
XFILLER_60_376 VGND VGND VPWR VPWR sky130_fd_sc_hd__fill_4
XFILLER_14_793 VPWR VGND VPWR VGND sky130_ef_sc_hd__decap_40_12
XFILLER_119_629 VPWR VGND VPWR VGND sky130_ef_sc_hd__decap_40_12
XANTENNA__2894__A1_N _3096_/A1 VGND VGND VPWR VPWR sky130_fd_sc_hd__diode_2
XTAP_TAPCELL_ROW_31_758 VGND VPWR sky130_fd_sc_hd__tapvpwrvgnd_1
XTAP_TAPCELL_ROW_31_769 VGND VPWR sky130_fd_sc_hd__tapvpwrvgnd_1
XTAP_TAPCELL_ROW_136_2341 VGND VPWR sky130_fd_sc_hd__tapvpwrvgnd_1
XFILLER_118_139 VGND VGND VPWR VPWR sky130_fd_sc_hd__fill_1
X_3661_ _6412_/Q _3661_/A1 _3667_/S VGND VGND VPWR VPWR _3661_/X sky130_fd_sc_hd__mux2_1
X_3592_ hold918/X _4961_/A0 _3595_/S VGND VGND VPWR VPWR _3592_/X sky130_fd_sc_hd__mux2_1
X_6380_ _6380_/CLK _6380_/D VGND VGND VPWR VPWR _6380_/Q sky130_fd_sc_hd__dfxtp_1
X_5400_ _6123_/CLK _5400_/D VGND VGND VPWR VPWR _5400_/Q sky130_fd_sc_hd__dfxtp_1
Xclkload33 _6347_/CLK VGND VGND VPWR VPWR clkload33/Y sky130_fd_sc_hd__clkinv_4
XANTENNA__4355__A1 _5046_/A1 VGND VGND VPWR VPWR sky130_fd_sc_hd__diode_2
XTAP_TAPCELL_ROW_11_460 VGND VPWR sky130_fd_sc_hd__tapvpwrvgnd_1
XTAP_TAPCELL_ROW_11_471 VGND VPWR sky130_fd_sc_hd__tapvpwrvgnd_1
Xclkload22 _5784_/CLK VGND VGND VPWR VPWR clkload22/Y sky130_fd_sc_hd__inv_8
Xclkload44 _5682_/CLK VGND VGND VPWR VPWR clkload44/Y sky130_fd_sc_hd__bufinv_16
Xclkload11 _6420_/CLK VGND VGND VPWR VPWR clkload11/Y sky130_fd_sc_hd__inv_6
Xclkload77 _6143_/CLK VGND VGND VPWR VPWR clkload77/Y sky130_fd_sc_hd__bufinv_16
XFILLER_127_673 VPWR VGND VPWR VGND sky130_ef_sc_hd__decap_40_12
X_5331_ _6172_/CLK _5331_/D VGND VGND VPWR VPWR _5331_/Q sky130_fd_sc_hd__dfxtp_1
Xclkload66 _6402_/CLK VGND VGND VPWR VPWR clkload66/Y sky130_fd_sc_hd__inv_8
Xclkload55 _6094_/CLK VGND VGND VPWR VPWR clkload55/Y sky130_fd_sc_hd__clkinv_4
Xclkload88 _6254_/CLK VGND VGND VPWR VPWR clkload88/Y sky130_fd_sc_hd__inv_6
Xclkload99 _6242_/CLK VGND VGND VPWR VPWR clkload99/Y sky130_fd_sc_hd__clkinv_2
XANTENNA__4400__S _4406_/S VGND VGND VPWR VPWR sky130_fd_sc_hd__diode_2
XFILLER_130_805 VGND VGND VPWR VPWR sky130_fd_sc_hd__fill_4
X_5262_ _6409_/CLK _5262_/D VGND VGND VPWR VPWR _5262_/Q sky130_fd_sc_hd__dfxtp_1
XANTENNA__2669__A1 _4899_/A0 VGND VGND VPWR VPWR sky130_fd_sc_hd__diode_2
XANTENNA__3016__S _3016_/S VGND VGND VPWR VPWR sky130_fd_sc_hd__diode_2
XANTENNA__3866__A0 _4961_/A0 VGND VGND VPWR VPWR sky130_fd_sc_hd__diode_2
X_5193_ _5189_/Y _5192_/X _5200_/A VGND VGND VPWR VPWR _5193_/X sky130_fd_sc_hd__o21a_1
X_4213_ _6006_/Q _5997_/Q _4213_/S VGND VGND VPWR VPWR _4213_/X sky130_fd_sc_hd__mux2_1
XANTENNA__2764__S1 _3050_/A VGND VGND VPWR VPWR sky130_fd_sc_hd__diode_2
X_4144_ hold952/X _4392_/A1 _4290_/A0 hold785/X _4257_/S _4241_/A VGND VGND VPWR VPWR
+ _4144_/X sky130_fd_sc_hd__mux4_1
XANTENNA__2855__S _3072_/S VGND VGND VPWR VPWR sky130_fd_sc_hd__diode_2
XFILLER_95_273 VGND VGND VPWR VPWR sky130_fd_sc_hd__fill_4
XFILLER_68_487 VGND VGND VPWR VPWR sky130_fd_sc_hd__fill_1
XFILLER_28_307 VGND VGND VPWR VPWR sky130_fd_sc_hd__fill_1
XFILLER_83_457 VGND VGND VPWR VPWR sky130_fd_sc_hd__fill_2
XFILLER_83_446 VGND VGND VPWR VPWR sky130_fd_sc_hd__fill_2
XFILLER_83_435 VGND VGND VPWR VPWR sky130_fd_sc_hd__fill_2
XPHY_EDGE_ROW_50_Left_189 VGND VGND VPWR VPWR sky130_fd_sc_hd__decap_3
X_4075_ _4272_/S _4074_/X _4068_/Y _5343_/Q VGND VGND VPWR VPWR _4076_/B sky130_fd_sc_hd__o211a_1
XFILLER_37_841 VGND VGND VPWR VPWR sky130_fd_sc_hd__fill_1
X_3026_ _5424_/Q _5498_/Q _5354_/Q _5582_/Q _2963_/S _2962_/A VGND VGND VPWR VPWR
+ _3027_/B sky130_fd_sc_hd__mux4_1
XFILLER_52_811 VGND VGND VPWR VPWR sky130_fd_sc_hd__fill_1
XANTENNA__5144__A1_N _3958_/A VGND VGND VPWR VPWR sky130_fd_sc_hd__diode_2
XFILLER_70_129 VGND VGND VPWR VPWR sky130_fd_sc_hd__fill_1
XFILLER_63_181 VGND VGND VPWR VPWR sky130_fd_sc_hd__fill_2
Xclkbuf_leaf_90_clk clkload1/A VGND VGND VPWR VPWR _6114_/CLK sky130_fd_sc_hd__clkbuf_8
XTAP_TAPCELL_ROW_19_582 VGND VPWR sky130_fd_sc_hd__tapvpwrvgnd_1
XFILLER_24_535 VGND VGND VPWR VPWR sky130_fd_sc_hd__fill_1
XFILLER_24_557 VGND VGND VPWR VPWR sky130_fd_sc_hd__fill_2
X_4977_ _4977_/A0 _5052_/A1 _4984_/S VGND VGND VPWR VPWR _4977_/X sky130_fd_sc_hd__mux2_1
Xclkload5 clkload5/A VGND VGND VPWR VPWR clkload5/Y sky130_fd_sc_hd__inv_16
X_3928_ hold503/X _5202_/A1 _3928_/S VGND VGND VPWR VPWR _3928_/X sky130_fd_sc_hd__mux2_1
XANTENNA__5159__A1_N _3958_/A VGND VGND VPWR VPWR sky130_fd_sc_hd__diode_2
X_3859_ _5085_/A _3859_/B VGND VGND VPWR VPWR _5842_/D sky130_fd_sc_hd__nor2_1
X_5529_ _5565_/CLK _5529_/D VGND VGND VPWR VPWR _5529_/Q sky130_fd_sc_hd__dfxtp_1
XFILLER_106_813 VPWR VGND VPWR VGND sky130_ef_sc_hd__decap_40_12
XTAP_TAPCELL_ROW_76_1443 VGND VPWR sky130_fd_sc_hd__tapvpwrvgnd_1
XFILLER_105_323 VGND VGND VPWR VPWR sky130_fd_sc_hd__fill_1
XFILLER_133_665 VGND VGND VPWR VPWR sky130_fd_sc_hd__fill_4
XFILLER_120_337 VGND VGND VPWR VPWR sky130_fd_sc_hd__fill_1
XFILLER_59_410 VGND VGND VPWR VPWR sky130_fd_sc_hd__fill_1
XFILLER_101_573 VPWR VGND VPWR VGND sky130_ef_sc_hd__decap_40_12
XFILLER_87_785 VPWR VGND VPWR VGND sky130_ef_sc_hd__decap_40_12
XFILLER_86_251 VGND VGND VPWR VPWR sky130_fd_sc_hd__fill_1
XFILLER_28_841 VGND VGND VPWR VPWR sky130_fd_sc_hd__fill_1
XFILLER_55_682 VGND VGND VPWR VPWR sky130_fd_sc_hd__fill_1
XFILLER_43_833 VGND VGND VPWR VPWR sky130_fd_sc_hd__fill_4
XANTENNA__4980__S _4984_/S VGND VGND VPWR VPWR sky130_fd_sc_hd__diode_2
XFILLER_70_663 VGND VGND VPWR VPWR sky130_fd_sc_hd__fill_2
Xclkbuf_leaf_81_clk clkload1/A VGND VGND VPWR VPWR _5714_/CLK sky130_fd_sc_hd__clkbuf_8
XFILLER_15_557 VGND VGND VPWR VPWR sky130_fd_sc_hd__fill_2
XFILLER_11_741 VPWR VGND VPWR VGND sky130_ef_sc_hd__decap_40_12
XFILLER_30_549 VGND VGND VPWR VPWR sky130_fd_sc_hd__fill_4
XFILLER_11_785 VPWR VGND VPWR VGND sky130_ef_sc_hd__decap_40_12
XTAP_TAPCELL_ROW_118_2071 VGND VPWR sky130_fd_sc_hd__tapvpwrvgnd_1
XANTENNA__4337__A1 _5051_/A1 VGND VGND VPWR VPWR sky130_fd_sc_hd__diode_2
XFILLER_109_673 VPWR VGND VPWR VGND sky130_ef_sc_hd__decap_40_12
XTAP_TAPCELL_ROW_131_2260 VGND VPWR sky130_fd_sc_hd__tapvpwrvgnd_1
XFILLER_124_643 VGND VGND VPWR VPWR sky130_fd_sc_hd__fill_1
XTAP_TAPCELL_ROW_131_2271 VGND VPWR sky130_fd_sc_hd__tapvpwrvgnd_1
XFILLER_123_142 VGND VGND VPWR VPWR sky130_fd_sc_hd__fill_2
XFILLER_112_805 VGND VGND VPWR VPWR sky130_fd_sc_hd__fill_4
XFILLER_97_516 VPWR VGND VPWR VGND sky130_ef_sc_hd__decap_40_12
XFILLER_111_326 VGND VGND VPWR VPWR sky130_fd_sc_hd__fill_2
XFILLER_38_605 VGND VGND VPWR VPWR sky130_fd_sc_hd__fill_1
XANTENNA_output50_A _5438_/Q VGND VGND VPWR VPWR sky130_fd_sc_hd__diode_2
XANTENNA__2675__S _5241_/S VGND VGND VPWR VPWR sky130_fd_sc_hd__diode_2
XFILLER_65_446 VGND VGND VPWR VPWR sky130_fd_sc_hd__fill_2
XANTENNA__5051__S _5059_/S VGND VGND VPWR VPWR sky130_fd_sc_hd__diode_2
XFILLER_1_54 VGND VGND VPWR VPWR sky130_fd_sc_hd__fill_2
XFILLER_19_841 VGND VGND VPWR VPWR sky130_fd_sc_hd__fill_1
XANTENNA__3076__A1 _3076_/A1 VGND VGND VPWR VPWR sky130_fd_sc_hd__diode_2
XFILLER_93_777 VGND VGND VPWR VPWR sky130_fd_sc_hd__fill_4
XFILLER_53_608 VGND VGND VPWR VPWR sky130_fd_sc_hd__fill_2
XFILLER_18_362 VGND VGND VPWR VPWR sky130_fd_sc_hd__fill_2
XFILLER_34_811 VGND VGND VPWR VPWR sky130_fd_sc_hd__fill_1
X_4900_ _5810_/Q _4900_/A1 _4906_/S VGND VGND VPWR VPWR _4900_/X sky130_fd_sc_hd__mux2_1
XANTENNA__4890__S _4893_/S VGND VGND VPWR VPWR sky130_fd_sc_hd__diode_2
X_5880_ _6417_/CLK _5880_/D VGND VGND VPWR VPWR _5880_/Q sky130_fd_sc_hd__dfxtp_1
XTAP_TAPCELL_ROW_47_1011 VGND VPWR sky130_fd_sc_hd__tapvpwrvgnd_1
XTAP_TAPCELL_ROW_47_1000 VGND VPWR sky130_fd_sc_hd__tapvpwrvgnd_1
XTAP_TAPCELL_ROW_36_839 VGND VPWR sky130_fd_sc_hd__tapvpwrvgnd_1
XANTENNA__2823__B2 _3096_/A1 VGND VGND VPWR VPWR sky130_fd_sc_hd__diode_2
X_4831_ _4883_/A1 _4831_/A1 _4841_/S VGND VGND VPWR VPWR _6184_/D sky130_fd_sc_hd__mux2_1
Xclkbuf_leaf_72_clk clkload2/A VGND VGND VPWR VPWR _6297_/CLK sky130_fd_sc_hd__clkbuf_8
XTAP_TAPCELL_ROW_16_541 VGND VPWR sky130_fd_sc_hd__tapvpwrvgnd_1
XTAP_TAPCELL_ROW_60_1200 VGND VPWR sky130_fd_sc_hd__tapvpwrvgnd_1
XFILLER_21_505 VPWR VGND VPWR VGND sky130_ef_sc_hd__decap_40_12
X_4762_ _2629_/Y _4761_/X _2628_/A VGND VGND VPWR VPWR _4762_/X sky130_fd_sc_hd__o21a_1
X_4693_ _6085_/Q _5883_/Q _4801_/S VGND VGND VPWR VPWR _4693_/X sky130_fd_sc_hd__mux2_1
X_3713_ _4134_/A0 _5043_/A1 _3717_/S VGND VGND VPWR VPWR _3713_/X sky130_fd_sc_hd__mux2_1
X_6432_ _6432_/CLK _6432_/D VGND VGND VPWR VPWR _6432_/Q sky130_fd_sc_hd__dfxtp_1
Xclkload100 _6232_/CLK VGND VGND VPWR VPWR clkload100/Y sky130_fd_sc_hd__inv_6
X_3644_ hold809/X _5213_/A1 _3647_/S VGND VGND VPWR VPWR _3644_/X sky130_fd_sc_hd__mux2_1
X_6363_ _6432_/CLK _6363_/D VGND VGND VPWR VPWR _6363_/Q sky130_fd_sc_hd__dfxtp_1
X_3575_ _4493_/B _4955_/A VGND VGND VPWR VPWR _3584_/S sky130_fd_sc_hd__nor2_4
X_5314_ _6429_/CLK _5314_/D VGND VGND VPWR VPWR _5314_/Q sky130_fd_sc_hd__dfxtp_1
XFILLER_115_665 VGND VGND VPWR VPWR sky130_fd_sc_hd__fill_4
XFILLER_88_516 VGND VGND VPWR VPWR sky130_fd_sc_hd__fill_4
X_6294_ _6294_/CLK _6294_/D VGND VGND VPWR VPWR _6294_/Q sky130_fd_sc_hd__dfxtp_1
XTAP_TAPCELL_ROW_58_1173 VGND VPWR sky130_fd_sc_hd__tapvpwrvgnd_1
XFILLER_130_613 VPWR VGND VPWR VGND sky130_ef_sc_hd__decap_40_12
X_5245_ _6435_/CLK _5245_/D VGND VGND VPWR VPWR _5245_/Q sky130_fd_sc_hd__dfxtp_1
XFILLER_130_657 VPWR VGND VPWR VGND sky130_ef_sc_hd__decap_40_12
XTAP_TAPCELL_ROW_71_1362 VGND VPWR sky130_fd_sc_hd__tapvpwrvgnd_1
Xhold17 hold17/A VGND VGND VPWR VPWR hold17/X sky130_fd_sc_hd__dlygate4sd3_1
Xhold1902 _6285_/Q VGND VGND VPWR VPWR _4950_/A1 sky130_fd_sc_hd__dlygate4sd3_1
XFILLER_29_39 VGND VGND VPWR VPWR sky130_fd_sc_hd__fill_1
Xhold28 hold28/A VGND VGND VPWR VPWR hold28/X sky130_fd_sc_hd__dlygate4sd3_1
XANTENNA__4500__A1 _5214_/A1 VGND VGND VPWR VPWR sky130_fd_sc_hd__diode_2
Xhold1924 _5081_/X VGND VGND VPWR VPWR _6372_/D sky130_fd_sc_hd__dlygate4sd3_1
X_5176_ _5176_/A _5176_/B VGND VGND VPWR VPWR _6399_/D sky130_fd_sc_hd__and2_1
Xhold1935 _6060_/Q VGND VGND VPWR VPWR _4437_/A1 sky130_fd_sc_hd__dlygate4sd3_1
XFILLER_69_785 VGND VGND VPWR VPWR sky130_fd_sc_hd__fill_4
XFILLER_68_251 VGND VGND VPWR VPWR sky130_fd_sc_hd__fill_1
Xhold39 hold39/A VGND VGND VPWR VPWR hold39/X sky130_fd_sc_hd__dlygate4sd3_1
Xhold1913 _6291_/Q VGND VGND VPWR VPWR _4957_/A1 sky130_fd_sc_hd__dlygate4sd3_1
XANTENNA__3270__A _3801_/A VGND VGND VPWR VPWR sky130_fd_sc_hd__diode_2
Xhold1968 _6059_/Q VGND VGND VPWR VPWR _4433_/A1 sky130_fd_sc_hd__dlygate4sd3_1
Xhold1957 _3721_/X VGND VGND VPWR VPWR _5739_/D sky130_fd_sc_hd__dlygate4sd3_1
Xhold1946 _5910_/Q VGND VGND VPWR VPWR _4135_/A1 sky130_fd_sc_hd__dlygate4sd3_1
X_4127_ _6003_/Q _5994_/Q _4213_/S VGND VGND VPWR VPWR _4127_/X sky130_fd_sc_hd__mux2_1
Xhold1979 _3147_/X VGND VGND VPWR VPWR _5328_/D sky130_fd_sc_hd__dlygate4sd3_1
X_4058_ _5770_/Q _6028_/Q _5938_/Q _6309_/Q _4258_/S _4241_/A VGND VGND VPWR VPWR
+ _4058_/X sky130_fd_sc_hd__mux4_1
XANTENNA__4264__B1 _4271_/S1 VGND VGND VPWR VPWR sky130_fd_sc_hd__diode_2
X_3009_ _3096_/A1 _3008_/X _3005_/Y _3007_/Y VGND VGND VPWR VPWR _3009_/X sky130_fd_sc_hd__o2bb2a_1
XFILLER_71_449 VGND VGND VPWR VPWR sky130_fd_sc_hd__fill_4
XFILLER_25_833 VGND VGND VPWR VPWR sky130_fd_sc_hd__fill_4
XFILLER_37_671 VGND VGND VPWR VPWR sky130_fd_sc_hd__fill_1
Xclkbuf_leaf_63_clk clkload5/A VGND VGND VPWR VPWR _6057_/CLK sky130_fd_sc_hd__clkbuf_8
XFILLER_24_321 VGND VGND VPWR VPWR sky130_fd_sc_hd__fill_2
XFILLER_101_55 VGND VGND VPWR VPWR sky130_fd_sc_hd__fill_1
XFILLER_52_696 VGND VGND VPWR VPWR sky130_fd_sc_hd__fill_2
XFILLER_24_365 VPWR VGND VPWR VGND sky130_ef_sc_hd__decap_40_12
XFILLER_40_825 VPWR VGND VPWR VGND sky130_ef_sc_hd__decap_40_12
XANTENNA__4567__A1 _4792_/A1 VGND VGND VPWR VPWR sky130_fd_sc_hd__diode_2
XFILLER_138_713 VPWR VGND VPWR VGND sky130_ef_sc_hd__decap_40_12
XANTENNA__4662__S1 _4802_/A VGND VGND VPWR VPWR sky130_fd_sc_hd__diode_2
XFILLER_138_757 VPWR VGND VPWR VGND sky130_ef_sc_hd__decap_40_12
XANTENNA__4319__A1 _5053_/A1 VGND VGND VPWR VPWR sky130_fd_sc_hd__diode_2
XFILLER_106_643 VGND VGND VPWR VPWR sky130_fd_sc_hd__fill_1
XFILLER_4_737 VPWR VGND VPWR VGND sky130_ef_sc_hd__decap_40_12
XFILLER_126_41 VGND VGND VPWR VPWR sky130_fd_sc_hd__fill_2
XFILLER_121_613 VGND VGND VPWR VPWR sky130_fd_sc_hd__fill_2
XFILLER_126_85 VGND VGND VPWR VPWR sky130_fd_sc_hd__fill_1
XANTENNA__3451__Y _3463_/S VGND VGND VPWR VPWR sky130_fd_sc_hd__diode_2
XFILLER_75_722 VGND VGND VPWR VPWR sky130_fd_sc_hd__fill_4
XANTENNA_fanout72_X _4811_/A1 VGND VGND VPWR VPWR sky130_fd_sc_hd__diode_2
XTAP_TAPCELL_ROW_89_1634 VGND VPWR sky130_fd_sc_hd__tapvpwrvgnd_1
XFILLER_59_295 VGND VGND VPWR VPWR sky130_fd_sc_hd__fill_2
XFILLER_19_137 VGND VGND VPWR VPWR sky130_fd_sc_hd__fill_1
XANTENNA__3058__A1 _3092_/A VGND VGND VPWR VPWR sky130_fd_sc_hd__diode_2
XFILLER_90_703 VGND VGND VPWR VPWR sky130_fd_sc_hd__fill_2
XFILLER_19_159 VGND VGND VPWR VPWR sky130_fd_sc_hd__fill_1
XFILLER_74_276 VGND VGND VPWR VPWR sky130_fd_sc_hd__fill_2
XFILLER_16_811 VGND VGND VPWR VPWR sky130_fd_sc_hd__fill_1
XFILLER_90_769 VPWR VGND VPWR VGND sky130_ef_sc_hd__decap_40_12
Xclkbuf_leaf_54_clk clkload6/A VGND VGND VPWR VPWR _6380_/CLK sky130_fd_sc_hd__clkbuf_8
XPHY_EDGE_ROW_106_Left_245 VGND VGND VPWR VPWR sky130_fd_sc_hd__decap_3
XTAP_TAPCELL_ROW_100_1801 VGND VPWR sky130_fd_sc_hd__tapvpwrvgnd_1
XTAP_TAPCELL_ROW_13_500 VGND VPWR sky130_fd_sc_hd__tapvpwrvgnd_1
XANTENNA__4558__A1 _4903_/A0 VGND VGND VPWR VPWR sky130_fd_sc_hd__diode_2
XTAP_TAPCELL_ROW_133_2300 VGND VPWR sky130_fd_sc_hd__tapvpwrvgnd_1
XFILLER_128_245 VGND VGND VPWR VPWR sky130_fd_sc_hd__fill_4
Xhold509 _6344_/Q VGND VGND VPWR VPWR hold509/X sky130_fd_sc_hd__dlygate4sd3_1
XFILLER_7_553 VGND VGND VPWR VPWR sky130_fd_sc_hd__fill_4
XFILLER_7_597 VPWR VGND VPWR VGND sky130_ef_sc_hd__decap_40_12
XPHY_EDGE_ROW_115_Left_254 VGND VGND VPWR VPWR sky130_fd_sc_hd__decap_3
XFILLER_98_825 VPWR VGND VPWR VGND sky130_ef_sc_hd__decap_40_12
XANTENNA__4245__A1_N _4252_/B1 VGND VGND VPWR VPWR sky130_fd_sc_hd__diode_2
X_3360_ _5389_/Q _5035_/C _5201_/B _5435_/Q VGND VGND VPWR VPWR _3360_/X sky130_fd_sc_hd__a22o_1
XFILLER_112_613 VPWR VGND VPWR VGND sky130_ef_sc_hd__decap_40_12
XANTENNA__4885__S _4893_/S VGND VGND VPWR VPWR sky130_fd_sc_hd__diode_2
XFILLER_3_781 VGND VGND VPWR VPWR sky130_fd_sc_hd__fill_2
XANTENNA__5343__Q _5343_/Q VGND VGND VPWR VPWR sky130_fd_sc_hd__diode_2
X_3291_ hold191/X _4889_/A1 _3295_/S VGND VGND VPWR VPWR _3291_/X sky130_fd_sc_hd__mux2_1
XFILLER_112_657 VPWR VGND VPWR VGND sky130_ef_sc_hd__decap_40_12
XTAP_TAPCELL_ROW_111_1963 VGND VPWR sky130_fd_sc_hd__tapvpwrvgnd_1
X_5030_ _5112_/B _5013_/Y _5029_/X _5915_/Q VGND VGND VPWR VPWR _5030_/X sky130_fd_sc_hd__o31a_1
XFILLER_2_291 VGND VGND VPWR VPWR sky130_fd_sc_hd__fill_1
XANTENNA__3297__A1 _4882_/A1 VGND VGND VPWR VPWR sky130_fd_sc_hd__diode_2
XFILLER_66_711 VGND VGND VPWR VPWR sky130_fd_sc_hd__fill_1
Xhold1209 _3416_/X VGND VGND VPWR VPWR _5469_/D sky130_fd_sc_hd__dlygate4sd3_1
XTAP_TAPCELL_ROW_53_1092 VGND VPWR sky130_fd_sc_hd__tapvpwrvgnd_1
XFILLER_25_3 VPWR VGND VPWR VGND sky130_ef_sc_hd__decap_40_12
XFILLER_66_755 VGND VGND VPWR VPWR sky130_fd_sc_hd__fill_1
XFILLER_93_552 VGND VGND VPWR VPWR sky130_fd_sc_hd__fill_8
XFILLER_81_714 VGND VGND VPWR VPWR sky130_fd_sc_hd__fill_4
XFILLER_66_777 VPWR VGND VPWR VGND sky130_ef_sc_hd__decap_40_12
XFILLER_53_405 VGND VGND VPWR VPWR sky130_fd_sc_hd__fill_8
XFILLER_93_585 VPWR VGND VPWR VGND sky130_ef_sc_hd__decap_40_12
XFILLER_80_213 VGND VGND VPWR VPWR sky130_fd_sc_hd__fill_4
X_5932_ _6338_/CLK _5932_/D VGND VGND VPWR VPWR _5932_/Q sky130_fd_sc_hd__dfxtp_1
XFILLER_19_671 VGND VGND VPWR VPWR sky130_fd_sc_hd__fill_1
Xclkbuf_leaf_45_clk clkload4/A VGND VGND VPWR VPWR _6248_/CLK sky130_fd_sc_hd__clkbuf_8
XPHY_EDGE_ROW_124_Left_263 VGND VGND VPWR VPWR sky130_fd_sc_hd__decap_3
XFILLER_46_490 VGND VGND VPWR VPWR sky130_fd_sc_hd__fill_2
XFILLER_15_19 VGND VGND VPWR VPWR sky130_fd_sc_hd__fill_1
X_5863_ _6097_/CLK _5863_/D VGND VGND VPWR VPWR _5863_/Q sky130_fd_sc_hd__dfxtp_1
XFILLER_22_825 VPWR VGND VPWR VGND sky130_ef_sc_hd__decap_40_12
X_4814_ _3278_/A _4813_/X _4676_/A VGND VGND VPWR VPWR _4814_/Y sky130_fd_sc_hd__a21oi_1
X_5794_ _5803_/CLK _5794_/D VGND VGND VPWR VPWR _5794_/Q sky130_fd_sc_hd__dfxtp_1
XANTENNA__4125__S _4213_/S VGND VGND VPWR VPWR sky130_fd_sc_hd__diode_2
X_4745_ _4802_/A _4745_/B VGND VGND VPWR VPWR _4745_/X sky130_fd_sc_hd__or2_1
XFILLER_135_727 VGND VGND VPWR VPWR sky130_fd_sc_hd__fill_1
X_4676_ _4676_/A _4676_/B VGND VGND VPWR VPWR _4676_/Y sky130_fd_sc_hd__nor2_1
XPHY_EDGE_ROW_133_Left_272 VGND VGND VPWR VPWR sky130_fd_sc_hd__decap_3
X_3627_ hold837/X _5202_/A1 _3627_/S VGND VGND VPWR VPWR _3627_/X sky130_fd_sc_hd__mux2_1
X_6415_ _6417_/CLK _6415_/D VGND VGND VPWR VPWR _6415_/Q sky130_fd_sc_hd__dfxtp_2
X_3558_ _4517_/A1 _4651_/A0 _3562_/S VGND VGND VPWR VPWR _5597_/D sky130_fd_sc_hd__mux2_1
XTAP_TAPCELL_ROW_73_1402 VGND VPWR sky130_fd_sc_hd__tapvpwrvgnd_1
X_6346_ _6351_/CLK _6346_/D VGND VGND VPWR VPWR _6346_/Q sky130_fd_sc_hd__dfxtp_1
XANTENNA__4721__B2 _4663_/A VGND VGND VPWR VPWR sky130_fd_sc_hd__diode_2
XFILLER_115_473 VPWR VGND VPWR VGND sky130_ef_sc_hd__decap_40_12
XFILLER_103_613 VGND VGND VPWR VPWR sky130_fd_sc_hd__fill_2
XFILLER_1_729 VPWR VGND VPWR VGND sky130_ef_sc_hd__decap_40_12
XFILLER_130_454 VGND VGND VPWR VPWR sky130_fd_sc_hd__fill_1
X_3489_ hold463/X _4905_/A0 _3490_/S VGND VGND VPWR VPWR _3489_/X sky130_fd_sc_hd__mux2_1
X_6277_ _6314_/CLK _6277_/D VGND VGND VPWR VPWR _6277_/Q sky130_fd_sc_hd__dfxtp_1
XANTENNA__3288__A1 _4899_/A0 VGND VGND VPWR VPWR sky130_fd_sc_hd__diode_2
X_5228_ _5228_/A0 _5228_/A1 _5237_/S VGND VGND VPWR VPWR _5228_/X sky130_fd_sc_hd__mux2_1
Xhold1710 _3526_/X VGND VGND VPWR VPWR _5569_/D sky130_fd_sc_hd__dlygate4sd3_1
XFILLER_29_402 VPWR VGND VPWR VGND sky130_ef_sc_hd__decap_40_12
Xhold1743 _3521_/X VGND VGND VPWR VPWR _5564_/D sky130_fd_sc_hd__dlygate4sd3_1
X_5159_ _3958_/A _5158_/X _5157_/Y _5162_/B VGND VGND VPWR VPWR _5160_/B sky130_fd_sc_hd__a2bb2o_1
Xhold1732 _4953_/X VGND VGND VPWR VPWR _6288_/D sky130_fd_sc_hd__dlygate4sd3_1
XFILLER_29_446 VGND VGND VPWR VPWR sky130_fd_sc_hd__fill_2
Xhold1721 _5973_/Q VGND VGND VPWR VPWR _4327_/A1 sky130_fd_sc_hd__dlygate4sd3_1
Xhold1754 _6297_/Q VGND VGND VPWR VPWR _4963_/A1 sky130_fd_sc_hd__dlygate4sd3_1
Xhold1765 _3673_/X VGND VGND VPWR VPWR _5696_/D sky130_fd_sc_hd__dlygate4sd3_1
Xhold1787 _4391_/X VGND VGND VPWR VPWR _6030_/D sky130_fd_sc_hd__dlygate4sd3_1
Xhold1776 _5943_/Q VGND VGND VPWR VPWR _4292_/A0 sky130_fd_sc_hd__dlygate4sd3_1
XFILLER_56_276 VGND VGND VPWR VPWR sky130_fd_sc_hd__fill_1
Xhold1798 _5978_/Q VGND VGND VPWR VPWR _4332_/A1 sky130_fd_sc_hd__dlygate4sd3_1
Xclkbuf_leaf_36_clk clkload4/A VGND VGND VPWR VPWR _6366_/CLK sky130_fd_sc_hd__clkbuf_8
XTAP_TAPCELL_ROW_84_1553 VGND VPWR sky130_fd_sc_hd__tapvpwrvgnd_1
XANTENNA__3460__A1 _4903_/A0 VGND VGND VPWR VPWR sky130_fd_sc_hd__diode_2
XTAP_TAPCELL_ROW_84_1564 VGND VPWR sky130_fd_sc_hd__tapvpwrvgnd_1
XFILLER_138_587 VGND VGND VPWR VPWR sky130_fd_sc_hd__fill_1
XFILLER_125_204 VGND VGND VPWR VPWR sky130_fd_sc_hd__fill_4
XTAP_TAPCELL_ROW_115_2030 VGND VPWR sky130_fd_sc_hd__tapvpwrvgnd_1
XFILLER_4_501 VPWR VGND VPWR VGND sky130_ef_sc_hd__decap_40_12
XFILLER_126_749 VGND VGND VPWR VPWR sky130_fd_sc_hd__fill_4
XFILLER_137_51 VGND VGND VPWR VPWR sky130_fd_sc_hd__fill_4
XFILLER_4_545 VPWR VGND VPWR VGND sky130_ef_sc_hd__decap_40_12
XFILLER_134_793 VPWR VGND VPWR VGND sky130_ef_sc_hd__decap_40_12
XANTENNA__3071__S0 _2984_/S VGND VGND VPWR VPWR sky130_fd_sc_hd__diode_2
XFILLER_4_589 VPWR VGND VPWR VGND sky130_ef_sc_hd__decap_40_12
XFILLER_121_421 VGND VGND VPWR VPWR sky130_fd_sc_hd__fill_1
XFILLER_97_99 VGND VGND VPWR VPWR sky130_fd_sc_hd__fill_2
XFILLER_95_839 VGND VGND VPWR VPWR sky130_fd_sc_hd__fill_1
XFILLER_48_755 VGND VGND VPWR VPWR sky130_fd_sc_hd__fill_1
XFILLER_47_243 VGND VGND VPWR VPWR sky130_fd_sc_hd__fill_2
XTAP_TAPCELL_ROW_126_2192 VGND VPWR sky130_fd_sc_hd__tapvpwrvgnd_1
XFILLER_90_533 VPWR VGND VPWR VGND sky130_ef_sc_hd__decap_40_12
Xclkbuf_leaf_27_clk clkload3/A VGND VGND VPWR VPWR _6065_/CLK sky130_fd_sc_hd__clkbuf_8
XFILLER_16_641 VGND VGND VPWR VPWR sky130_fd_sc_hd__fill_2
XTAP_TAPCELL_ROW_46_989 VGND VPWR sky130_fd_sc_hd__tapvpwrvgnd_1
X_2860_ _5540_/Q _5564_/Q _3051_/S VGND VGND VPWR VPWR _2861_/B sky130_fd_sc_hd__mux2_1
XTAP_TAPCELL_ROW_26_691 VGND VPWR sky130_fd_sc_hd__tapvpwrvgnd_1
XFILLER_30_121 VGND VGND VPWR VPWR sky130_fd_sc_hd__fill_2
X_2791_ _5514_/Q _5526_/Q _3051_/S VGND VGND VPWR VPWR _2791_/X sky130_fd_sc_hd__mux2_1
XANTENNA__3203__A1 _5234_/A0 VGND VGND VPWR VPWR sky130_fd_sc_hd__diode_2
XANTENNA__4400__A0 _5825_/Q VGND VGND VPWR VPWR sky130_fd_sc_hd__diode_2
XFILLER_31_699 VGND VGND VPWR VPWR sky130_fd_sc_hd__fill_1
XFILLER_117_727 VGND VGND VPWR VPWR sky130_fd_sc_hd__fill_1
X_4530_ hold477/X _5232_/A0 _4535_/S VGND VGND VPWR VPWR _4530_/X sky130_fd_sc_hd__mux2_1
X_4461_ _5238_/A1 _4461_/A1 _4472_/S VGND VGND VPWR VPWR _4461_/X sky130_fd_sc_hd__mux2_1
Xhold317 _5509_/Q VGND VGND VPWR VPWR hold317/X sky130_fd_sc_hd__dlygate4sd3_1
XFILLER_7_361 VPWR VGND VPWR VGND sky130_ef_sc_hd__decap_40_12
Xhold306 _4478_/X VGND VGND VPWR VPWR _6085_/D sky130_fd_sc_hd__dlygate4sd3_1
Xhold328 _3117_/X VGND VGND VPWR VPWR _5310_/D sky130_fd_sc_hd__dlygate4sd3_1
XANTENNA__3085__A _3085_/A VGND VGND VPWR VPWR sky130_fd_sc_hd__diode_2
X_6200_ _6237_/CLK _6200_/D VGND VGND VPWR VPWR _6200_/Q sky130_fd_sc_hd__dfxtp_1
Xhold339 _5754_/Q VGND VGND VPWR VPWR hold339/X sky130_fd_sc_hd__dlygate4sd3_1
X_3412_ _4984_/A1 _3412_/A1 _3412_/S VGND VGND VPWR VPWR _3412_/X sky130_fd_sc_hd__mux2_1
X_6131_ _6137_/CLK _6131_/D VGND VGND VPWR VPWR _6131_/Q sky130_fd_sc_hd__dfxtp_1
XANTENNA__2714__A0 _5045_/A1 VGND VGND VPWR VPWR sky130_fd_sc_hd__diode_2
XTAP_TAPCELL_ROW_55_1132 VGND VPWR sky130_fd_sc_hd__tapvpwrvgnd_1
XTAP_TAPCELL_ROW_55_1121 VGND VPWR sky130_fd_sc_hd__tapvpwrvgnd_1
X_4392_ _4980_/A1 _4392_/A1 _4396_/S VGND VGND VPWR VPWR _4392_/X sky130_fd_sc_hd__mux2_1
XFILLER_97_121 VGND VGND VPWR VPWR sky130_fd_sc_hd__fill_1
XANTENNA__3372__X _4445_/B VGND VGND VPWR VPWR sky130_fd_sc_hd__diode_2
X_3343_ _4997_/A _3343_/B _3343_/C VGND VGND VPWR VPWR _5427_/D sky130_fd_sc_hd__and3_1
X_6062_ _6248_/CLK _6062_/D VGND VGND VPWR VPWR _6062_/Q sky130_fd_sc_hd__dfxtp_1
Xhold1006 _4900_/X VGND VGND VPWR VPWR _6248_/D sky130_fd_sc_hd__dlygate4sd3_1
XANTENNA__4467__A0 _5811_/Q VGND VGND VPWR VPWR sky130_fd_sc_hd__diode_2
XFILLER_98_699 VGND VGND VPWR VPWR sky130_fd_sc_hd__fill_1
X_3274_ _4663_/A _3270_/B _3273_/Y VGND VGND VPWR VPWR _5399_/D sky130_fd_sc_hd__o21a_1
Xhold1039 _2676_/X VGND VGND VPWR VPWR _5249_/D sky130_fd_sc_hd__dlygate4sd3_1
XANTENNA__4562__S0 _4773_/S VGND VGND VPWR VPWR sky130_fd_sc_hd__diode_2
Xhold1028 _5470_/Q VGND VGND VPWR VPWR _4618_/A0 sky130_fd_sc_hd__dlygate4sd3_1
X_5013_ _5029_/B _5110_/A _5013_/C VGND VGND VPWR VPWR _5013_/Y sky130_fd_sc_hd__nor3_1
Xhold1017 _4349_/X VGND VGND VPWR VPWR _5992_/D sky130_fd_sc_hd__dlygate4sd3_1
XANTENNA__3690__A1 _4484_/A0 VGND VGND VPWR VPWR sky130_fd_sc_hd__diode_2
XFILLER_93_393 VGND VGND VPWR VPWR sky130_fd_sc_hd__fill_1
Xclkbuf_leaf_18_clk clkload3/A VGND VGND VPWR VPWR _6172_/CLK sky130_fd_sc_hd__clkbuf_8
XPHY_EDGE_ROW_5_Right_5 VGND VGND VPWR VPWR sky130_fd_sc_hd__decap_3
XANTENNA_fanout167_A _4257_/S VGND VGND VPWR VPWR sky130_fd_sc_hd__diode_2
XANTENNA__3442__A1 _4846_/A0 VGND VGND VPWR VPWR sky130_fd_sc_hd__diode_2
XFILLER_81_577 VGND VGND VPWR VPWR sky130_fd_sc_hd__fill_1
X_5915_ _6422_/CLK _5915_/D VGND VGND VPWR VPWR _5915_/Q sky130_fd_sc_hd__dfxtp_2
X_5846_ _5849_/CLK _5846_/D VGND VGND VPWR VPWR _5846_/Q sky130_fd_sc_hd__dfxtp_1
XTAP_TAPCELL_ROW_66_1294 VGND VPWR sky130_fd_sc_hd__tapvpwrvgnd_1
XTAP_TAPCELL_ROW_66_1283 VGND VPWR sky130_fd_sc_hd__tapvpwrvgnd_1
XFILLER_34_471 VGND VGND VPWR VPWR sky130_fd_sc_hd__fill_2
X_2989_ _5545_/Q _5569_/Q _3077_/S VGND VGND VPWR VPWR _2990_/B sky130_fd_sc_hd__mux2_1
X_5777_ _6316_/CLK _5777_/D VGND VGND VPWR VPWR _5777_/Q sky130_fd_sc_hd__dfxtp_1
XANTENNA__3694__S _3698_/S VGND VGND VPWR VPWR sky130_fd_sc_hd__diode_2
XFILLER_22_699 VGND VGND VPWR VPWR sky130_fd_sc_hd__fill_1
XANTENNA_fanout122_X _5237_/A0 VGND VGND VPWR VPWR sky130_fd_sc_hd__diode_2
X_4728_ _4715_/X _4727_/X _5401_/Q VGND VGND VPWR VPWR _4728_/X sky130_fd_sc_hd__mux2_1
XFILLER_108_749 VGND VGND VPWR VPWR sky130_fd_sc_hd__fill_4
XFILLER_107_215 VGND VGND VPWR VPWR sky130_fd_sc_hd__fill_1
X_4659_ _4791_/B1 _4658_/X _4655_/Y _4657_/Y VGND VGND VPWR VPWR _4660_/B sky130_fd_sc_hd__o2bb2a_1
XFILLER_135_557 VGND VGND VPWR VPWR sky130_fd_sc_hd__fill_2
XFILLER_116_793 VPWR VGND VPWR VGND sky130_ef_sc_hd__decap_40_12
XFILLER_89_600 VGND VGND VPWR VPWR sky130_fd_sc_hd__fill_2
Xhold862 _3188_/X VGND VGND VPWR VPWR _5351_/D sky130_fd_sc_hd__dlygate4sd3_1
Xhold851 _5581_/Q VGND VGND VPWR VPWR hold851/X sky130_fd_sc_hd__dlygate4sd3_1
Xhold873 _5448_/Q VGND VGND VPWR VPWR hold873/X sky130_fd_sc_hd__dlygate4sd3_1
Xhold840 _4928_/X VGND VGND VPWR VPWR _6265_/D sky130_fd_sc_hd__dlygate4sd3_1
XFILLER_131_741 VPWR VGND VPWR VGND sky130_ef_sc_hd__decap_40_12
Xhold895 _3206_/X VGND VGND VPWR VPWR _5368_/D sky130_fd_sc_hd__dlygate4sd3_1
Xhold884 _5871_/Q VGND VGND VPWR VPWR hold884/X sky130_fd_sc_hd__dlygate4sd3_1
X_6329_ _6417_/CLK _6329_/D VGND VGND VPWR VPWR _6329_/Q sky130_fd_sc_hd__dfxtp_2
XFILLER_1_559 VGND VGND VPWR VPWR sky130_fd_sc_hd__fill_1
XFILLER_131_785 VPWR VGND VPWR VGND sky130_ef_sc_hd__decap_40_12
Xhold2230 _5818_/Q VGND VGND VPWR VPWR hold2230/X sky130_fd_sc_hd__dlygate4sd3_1
XFILLER_77_839 VGND VGND VPWR VPWR sky130_fd_sc_hd__fill_1
XANTENNA__4458__B1 _4427_/B VGND VGND VPWR VPWR sky130_fd_sc_hd__diode_2
Xhold2252 _5253_/Q VGND VGND VPWR VPWR _3464_/B sky130_fd_sc_hd__dlygate4sd3_1
Xhold2241 _5385_/Q VGND VGND VPWR VPWR _3585_/A sky130_fd_sc_hd__dlygate4sd3_1
XFILLER_92_809 VGND VGND VPWR VPWR sky130_fd_sc_hd__fill_2
Xhold1551 _5667_/Q VGND VGND VPWR VPWR _3640_/A0 sky130_fd_sc_hd__dlygate4sd3_1
Xhold1540 _3720_/X VGND VGND VPWR VPWR _5738_/D sky130_fd_sc_hd__dlygate4sd3_1
XTAP_TAPCELL_ROW_4_364 VGND VPWR sky130_fd_sc_hd__tapvpwrvgnd_1
XTAP_TAPCELL_ROW_4_353 VGND VPWR sky130_fd_sc_hd__tapvpwrvgnd_1
Xhold1562 _5693_/Q VGND VGND VPWR VPWR _3670_/A1 sky130_fd_sc_hd__dlygate4sd3_1
Xhold1595 _4959_/X VGND VGND VPWR VPWR _6293_/D sky130_fd_sc_hd__dlygate4sd3_1
XANTENNA__3869__S _3869_/S VGND VGND VPWR VPWR sky130_fd_sc_hd__diode_2
Xhold1573 _3893_/X VGND VGND VPWR VPWR _5872_/D sky130_fd_sc_hd__dlygate4sd3_1
Xhold1584 _6066_/Q VGND VGND VPWR VPWR _4455_/A1 sky130_fd_sc_hd__dlygate4sd3_1
XFILLER_45_725 VGND VGND VPWR VPWR sky130_fd_sc_hd__fill_1
XFILLER_17_405 VPWR VGND VPWR VGND sky130_ef_sc_hd__decap_40_12
XFILLER_17_449 VPWR VGND VPWR VGND sky130_ef_sc_hd__decap_40_12
XANTENNA__3433__A1 _4889_/A1 VGND VGND VPWR VPWR sky130_fd_sc_hd__diode_2
XFILLER_16_40 VGND VGND VPWR VPWR sky130_fd_sc_hd__fill_2
XFILLER_32_408 VGND VGND VPWR VPWR sky130_fd_sc_hd__fill_1
XTAP_TAPCELL_ROW_43_948 VGND VPWR sky130_fd_sc_hd__tapvpwrvgnd_1
XFILLER_9_615 VGND VGND VPWR VPWR sky130_fd_sc_hd__fill_1
XTAP_TAPCELL_ROW_23_650 VGND VPWR sky130_fd_sc_hd__tapvpwrvgnd_1
XANTENNA__5186__A1 _3958_/A VGND VGND VPWR VPWR sky130_fd_sc_hd__diode_2
XANTENNA__4933__A1 _4983_/A1 VGND VGND VPWR VPWR sky130_fd_sc_hd__diode_2
XFILLER_32_83 VGND VGND VPWR VPWR sky130_fd_sc_hd__fill_1
XFILLER_126_513 VPWR VGND VPWR VGND sky130_ef_sc_hd__decap_40_12
XTAP_TAPCELL_ROW_97_1755 VGND VPWR sky130_fd_sc_hd__tapvpwrvgnd_1
XFILLER_5_821 VPWR VGND VPWR VGND sky130_ef_sc_hd__decap_40_12
XFILLER_126_557 VPWR VGND VPWR VGND sky130_ef_sc_hd__decap_40_12
XFILLER_4_331 VPWR VGND VPWR VGND sky130_ef_sc_hd__decap_40_12
XANTENNA__2948__S _3062_/S VGND VGND VPWR VPWR sky130_fd_sc_hd__diode_2
XFILLER_68_817 VGND VGND VPWR VPWR sky130_fd_sc_hd__fill_2
XFILLER_67_305 VGND VGND VPWR VPWR sky130_fd_sc_hd__fill_1
XTAP_TAPCELL_ROW_128_2221 VGND VPWR sky130_fd_sc_hd__tapvpwrvgnd_1
XANTENNA__4449__B1 _4445_/B VGND VGND VPWR VPWR sky130_fd_sc_hd__diode_2
XFILLER_95_669 VGND VGND VPWR VPWR sky130_fd_sc_hd__fill_2
XFILLER_83_809 VPWR VGND VPWR VGND sky130_ef_sc_hd__decap_40_12
XTAP_TAPCELL_ROW_50_1051 VGND VPWR sky130_fd_sc_hd__tapvpwrvgnd_1
XFILLER_63_511 VGND VGND VPWR VPWR sky130_fd_sc_hd__fill_1
XFILLER_35_213 VGND VGND VPWR VPWR sky130_fd_sc_hd__fill_2
XFILLER_75_393 VGND VGND VPWR VPWR sky130_fd_sc_hd__fill_8
XFILLER_36_747 VGND VGND VPWR VPWR sky130_fd_sc_hd__fill_4
X_3961_ _5003_/A _5003_/B VGND VGND VPWR VPWR _5006_/B sky130_fd_sc_hd__or2_1
XFILLER_35_279 VGND VGND VPWR VPWR sky130_fd_sc_hd__fill_1
X_2912_ _6074_/Q _6366_/Q _2984_/S VGND VGND VPWR VPWR _2913_/B sky130_fd_sc_hd__mux2_1
XTAP_TAPCELL_ROW_106_1895 VGND VPWR sky130_fd_sc_hd__tapvpwrvgnd_1
XTAP_TAPCELL_ROW_106_1884 VGND VPWR sky130_fd_sc_hd__tapvpwrvgnd_1
X_5700_ _6122_/CLK _5700_/D VGND VGND VPWR VPWR _5700_/Q sky130_fd_sc_hd__dfxtp_1
X_3892_ hold884/X _4515_/A1 _3899_/S VGND VGND VPWR VPWR _3892_/X sky130_fd_sc_hd__mux2_1
XTAP_TAPCELL_ROW_21_609 VGND VPWR sky130_fd_sc_hd__tapvpwrvgnd_1
X_2843_ _3005_/A _2843_/B VGND VGND VPWR VPWR _2843_/X sky130_fd_sc_hd__or2_1
XANTENNA__3367__X _4457_/S VGND VGND VPWR VPWR sky130_fd_sc_hd__diode_2
X_5631_ _6388_/CLK _5631_/D VGND VGND VPWR VPWR _5631_/Q sky130_fd_sc_hd__dfxtp_1
XFILLER_31_485 VGND VGND VPWR VPWR sky130_fd_sc_hd__fill_2
X_5562_ _6438_/CLK _5562_/D VGND VGND VPWR VPWR _5562_/Q sky130_fd_sc_hd__dfxtp_1
X_2774_ _6231_/Q _6207_/Q _3091_/S VGND VGND VPWR VPWR _2775_/B sky130_fd_sc_hd__mux2_1
XANTENNA__4403__S _4406_/S VGND VGND VPWR VPWR sky130_fd_sc_hd__diode_2
XANTENNA__2935__B1 _3027_/A VGND VGND VPWR VPWR sky130_fd_sc_hd__diode_2
X_4513_ _4513_/A _4513_/B VGND VGND VPWR VPWR _4522_/S sky130_fd_sc_hd__nor2_4
XFILLER_8_681 VPWR VGND VPWR VGND sky130_ef_sc_hd__decap_40_12
XANTENNA__3019__S _3077_/S VGND VGND VPWR VPWR sky130_fd_sc_hd__diode_2
XFILLER_117_557 VGND VGND VPWR VPWR sky130_fd_sc_hd__fill_2
X_5493_ _6146_/CLK hold13/X VGND VGND VPWR VPWR hold12/A sky130_fd_sc_hd__dfxtp_1
Xhold103 _5490_/Q VGND VGND VPWR VPWR hold103/X sky130_fd_sc_hd__dlygate4sd3_1
Xhold125 _5804_/Q VGND VGND VPWR VPWR hold125/X sky130_fd_sc_hd__dlygate4sd3_1
Xhold114 _3637_/X VGND VGND VPWR VPWR _5665_/D sky130_fd_sc_hd__dlygate4sd3_1
X_4444_ hold278/X _4443_/X _4457_/S VGND VGND VPWR VPWR _4444_/X sky130_fd_sc_hd__mux2_1
Xhold147 _5644_/Q VGND VGND VPWR VPWR hold147/X sky130_fd_sc_hd__dlygate4sd3_1
Xclkbuf_leaf_7_clk clkbuf_leaf_9_clk/A VGND VGND VPWR VPWR _6342_/CLK sky130_fd_sc_hd__clkbuf_8
Xhold158 _4296_/X VGND VGND VPWR VPWR _5946_/D sky130_fd_sc_hd__dlygate4sd3_1
Xhold136 _3647_/X VGND VGND VPWR VPWR _5674_/D sky130_fd_sc_hd__dlygate4sd3_1
XFILLER_113_741 VPWR VGND VPWR VGND sky130_ef_sc_hd__decap_40_12
Xhold169 _5935_/Q VGND VGND VPWR VPWR hold169/X sky130_fd_sc_hd__dlygate4sd3_1
X_4375_ _5046_/A1 _4375_/A1 _4376_/S VGND VGND VPWR VPWR _4375_/X sky130_fd_sc_hd__mux2_1
XFILLER_113_785 VPWR VGND VPWR VGND sky130_ef_sc_hd__decap_40_12
XFILLER_86_614 VGND VGND VPWR VPWR sky130_fd_sc_hd__fill_1
X_3326_ _4002_/A _4002_/B _5329_/Q VGND VGND VPWR VPWR _3326_/X sky130_fd_sc_hd__or3b_2
XFILLER_59_839 VGND VGND VPWR VPWR sky130_fd_sc_hd__fill_1
X_6114_ _6114_/CLK _6114_/D VGND VGND VPWR VPWR _6114_/Q sky130_fd_sc_hd__dfxtp_1
XANTENNA__3360__B1 _5201_/B VGND VGND VPWR VPWR sky130_fd_sc_hd__diode_2
XFILLER_85_124 VGND VGND VPWR VPWR sky130_fd_sc_hd__fill_1
X_6045_ _6409_/CLK _6045_/D VGND VGND VPWR VPWR _6045_/Q sky130_fd_sc_hd__dfxtp_1
X_3257_ _3352_/A1 _5925_/Q _3258_/S VGND VGND VPWR VPWR _3257_/X sky130_fd_sc_hd__mux2_1
XANTENNA__4860__A0 _4886_/A1 VGND VGND VPWR VPWR sky130_fd_sc_hd__diode_2
X_3188_ hold861/X _5232_/A0 _3193_/S VGND VGND VPWR VPWR _3188_/X sky130_fd_sc_hd__mux2_1
XTAP_TAPCELL_ROW_68_1323 VGND VPWR sky130_fd_sc_hd__tapvpwrvgnd_1
XFILLER_66_360 VGND VGND VPWR VPWR sky130_fd_sc_hd__fill_4
XTAP_TAPCELL_ROW_1_312 VGND VPWR sky130_fd_sc_hd__tapvpwrvgnd_1
XFILLER_39_563 VGND VGND VPWR VPWR sky130_fd_sc_hd__fill_1
XFILLER_14_419 VGND VGND VPWR VPWR sky130_fd_sc_hd__fill_1
XFILLER_26_268 VGND VGND VPWR VPWR sky130_fd_sc_hd__fill_1
XTAP_TAPCELL_ROW_81_1512 VGND VPWR sky130_fd_sc_hd__tapvpwrvgnd_1
XANTENNA__3415__A1 _5208_/A1 VGND VGND VPWR VPWR sky130_fd_sc_hd__diode_2
XTAP_TAPCELL_ROW_40_907 VGND VPWR sky130_fd_sc_hd__tapvpwrvgnd_1
X_5829_ _6338_/CLK _5829_/D VGND VGND VPWR VPWR _5829_/Q sky130_fd_sc_hd__dfxtp_1
XFILLER_10_625 VPWR VGND VPWR VGND sky130_ef_sc_hd__decap_40_12
XFILLER_136_811 VGND VGND VPWR VPWR sky130_fd_sc_hd__fill_1
XFILLER_10_669 VPWR VGND VPWR VGND sky130_ef_sc_hd__decap_40_12
XFILLER_108_557 VPWR VGND VPWR VGND sky130_ef_sc_hd__decap_40_12
XTAP_TAPCELL_ROW_79_1485 VGND VPWR sky130_fd_sc_hd__tapvpwrvgnd_1
XFILLER_123_505 VPWR VGND VPWR VGND sky130_ef_sc_hd__decap_40_12
XANTENNA__3026__S0 _2963_/S VGND VGND VPWR VPWR sky130_fd_sc_hd__diode_2
XTAP_TAPCELL_ROW_9_434 VGND VPWR sky130_fd_sc_hd__tapvpwrvgnd_1
XFILLER_2_813 VPWR VGND VPWR VGND sky130_ef_sc_hd__decap_40_12
Xhold670 _3197_/X VGND VGND VPWR VPWR _5359_/D sky130_fd_sc_hd__dlygate4sd3_1
XFILLER_1_334 VGND VGND VPWR VPWR sky130_fd_sc_hd__fill_2
Xhold681 _6023_/Q VGND VGND VPWR VPWR hold681/X sky130_fd_sc_hd__dlygate4sd3_1
XANTENNA__4644__A1_N _4811_/C1 VGND VGND VPWR VPWR sky130_fd_sc_hd__diode_2
Xhold692 _5510_/Q VGND VGND VPWR VPWR hold692/X sky130_fd_sc_hd__dlygate4sd3_1
XTAP_TAPCELL_ROW_92_1685 VGND VPWR sky130_fd_sc_hd__tapvpwrvgnd_1
XTAP_TAPCELL_ROW_92_1674 VGND VPWR sky130_fd_sc_hd__tapvpwrvgnd_1
XFILLER_49_305 VGND VGND VPWR VPWR sky130_fd_sc_hd__fill_4
XFILLER_134_41 VGND VGND VPWR VPWR sky130_fd_sc_hd__fill_8
XANTENNA__4983__S _4984_/S VGND VGND VPWR VPWR sky130_fd_sc_hd__diode_2
XFILLER_1_378 VGND VGND VPWR VPWR sky130_fd_sc_hd__fill_1
XANTENNA__3172__B _3172_/B VGND VGND VPWR VPWR sky130_fd_sc_hd__diode_2
XANTENNA__4659__A1_N _4791_/B1 VGND VGND VPWR VPWR sky130_fd_sc_hd__diode_2
Xhold2071 _5064_/X VGND VGND VPWR VPWR _6356_/D sky130_fd_sc_hd__dlygate4sd3_1
Xhold2060 _6355_/Q VGND VGND VPWR VPWR _3320_/B sky130_fd_sc_hd__dlygate4sd3_1
XFILLER_65_809 VPWR VGND VPWR VGND sky130_ef_sc_hd__decap_40_12
XANTENNA__4851__A0 _5813_/Q VGND VGND VPWR VPWR sky130_fd_sc_hd__diode_2
Xhold1370 _5258_/Q VGND VGND VPWR VPWR _2710_/A1 sky130_fd_sc_hd__dlygate4sd3_1
Xhold2082 _3962_/Y VGND VGND VPWR VPWR _5201_/C sky130_fd_sc_hd__dlygate4sd3_1
XFILLER_18_725 VPWR VGND VPWR VGND sky130_ef_sc_hd__decap_40_12
XANTENNA__3654__A1 _5213_/A1 VGND VGND VPWR VPWR sky130_fd_sc_hd__diode_2
Xhold2093 _3129_/Y VGND VGND VPWR VPWR _5320_/D sky130_fd_sc_hd__dlygate4sd3_1
XTAP_TAPCELL_ROW_123_2140 VGND VPWR sky130_fd_sc_hd__tapvpwrvgnd_1
XANTENNA_input12_A s_axil_wdata[0] VGND VGND VPWR VPWR sky130_fd_sc_hd__diode_2
XANTENNA_hold1988_X _3278_/A VGND VGND VPWR VPWR sky130_fd_sc_hd__diode_2
XFILLER_57_393 VPWR VGND VPWR VGND sky130_ef_sc_hd__decap_40_12
XFILLER_45_533 VGND VGND VPWR VPWR sky130_fd_sc_hd__fill_2
Xhold1381 _6016_/Q VGND VGND VPWR VPWR _4375_/A1 sky130_fd_sc_hd__dlygate4sd3_1
XFILLER_18_769 VPWR VGND VPWR VGND sky130_ef_sc_hd__decap_40_12
XTAP_TAPCELL_ROW_28_720 VGND VPWR sky130_fd_sc_hd__tapvpwrvgnd_1
Xhold1392 _6055_/Q VGND VGND VPWR VPWR _3162_/A sky130_fd_sc_hd__dlygate4sd3_1
XTAP_TAPCELL_ROW_123_2151 VGND VPWR sky130_fd_sc_hd__tapvpwrvgnd_1
XFILLER_72_363 VGND VGND VPWR VPWR sky130_fd_sc_hd__fill_1
XFILLER_72_352 VGND VGND VPWR VPWR sky130_fd_sc_hd__fill_2
XFILLER_17_268 VGND VGND VPWR VPWR sky130_fd_sc_hd__fill_1
XFILLER_17_279 VGND VGND VPWR VPWR sky130_fd_sc_hd__fill_1
XANTENNA_clkbuf_3_7__f_clk_A clkbuf_0_clk/X VGND VGND VPWR VPWR sky130_fd_sc_hd__diode_2
XFILLER_13_441 VGND VGND VPWR VPWR sky130_fd_sc_hd__fill_4
XFILLER_13_485 VPWR VGND VPWR VGND sky130_ef_sc_hd__decap_40_12
XANTENNA__4223__S _4228_/S VGND VGND VPWR VPWR sky130_fd_sc_hd__diode_2
XFILLER_9_445 VGND VGND VPWR VPWR sky130_fd_sc_hd__fill_2
XFILLER_127_833 VGND VGND VPWR VPWR sky130_fd_sc_hd__fill_4
XFILLER_126_332 VGND VGND VPWR VPWR sky130_fd_sc_hd__fill_2
XFILLER_126_365 VGND VGND VPWR VPWR sky130_fd_sc_hd__fill_1
XFILLER_5_673 VPWR VGND VPWR VGND sky130_ef_sc_hd__decap_40_12
X_4160_ _4271_/S1 _4159_/X _4156_/Y _4158_/Y VGND VGND VPWR VPWR _4160_/X sky130_fd_sc_hd__o2bb2a_1
XFILLER_4_65 VPWR VGND VPWR VGND sky130_ef_sc_hd__decap_40_12
XANTENNA__5054__S _5059_/S VGND VGND VPWR VPWR sky130_fd_sc_hd__diode_2
X_3111_ hold586/X _5080_/A0 _3112_/S VGND VGND VPWR VPWR _3111_/X sky130_fd_sc_hd__mux2_1
XFILLER_95_422 VGND VGND VPWR VPWR sky130_fd_sc_hd__fill_2
XANTENNA__3893__A1 _5210_/A1 VGND VGND VPWR VPWR sky130_fd_sc_hd__diode_2
XFILLER_4_98 VGND VGND VPWR VPWR sky130_fd_sc_hd__fill_1
XFILLER_110_755 VGND VGND VPWR VPWR sky130_fd_sc_hd__fill_1
XANTENNA__4893__S _4893_/S VGND VGND VPWR VPWR sky130_fd_sc_hd__diode_2
XFILLER_56_809 VGND VGND VPWR VPWR sky130_fd_sc_hd__fill_2
X_4091_ _5984_/Q _5975_/Q _4262_/S VGND VGND VPWR VPWR _4091_/X sky130_fd_sc_hd__mux2_1
X_3042_ _5306_/Q _5379_/Q _5367_/Q _6148_/Q _2984_/S _2985_/A VGND VGND VPWR VPWR
+ _3042_/X sky130_fd_sc_hd__mux4_1
XTAP_TAPCELL_ROW_108_1924 VGND VPWR sky130_fd_sc_hd__tapvpwrvgnd_1
XTAP_TAPCELL_ROW_108_1913 VGND VPWR sky130_fd_sc_hd__tapvpwrvgnd_1
XANTENNA__3645__A1 _3926_/A1 VGND VGND VPWR VPWR sky130_fd_sc_hd__diode_2
XFILLER_82_127 VGND VGND VPWR VPWR sky130_fd_sc_hd__fill_1
XFILLER_90_171 VGND VGND VPWR VPWR sky130_fd_sc_hd__fill_2
X_4993_ hold214/X _5047_/A1 _4993_/S VGND VGND VPWR VPWR _4993_/X sky130_fd_sc_hd__mux2_1
XFILLER_23_216 VGND VGND VPWR VPWR sky130_fd_sc_hd__fill_4
X_3944_ _3944_/A _6395_/Q VGND VGND VPWR VPWR _3945_/D sky130_fd_sc_hd__or2_1
XTAP_TAPCELL_ROW_63_1242 VGND VPWR sky130_fd_sc_hd__tapvpwrvgnd_1
XFILLER_32_750 VGND VGND VPWR VPWR sky130_fd_sc_hd__fill_4
X_3875_ _6414_/Q _3875_/A1 _3879_/S VGND VGND VPWR VPWR _3875_/X sky130_fd_sc_hd__mux2_1
X_2826_ _3085_/A _2826_/B VGND VGND VPWR VPWR _2826_/X sky130_fd_sc_hd__and2_1
X_5614_ _6292_/CLK _5614_/D VGND VGND VPWR VPWR _5614_/Q sky130_fd_sc_hd__dfxtp_1
XFILLER_118_811 VGND VGND VPWR VPWR sky130_fd_sc_hd__fill_1
X_2757_ _6423_/Q _5308_/Q _3016_/S VGND VGND VPWR VPWR _2757_/X sky130_fd_sc_hd__mux2_1
X_5545_ _5571_/CLK _5545_/D VGND VGND VPWR VPWR _5545_/Q sky130_fd_sc_hd__dfxtp_1
X_2688_ _2688_/A _3113_/B _4548_/C VGND VGND VPWR VPWR _3208_/A sky130_fd_sc_hd__or3_4
XANTENNA__3008__S0 _3062_/S VGND VGND VPWR VPWR sky130_fd_sc_hd__diode_2
X_5476_ _6290_/CLK _5476_/D VGND VGND VPWR VPWR _5476_/Q sky130_fd_sc_hd__dfxtp_1
X_4427_ _6422_/Q _4427_/B VGND VGND VPWR VPWR _4427_/X sky130_fd_sc_hd__and2_1
XANTENNA__3273__A _3801_/A VGND VGND VPWR VPWR sky130_fd_sc_hd__diode_2
XFILLER_99_783 VGND VGND VPWR VPWR sky130_fd_sc_hd__fill_1
XANTENNA__3884__A1 _5211_/A1 VGND VGND VPWR VPWR sky130_fd_sc_hd__diode_2
XANTENNA_input4_A s_axil_araddr[2] VGND VGND VPWR VPWR sky130_fd_sc_hd__diode_2
XFILLER_48_27 VGND VGND VPWR VPWR sky130_fd_sc_hd__fill_1
X_4358_ hold771/X _5051_/A1 _4366_/S VGND VGND VPWR VPWR _4358_/X sky130_fd_sc_hd__mux2_1
X_3309_ _3975_/A _3973_/B _3964_/B VGND VGND VPWR VPWR _3339_/A sky130_fd_sc_hd__or3b_4
XFILLER_47_809 VPWR VGND VPWR VGND sky130_ef_sc_hd__decap_40_12
X_4289_ hold735/X _5042_/A1 _4294_/S VGND VGND VPWR VPWR _4289_/X sky130_fd_sc_hd__mux2_1
XFILLER_101_777 VGND VGND VPWR VPWR sky130_fd_sc_hd__fill_4
XANTENNA__4833__A0 _4846_/A0 VGND VGND VPWR VPWR sky130_fd_sc_hd__diode_2
X_6028_ _6316_/CLK _6028_/D VGND VGND VPWR VPWR _6028_/Q sky130_fd_sc_hd__dfxtp_1
XANTENNA__3636__A1 _4521_/A1 VGND VGND VPWR VPWR sky130_fd_sc_hd__diode_2
XFILLER_104_55 VGND VGND VPWR VPWR sky130_fd_sc_hd__fill_2
XFILLER_27_522 VGND VGND VPWR VPWR sky130_fd_sc_hd__fill_1
XFILLER_39_393 VGND VGND VPWR VPWR sky130_fd_sc_hd__fill_4
XANTENNA__3212__S _3220_/S VGND VGND VPWR VPWR sky130_fd_sc_hd__diode_2
XANTENNA__4061__A1 _4260_/S VGND VGND VPWR VPWR sky130_fd_sc_hd__diode_2
XFILLER_23_750 VPWR VGND VPWR VGND sky130_ef_sc_hd__decap_40_12
Xfanout64 _2642_/Y VGND VGND VPWR VPWR _3036_/A1 sky130_fd_sc_hd__clkbuf_8
Xfanout75 _2628_/Y VGND VGND VPWR VPWR _4791_/B1 sky130_fd_sc_hd__buf_4
XFILLER_10_433 VPWR VGND VPWR VGND sky130_ef_sc_hd__decap_40_12
Xfanout97 _5830_/Q VGND VGND VPWR VPWR _4983_/A1 sky130_fd_sc_hd__clkbuf_4
Xfanout86 _5210_/A1 VGND VGND VPWR VPWR _4958_/A0 sky130_fd_sc_hd__clkbuf_4
XFILLER_109_833 VGND VGND VPWR VPWR sky130_fd_sc_hd__fill_4
XFILLER_10_477 VPWR VGND VPWR VGND sky130_ef_sc_hd__decap_40_12
XANTENNA__3167__B _4257_/S VGND VGND VPWR VPWR sky130_fd_sc_hd__diode_2
XFILLER_136_641 VGND VGND VPWR VPWR sky130_fd_sc_hd__fill_2
XTAP_TAPCELL_ROW_94_1714 VGND VPWR sky130_fd_sc_hd__tapvpwrvgnd_1
XTAP_TAPCELL_ROW_94_1703 VGND VPWR sky130_fd_sc_hd__tapvpwrvgnd_1
XANTENNA__4978__S _4984_/S VGND VGND VPWR VPWR sky130_fd_sc_hd__diode_2
XFILLER_124_825 VPWR VGND VPWR VGND sky130_ef_sc_hd__decap_40_12
XFILLER_108_365 VGND VGND VPWR VPWR sky130_fd_sc_hd__fill_1
XFILLER_123_335 VGND VGND VPWR VPWR sky130_fd_sc_hd__fill_1
XFILLER_123_313 VGND VGND VPWR VPWR sky130_fd_sc_hd__fill_2
XFILLER_97_709 VPWR VGND VPWR VGND sky130_ef_sc_hd__decap_40_12
XFILLER_2_643 VGND VGND VPWR VPWR sky130_fd_sc_hd__fill_1
XFILLER_77_411 VGND VGND VPWR VPWR sky130_fd_sc_hd__fill_2
XANTENNA__5077__A0 _5233_/A0 VGND VGND VPWR VPWR sky130_fd_sc_hd__diode_2
XANTENNA__4824__A0 _4889_/A1 VGND VGND VPWR VPWR sky130_fd_sc_hd__diode_2
XANTENNA__3627__A1 _5202_/A1 VGND VGND VPWR VPWR sky130_fd_sc_hd__diode_2
XANTENNA__4285__Y _4294_/S VGND VGND VPWR VPWR sky130_fd_sc_hd__diode_2
XFILLER_18_533 VPWR VGND VPWR VGND sky130_ef_sc_hd__decap_40_12
XTAP_TAPCELL_ROW_103_1843 VGND VPWR sky130_fd_sc_hd__tapvpwrvgnd_1
XANTENNA__2961__S _2963_/S VGND VGND VPWR VPWR sky130_fd_sc_hd__diode_2
XANTENNA__4052__A1 _4252_/A1 VGND VGND VPWR VPWR sky130_fd_sc_hd__diode_2
XTAP_TAPCELL_ROW_31_759 VGND VPWR sky130_fd_sc_hd__tapvpwrvgnd_1
XTAP_TAPCELL_ROW_136_2342 VGND VPWR sky130_fd_sc_hd__tapvpwrvgnd_1
X_3660_ _4515_/A1 _3660_/A1 _3667_/S VGND VGND VPWR VPWR _5685_/D sky130_fd_sc_hd__mux2_1
XFILLER_127_641 VPWR VGND VPWR VGND sky130_ef_sc_hd__decap_40_12
XANTENNA__4888__S _4893_/S VGND VGND VPWR VPWR sky130_fd_sc_hd__diode_2
X_3591_ _3591_/A0 _4488_/A0 _3595_/S VGND VGND VPWR VPWR _3591_/X sky130_fd_sc_hd__mux2_1
Xclkload34 _6349_/CLK VGND VGND VPWR VPWR clkload34/Y sky130_fd_sc_hd__bufinv_16
XTAP_TAPCELL_ROW_11_461 VGND VPWR sky130_fd_sc_hd__tapvpwrvgnd_1
XTAP_TAPCELL_ROW_11_472 VGND VPWR sky130_fd_sc_hd__tapvpwrvgnd_1
Xclkload12 _6300_/CLK VGND VGND VPWR VPWR clkload12/Y sky130_fd_sc_hd__clkinv_8
Xclkload23 _5988_/CLK VGND VGND VPWR VPWR clkload23/Y sky130_fd_sc_hd__inv_8
Xclkload78 _6366_/CLK VGND VGND VPWR VPWR clkload78/Y sky130_fd_sc_hd__clkinv_2
XFILLER_127_685 VPWR VGND VPWR VGND sky130_ef_sc_hd__decap_40_12
XANTENNA__3563__A0 _4964_/A0 VGND VGND VPWR VPWR sky130_fd_sc_hd__diode_2
X_5330_ _6172_/CLK _5330_/D VGND VGND VPWR VPWR _5330_/Q sky130_fd_sc_hd__dfxtp_1
Xclkload67 _6261_/CLK VGND VGND VPWR VPWR clkload67/Y sky130_fd_sc_hd__inv_6
Xclkload56 _6097_/CLK VGND VGND VPWR VPWR clkload56/Y sky130_fd_sc_hd__clkinv_2
Xclkload45 _6122_/CLK VGND VGND VPWR VPWR clkload45/X sky130_fd_sc_hd__clkbuf_4
XFILLER_126_195 VGND VGND VPWR VPWR sky130_fd_sc_hd__fill_1
Xclkload89 _6222_/CLK VGND VGND VPWR VPWR clkload89/Y sky130_fd_sc_hd__inv_6
XANTENNA_clkbuf_leaf_53_clk_A clkload6/A VGND VGND VPWR VPWR sky130_fd_sc_hd__diode_2
X_5261_ clkload9/A _5261_/D VGND VGND VPWR VPWR _5261_/Q sky130_fd_sc_hd__dfxtp_1
X_4212_ _4212_/A _4212_/B VGND VGND VPWR VPWR _4212_/Y sky130_fd_sc_hd__nor2_1
X_5192_ _3958_/A _5190_/X _5191_/Y _5175_/S VGND VGND VPWR VPWR _5192_/X sky130_fd_sc_hd__o211a_1
XFILLER_96_753 VGND VGND VPWR VPWR sky130_fd_sc_hd__fill_2
X_4143_ _4252_/A1 _4142_/X _3172_/B VGND VGND VPWR VPWR _4143_/Y sky130_fd_sc_hd__o21ai_1
XFILLER_29_809 VPWR VGND VPWR VGND sky130_ef_sc_hd__decap_40_12
XFILLER_110_585 VGND VGND VPWR VPWR sky130_fd_sc_hd__fill_2
XFILLER_83_414 VGND VGND VPWR VPWR sky130_fd_sc_hd__fill_1
XANTENNA_clkbuf_leaf_68_clk_A clkload5/A VGND VGND VPWR VPWR sky130_fd_sc_hd__diode_2
X_4074_ _4271_/S1 _4073_/X _4070_/Y _4072_/Y VGND VGND VPWR VPWR _4074_/X sky130_fd_sc_hd__o2bb2a_1
X_3025_ _3018_/X _3024_/X _3083_/S VGND VGND VPWR VPWR _3025_/X sky130_fd_sc_hd__mux2_1
XANTENNA_clkbuf_leaf_111_clk_A clkload0/A VGND VGND VPWR VPWR sky130_fd_sc_hd__diode_2
XANTENNA__4291__A1 _4981_/A1 VGND VGND VPWR VPWR sky130_fd_sc_hd__diode_2
XTAP_TAPCELL_ROW_19_583 VGND VPWR sky130_fd_sc_hd__tapvpwrvgnd_1
XFILLER_34_18 VGND VGND VPWR VPWR sky130_fd_sc_hd__fill_2
XFILLER_51_333 VGND VGND VPWR VPWR sky130_fd_sc_hd__fill_2
XFILLER_34_29 VGND VGND VPWR VPWR sky130_fd_sc_hd__fill_2
X_4976_ hold349/X _4976_/A1 _4984_/S VGND VGND VPWR VPWR _4976_/X sky130_fd_sc_hd__mux2_1
XANTENNA__3268__A _3801_/A VGND VGND VPWR VPWR sky130_fd_sc_hd__diode_2
X_3927_ hold964/X _4521_/A1 _3928_/S VGND VGND VPWR VPWR _3927_/X sky130_fd_sc_hd__mux2_1
Xclkload6 clkload6/A VGND VGND VPWR VPWR clkload6/Y sky130_fd_sc_hd__inv_12
X_3858_ hold2150/X _3857_/X _3835_/S _4451_/A VGND VGND VPWR VPWR _3858_/X sky130_fd_sc_hd__o2bb2a_1
XFILLER_20_753 VGND VGND VPWR VPWR sky130_fd_sc_hd__fill_2
XFILLER_137_449 VPWR VGND VPWR VGND sky130_ef_sc_hd__decap_40_12
XFILLER_118_641 VGND VGND VPWR VPWR sky130_fd_sc_hd__fill_2
X_2809_ _2967_/S _2808_/X _2802_/Y _2735_/A VGND VGND VPWR VPWR _2809_/Y sky130_fd_sc_hd__o211ai_1
X_3789_ hold733/X _5208_/A1 _3797_/S VGND VGND VPWR VPWR _3789_/X sky130_fd_sc_hd__mux2_1
X_5528_ _6438_/CLK _5528_/D VGND VGND VPWR VPWR _5528_/Q sky130_fd_sc_hd__dfxtp_1
XFILLER_106_825 VPWR VGND VPWR VGND sky130_ef_sc_hd__decap_40_12
XANTENNA__2900__A _3005_/A VGND VGND VPWR VPWR sky130_fd_sc_hd__diode_2
XTAP_TAPCELL_ROW_76_1433 VGND VPWR sky130_fd_sc_hd__tapvpwrvgnd_1
XANTENNA_fanout202_X _5034_/B VGND VGND VPWR VPWR sky130_fd_sc_hd__diode_2
XTAP_TAPCELL_ROW_76_1444 VGND VPWR sky130_fd_sc_hd__tapvpwrvgnd_1
X_5459_ _5908_/CLK _5459_/D VGND VGND VPWR VPWR _5459_/Q sky130_fd_sc_hd__dfxtp_1
XFILLER_121_839 VGND VGND VPWR VPWR sky130_fd_sc_hd__fill_1
XFILLER_101_541 VPWR VGND VPWR VGND sky130_ef_sc_hd__decap_40_12
XFILLER_87_753 VPWR VGND VPWR VGND sky130_ef_sc_hd__decap_40_12
XFILLER_86_230 VGND VGND VPWR VPWR sky130_fd_sc_hd__fill_1
XFILLER_101_585 VPWR VGND VPWR VGND sky130_ef_sc_hd__decap_40_12
XFILLER_87_797 VPWR VGND VPWR VGND sky130_ef_sc_hd__decap_40_12
XFILLER_47_639 VGND VGND VPWR VPWR sky130_fd_sc_hd__fill_1
XFILLER_47_617 VGND VGND VPWR VPWR sky130_fd_sc_hd__fill_2
XANTENNA_fanout62_A _2642_/Y VGND VGND VPWR VPWR sky130_fd_sc_hd__diode_2
XANTENNA__3609__A1 _5209_/A1 VGND VGND VPWR VPWR sky130_fd_sc_hd__diode_2
XFILLER_74_469 VGND VGND VPWR VPWR sky130_fd_sc_hd__fill_4
XANTENNA__4282__A1 _5045_/A1 VGND VGND VPWR VPWR sky130_fd_sc_hd__diode_2
XFILLER_15_503 VGND VGND VPWR VPWR sky130_fd_sc_hd__fill_1
XFILLER_55_694 VGND VGND VPWR VPWR sky130_fd_sc_hd__fill_1
XFILLER_27_374 VGND VGND VPWR VPWR sky130_fd_sc_hd__fill_2
XTAP_TAPCELL_ROW_38_870 VGND VPWR sky130_fd_sc_hd__tapvpwrvgnd_1
XANTENNA__5231__A0 _5810_/Q VGND VGND VPWR VPWR sky130_fd_sc_hd__diode_2
XFILLER_54_193 VGND VGND VPWR VPWR sky130_fd_sc_hd__fill_2
XFILLER_42_344 VGND VGND VPWR VPWR sky130_fd_sc_hd__fill_2
XANTENNA__5808__D _5808_/D VGND VGND VPWR VPWR sky130_fd_sc_hd__diode_2
XFILLER_24_62 VGND VGND VPWR VPWR sky130_fd_sc_hd__fill_2
XFILLER_6_201 VGND VGND VPWR VPWR sky130_fd_sc_hd__fill_2
XFILLER_11_753 VPWR VGND VPWR VGND sky130_ef_sc_hd__decap_40_12
XFILLER_24_95 VGND VGND VPWR VPWR sky130_fd_sc_hd__fill_2
XTAP_TAPCELL_ROW_118_2072 VGND VPWR sky130_fd_sc_hd__tapvpwrvgnd_1
XFILLER_11_797 VPWR VGND VPWR VGND sky130_ef_sc_hd__decap_40_12
XFILLER_136_460 VPWR VGND VPWR VGND sky130_ef_sc_hd__decap_40_12
XANTENNA__3465__X _3477_/S VGND VGND VPWR VPWR sky130_fd_sc_hd__diode_2
XFILLER_109_685 VPWR VGND VPWR VGND sky130_ef_sc_hd__decap_40_12
XFILLER_40_83 VGND VGND VPWR VPWR sky130_fd_sc_hd__fill_1
XTAP_TAPCELL_ROW_131_2272 VGND VPWR sky130_fd_sc_hd__tapvpwrvgnd_1
XTAP_TAPCELL_ROW_131_2261 VGND VPWR sky130_fd_sc_hd__tapvpwrvgnd_1
XFILLER_124_699 VGND VGND VPWR VPWR sky130_fd_sc_hd__fill_1
XFILLER_97_528 VPWR VGND VPWR VGND sky130_ef_sc_hd__decap_40_12
XFILLER_2_473 VGND VGND VPWR VPWR sky130_fd_sc_hd__fill_2
XANTENNA__2956__S _3091_/S VGND VGND VPWR VPWR sky130_fd_sc_hd__diode_2
XANTENNA__4737__A _4794_/A VGND VGND VPWR VPWR sky130_fd_sc_hd__diode_2
XFILLER_77_241 VGND VGND VPWR VPWR sky130_fd_sc_hd__fill_2
XFILLER_80_439 VGND VGND VPWR VPWR sky130_fd_sc_hd__fill_1
XFILLER_80_417 VGND VGND VPWR VPWR sky130_fd_sc_hd__fill_2
XTAP_TAPCELL_ROW_47_1012 VGND VPWR sky130_fd_sc_hd__tapvpwrvgnd_1
XTAP_TAPCELL_ROW_47_1001 VGND VPWR sky130_fd_sc_hd__tapvpwrvgnd_1
X_4830_ _5238_/A1 _4830_/A1 _4841_/S VGND VGND VPWR VPWR _4830_/X sky130_fd_sc_hd__mux2_1
XTAP_TAPCELL_ROW_16_542 VGND VPWR sky130_fd_sc_hd__tapvpwrvgnd_1
XTAP_TAPCELL_ROW_60_1201 VGND VPWR sky130_fd_sc_hd__tapvpwrvgnd_1
XFILLER_21_517 VPWR VGND VPWR VGND sky130_ef_sc_hd__decap_40_12
X_4761_ _5655_/Q _5673_/Q _4808_/S VGND VGND VPWR VPWR _4761_/X sky130_fd_sc_hd__mux2_1
X_3712_ _4104_/A0 _4929_/A1 _3717_/S VGND VGND VPWR VPWR _3712_/X sky130_fd_sc_hd__mux2_1
X_4692_ hold49/A _5892_/Q _4801_/S VGND VGND VPWR VPWR _4692_/X sky130_fd_sc_hd__mux2_1
XFILLER_119_449 VGND VGND VPWR VPWR sky130_fd_sc_hd__fill_4
X_6431_ _6434_/CLK _6431_/D VGND VGND VPWR VPWR _6431_/Q sky130_fd_sc_hd__dfxtp_1
Xclkload101 _6238_/CLK VGND VGND VPWR VPWR clkload101/Y sky130_fd_sc_hd__clkinv_4
X_3643_ hold63/X _4488_/A0 _3647_/S VGND VGND VPWR VPWR hold64/A sky130_fd_sc_hd__mux2_1
X_6362_ _6366_/CLK _6362_/D VGND VGND VPWR VPWR _6362_/Q sky130_fd_sc_hd__dfxtp_1
XANTENNA__4411__S _4416_/S VGND VGND VPWR VPWR sky130_fd_sc_hd__diode_2
X_5313_ _6365_/CLK _5313_/D VGND VGND VPWR VPWR _5313_/Q sky130_fd_sc_hd__dfxtp_1
X_3574_ hold631/X _4964_/A0 _3574_/S VGND VGND VPWR VPWR _3574_/X sky130_fd_sc_hd__mux2_1
XFILLER_114_154 VGND VGND VPWR VPWR sky130_fd_sc_hd__fill_1
X_6293_ _6298_/CLK _6293_/D VGND VGND VPWR VPWR _6293_/Q sky130_fd_sc_hd__dfxtp_1
XTAP_TAPCELL_ROW_58_1174 VGND VPWR sky130_fd_sc_hd__tapvpwrvgnd_1
XTAP_TAPCELL_ROW_58_1163 VGND VPWR sky130_fd_sc_hd__tapvpwrvgnd_1
XFILLER_130_625 VPWR VGND VPWR VGND sky130_ef_sc_hd__decap_40_12
X_5244_ _5571_/CLK _5244_/D VGND VGND VPWR VPWR _5244_/Q sky130_fd_sc_hd__dfxtp_1
XFILLER_103_839 VGND VGND VPWR VPWR sky130_fd_sc_hd__fill_1
XFILLER_130_669 VPWR VGND VPWR VGND sky130_ef_sc_hd__decap_40_12
X_5175_ _5173_/A _5174_/X _5175_/S VGND VGND VPWR VPWR _5176_/B sky130_fd_sc_hd__mux2_1
XTAP_TAPCELL_ROW_71_1363 VGND VPWR sky130_fd_sc_hd__tapvpwrvgnd_1
Xhold18 hold18/A VGND VGND VPWR VPWR hold18/X sky130_fd_sc_hd__dlygate4sd3_1
Xhold29 hold29/A VGND VGND VPWR VPWR hold29/X sky130_fd_sc_hd__dlygate4sd3_1
XANTENNA_fanout197_A _3033_/S VGND VGND VPWR VPWR sky130_fd_sc_hd__diode_2
Xhold1925 _5336_/Q VGND VGND VPWR VPWR _5066_/A0 sky130_fd_sc_hd__dlygate4sd3_1
XFILLER_69_797 VGND VGND VPWR VPWR sky130_fd_sc_hd__fill_1
Xhold1936 _4437_/X VGND VGND VPWR VPWR _6060_/D sky130_fd_sc_hd__dlygate4sd3_1
Xhold1914 _4957_/X VGND VGND VPWR VPWR _6291_/D sky130_fd_sc_hd__dlygate4sd3_1
Xhold1903 _4950_/X VGND VGND VPWR VPWR _6285_/D sky130_fd_sc_hd__dlygate4sd3_1
X_4126_ _4212_/A _4126_/B VGND VGND VPWR VPWR _4126_/Y sky130_fd_sc_hd__nor2_1
Xhold1958 _5534_/Q VGND VGND VPWR VPWR _3488_/A0 sky130_fd_sc_hd__dlygate4sd3_1
Xhold1947 _5852_/Q VGND VGND VPWR VPWR _3871_/A1 sky130_fd_sc_hd__dlygate4sd3_1
XFILLER_68_296 VGND VGND VPWR VPWR sky130_fd_sc_hd__fill_2
Xhold1969 _4433_/X VGND VGND VPWR VPWR _6059_/D sky130_fd_sc_hd__dlygate4sd3_1
X_4057_ _4252_/A1 _4056_/X _3172_/B VGND VGND VPWR VPWR _4057_/Y sky130_fd_sc_hd__o21ai_1
XANTENNA__4264__A1 _4264_/A1 VGND VGND VPWR VPWR sky130_fd_sc_hd__diode_2
X_3008_ _6179_/Q _6203_/Q _6191_/Q _5485_/Q _3062_/S _3005_/A VGND VGND VPWR VPWR
+ _3008_/X sky130_fd_sc_hd__mux4_1
XFILLER_83_277 VGND VGND VPWR VPWR sky130_fd_sc_hd__fill_1
XFILLER_71_417 VGND VGND VPWR VPWR sky130_fd_sc_hd__fill_4
XFILLER_101_23 VGND VGND VPWR VPWR sky130_fd_sc_hd__fill_2
XANTENNA__3697__S _3698_/S VGND VGND VPWR VPWR sky130_fd_sc_hd__diode_2
XFILLER_24_377 VPWR VGND VPWR VGND sky130_ef_sc_hd__decap_40_12
XFILLER_40_837 VGND VGND VPWR VPWR sky130_fd_sc_hd__fill_4
X_4959_ _5211_/A1 _4959_/A1 _4964_/S VGND VGND VPWR VPWR _4959_/X sky130_fd_sc_hd__mux2_1
XANTENNA__3775__A0 _4983_/A1 VGND VGND VPWR VPWR sky130_fd_sc_hd__diode_2
XFILLER_138_725 VGND VGND VPWR VPWR sky130_fd_sc_hd__fill_2
XFILLER_138_769 VGND VGND VPWR VPWR sky130_fd_sc_hd__fill_4
XFILLER_125_408 VGND VGND VPWR VPWR sky130_fd_sc_hd__fill_1
XANTENNA__3527__A0 _4904_/A0 VGND VGND VPWR VPWR sky130_fd_sc_hd__diode_2
XFILLER_4_749 VGND VGND VPWR VPWR sky130_fd_sc_hd__fill_4
XFILLER_106_699 VGND VGND VPWR VPWR sky130_fd_sc_hd__fill_1
XFILLER_105_165 VGND VGND VPWR VPWR sky130_fd_sc_hd__fill_1
XANTENNA__2750__A1 _5234_/A0 VGND VGND VPWR VPWR sky130_fd_sc_hd__diode_2
XFILLER_121_669 VGND VGND VPWR VPWR sky130_fd_sc_hd__fill_2
XANTENNA__2776__S _3091_/S VGND VGND VPWR VPWR sky130_fd_sc_hd__diode_2
XANTENNA_fanout65_X _3089_/C1 VGND VGND VPWR VPWR sky130_fd_sc_hd__diode_2
XTAP_TAPCELL_ROW_89_1635 VGND VPWR sky130_fd_sc_hd__tapvpwrvgnd_1
XFILLER_74_211 VGND VGND VPWR VPWR sky130_fd_sc_hd__fill_1
XFILLER_59_285 VGND VGND VPWR VPWR sky130_fd_sc_hd__fill_2
XFILLER_74_255 VGND VGND VPWR VPWR sky130_fd_sc_hd__fill_1
XANTENNA__4991__S _4993_/S VGND VGND VPWR VPWR sky130_fd_sc_hd__diode_2
XFILLER_62_428 VGND VGND VPWR VPWR sky130_fd_sc_hd__fill_4
XFILLER_62_417 VGND VGND VPWR VPWR sky130_fd_sc_hd__fill_2
XFILLER_15_311 VGND VGND VPWR VPWR sky130_fd_sc_hd__fill_8
XTAP_TAPCELL_ROW_100_1802 VGND VPWR sky130_fd_sc_hd__tapvpwrvgnd_1
XFILLER_42_141 VGND VGND VPWR VPWR sky130_fd_sc_hd__fill_1
XTAP_TAPCELL_ROW_13_501 VGND VPWR sky130_fd_sc_hd__tapvpwrvgnd_1
XFILLER_31_837 VGND VGND VPWR VPWR sky130_fd_sc_hd__fill_2
XFILLER_129_725 VGND VGND VPWR VPWR sky130_fd_sc_hd__fill_2
XTAP_TAPCELL_ROW_133_2301 VGND VPWR sky130_fd_sc_hd__tapvpwrvgnd_1
XFILLER_128_213 VGND VGND VPWR VPWR sky130_fd_sc_hd__fill_2
XFILLER_11_561 VPWR VGND VPWR VGND sky130_ef_sc_hd__decap_40_12
XANTENNA__3518__A0 _5238_/A1 VGND VGND VPWR VPWR sky130_fd_sc_hd__diode_2
X_3290_ hold560/X _4901_/A0 _3295_/S VGND VGND VPWR VPWR _3290_/X sky130_fd_sc_hd__mux2_1
XFILLER_112_625 VPWR VGND VPWR VGND sky130_ef_sc_hd__decap_40_12
XFILLER_98_837 VGND VGND VPWR VPWR sky130_fd_sc_hd__fill_4
XFILLER_112_669 VPWR VGND VPWR VGND sky130_ef_sc_hd__decap_40_12
XTAP_TAPCELL_ROW_111_1964 VGND VPWR sky130_fd_sc_hd__tapvpwrvgnd_1
XFILLER_100_809 VGND VGND VPWR VPWR sky130_fd_sc_hd__fill_2
XFILLER_38_403 VGND VGND VPWR VPWR sky130_fd_sc_hd__fill_2
XANTENNA__4494__A1 _5208_/A1 VGND VGND VPWR VPWR sky130_fd_sc_hd__diode_2
XFILLER_78_583 VGND VGND VPWR VPWR sky130_fd_sc_hd__fill_2
XFILLER_65_200 VGND VGND VPWR VPWR sky130_fd_sc_hd__fill_1
XTAP_TAPCELL_ROW_53_1093 VGND VPWR sky130_fd_sc_hd__tapvpwrvgnd_1
XFILLER_18_3 VGND VGND VPWR VPWR sky130_fd_sc_hd__fill_8
XFILLER_38_425 VGND VGND VPWR VPWR sky130_fd_sc_hd__fill_2
XFILLER_66_789 VGND VGND VPWR VPWR sky130_fd_sc_hd__fill_8
XFILLER_93_597 VPWR VGND VPWR VGND sky130_ef_sc_hd__decap_40_12
XFILLER_53_439 VGND VGND VPWR VPWR sky130_fd_sc_hd__fill_1
X_5931_ _6339_/CLK _5931_/D VGND VGND VPWR VPWR _5931_/Q sky130_fd_sc_hd__dfxtp_1
XFILLER_25_108 VGND VGND VPWR VPWR sky130_fd_sc_hd__fill_2
XFILLER_80_269 VGND VGND VPWR VPWR sky130_fd_sc_hd__fill_4
XANTENNA__4406__S _4406_/S VGND VGND VPWR VPWR sky130_fd_sc_hd__diode_2
X_5862_ _5898_/CLK _5862_/D VGND VGND VPWR VPWR _5862_/Q sky130_fd_sc_hd__dfxtp_1
X_5793_ _6120_/CLK _5793_/D VGND VGND VPWR VPWR _5793_/Q sky130_fd_sc_hd__dfxtp_1
XFILLER_22_837 VGND VGND VPWR VPWR sky130_fd_sc_hd__fill_4
X_4813_ _4812_/Y _4806_/Y _4813_/S VGND VGND VPWR VPWR _4813_/X sky130_fd_sc_hd__mux2_1
X_4744_ _6105_/Q _5894_/Q _4803_/S VGND VGND VPWR VPWR _4745_/B sky130_fd_sc_hd__mux2_1
XFILLER_119_246 VGND VGND VPWR VPWR sky130_fd_sc_hd__fill_1
XANTENNA__3509__A0 _4886_/A1 VGND VGND VPWR VPWR sky130_fd_sc_hd__diode_2
X_4675_ _4813_/S _4674_/X _4668_/Y _5401_/Q VGND VGND VPWR VPWR _4676_/B sky130_fd_sc_hd__o211a_1
XANTENNA_fanout112_A _5238_/A1 VGND VGND VPWR VPWR sky130_fd_sc_hd__diode_2
X_3626_ hold369/X _4521_/A1 _3627_/S VGND VGND VPWR VPWR _3626_/X sky130_fd_sc_hd__mux2_1
X_6414_ _6414_/CLK _6414_/D VGND VGND VPWR VPWR _6414_/Q sky130_fd_sc_hd__dfxtp_2
XPHY_EDGE_ROW_131_Right_131 VGND VGND VPWR VPWR sky130_fd_sc_hd__decap_3
X_3557_ _4958_/A0 hold998/X _3562_/S VGND VGND VPWR VPWR _5596_/D sky130_fd_sc_hd__mux2_1
X_6345_ _6345_/CLK _6345_/D VGND VGND VPWR VPWR _6345_/Q sky130_fd_sc_hd__dfxtp_1
XFILLER_115_485 VPWR VGND VPWR VGND sky130_ef_sc_hd__decap_40_12
XFILLER_89_837 VGND VGND VPWR VPWR sky130_fd_sc_hd__fill_2
XFILLER_88_325 VGND VGND VPWR VPWR sky130_fd_sc_hd__fill_1
X_6276_ _6312_/CLK _6276_/D VGND VGND VPWR VPWR _6276_/Q sky130_fd_sc_hd__dfxtp_1
X_5227_ _5239_/A1 _5227_/A1 _5237_/S VGND VGND VPWR VPWR _5227_/X sky130_fd_sc_hd__mux2_1
X_3488_ _3488_/A0 _4904_/A0 _3490_/S VGND VGND VPWR VPWR _5534_/D sky130_fd_sc_hd__mux2_1
XFILLER_103_669 VGND VGND VPWR VPWR sky130_fd_sc_hd__fill_2
XFILLER_102_113 VGND VGND VPWR VPWR sky130_fd_sc_hd__fill_2
Xhold1711 _5516_/Q VGND VGND VPWR VPWR _3469_/A1 sky130_fd_sc_hd__dlygate4sd3_1
XFILLER_102_146 VGND VGND VPWR VPWR sky130_fd_sc_hd__fill_1
XFILLER_69_561 VGND VGND VPWR VPWR sky130_fd_sc_hd__fill_2
Xhold1700 _3599_/X VGND VGND VPWR VPWR _5632_/D sky130_fd_sc_hd__dlygate4sd3_1
XANTENNA__5131__C1 _5034_/B VGND VGND VPWR VPWR sky130_fd_sc_hd__diode_2
XFILLER_57_712 VGND VGND VPWR VPWR sky130_fd_sc_hd__fill_1
XFILLER_84_531 VGND VGND VPWR VPWR sky130_fd_sc_hd__fill_1
X_5158_ _5840_/Q _5839_/Q _5194_/S VGND VGND VPWR VPWR _5158_/X sky130_fd_sc_hd__mux2_1
Xhold1733 _5727_/Q VGND VGND VPWR VPWR _3706_/A1 sky130_fd_sc_hd__dlygate4sd3_1
Xhold1744 _6037_/Q VGND VGND VPWR VPWR _4399_/A1 sky130_fd_sc_hd__dlygate4sd3_1
XFILLER_29_414 VPWR VGND VPWR VGND sky130_ef_sc_hd__decap_40_12
Xhold1722 _4327_/X VGND VGND VPWR VPWR _5973_/D sky130_fd_sc_hd__dlygate4sd3_1
XFILLER_110_190 VGND VGND VPWR VPWR sky130_fd_sc_hd__fill_2
Xhold1766 _5630_/Q VGND VGND VPWR VPWR _4562_/A2 sky130_fd_sc_hd__dlygate4sd3_1
X_5089_ _5089_/A0 _6165_/Q _5094_/S VGND VGND VPWR VPWR _5089_/X sky130_fd_sc_hd__mux2_1
Xhold1755 _4963_/X VGND VGND VPWR VPWR _6297_/D sky130_fd_sc_hd__dlygate4sd3_1
XFILLER_56_233 VGND VGND VPWR VPWR sky130_fd_sc_hd__fill_2
X_4109_ _4149_/A _4104_/X _4106_/X _4108_/X VGND VGND VPWR VPWR _4109_/X sky130_fd_sc_hd__a22o_1
XFILLER_17_609 VGND VGND VPWR VPWR sky130_fd_sc_hd__fill_4
Xhold1777 _4292_/X VGND VGND VPWR VPWR _5943_/D sky130_fd_sc_hd__dlygate4sd3_1
Xhold1788 _6216_/Q VGND VGND VPWR VPWR _4865_/A1 sky130_fd_sc_hd__dlygate4sd3_1
XFILLER_44_406 VPWR VGND VPWR VGND sky130_ef_sc_hd__decap_40_12
Xhold1799 _4332_/X VGND VGND VPWR VPWR _5978_/D sky130_fd_sc_hd__dlygate4sd3_1
XFILLER_71_225 VGND VGND VPWR VPWR sky130_fd_sc_hd__fill_4
XANTENNA__3220__S _3220_/S VGND VGND VPWR VPWR sky130_fd_sc_hd__diode_2
XTAP_TAPCELL_ROW_84_1565 VGND VPWR sky130_fd_sc_hd__tapvpwrvgnd_1
XTAP_TAPCELL_ROW_84_1554 VGND VPWR sky130_fd_sc_hd__tapvpwrvgnd_1
XFILLER_13_837 VGND VGND VPWR VPWR sky130_fd_sc_hd__fill_2
XFILLER_25_697 VGND VGND VPWR VPWR sky130_fd_sc_hd__fill_1
XANTENNA__3748__A0 _5040_/A1 VGND VGND VPWR VPWR sky130_fd_sc_hd__diode_2
XFILLER_40_667 VGND VGND VPWR VPWR sky130_fd_sc_hd__fill_1
XFILLER_138_533 VPWR VGND VPWR VGND sky130_ef_sc_hd__decap_40_12
XFILLER_122_3 VPWR VGND VPWR VGND sky130_ef_sc_hd__decap_40_12
XTAP_TAPCELL_ROW_115_2020 VGND VPWR sky130_fd_sc_hd__tapvpwrvgnd_1
XTAP_TAPCELL_ROW_115_2031 VGND VPWR sky130_fd_sc_hd__tapvpwrvgnd_1
XFILLER_4_513 VPWR VGND VPWR VGND sky130_ef_sc_hd__decap_40_12
XANTENNA__4051__S _4237_/S VGND VGND VPWR VPWR sky130_fd_sc_hd__diode_2
XANTENNA__4986__S _4993_/S VGND VGND VPWR VPWR sky130_fd_sc_hd__diode_2
XFILLER_4_557 VPWR VGND VPWR VGND sky130_ef_sc_hd__decap_40_12
XFILLER_106_485 VGND VGND VPWR VPWR sky130_fd_sc_hd__fill_1
XFILLER_121_433 VGND VGND VPWR VPWR sky130_fd_sc_hd__fill_4
XFILLER_0_741 VGND VGND VPWR VPWR sky130_fd_sc_hd__fill_4
XFILLER_94_306 VGND VGND VPWR VPWR sky130_fd_sc_hd__fill_2
XANTENNA__4476__A1 _5210_/A1 VGND VGND VPWR VPWR sky130_fd_sc_hd__diode_2
XFILLER_121_499 VGND VGND VPWR VPWR sky130_fd_sc_hd__fill_4
XFILLER_48_745 VGND VGND VPWR VPWR sky130_fd_sc_hd__fill_1
XFILLER_0_785 VPWR VGND VPWR VGND sky130_ef_sc_hd__decap_40_12
XTAP_TAPCELL_ROW_126_2193 VGND VPWR sky130_fd_sc_hd__tapvpwrvgnd_1
XFILLER_75_597 VGND VGND VPWR VPWR sky130_fd_sc_hd__fill_8
XFILLER_63_737 VGND VGND VPWR VPWR sky130_fd_sc_hd__fill_2
XFILLER_90_545 VPWR VGND VPWR VGND sky130_ef_sc_hd__decap_40_12
Xmax_cap61 _5201_/C VGND VGND VPWR VPWR _5019_/A sky130_fd_sc_hd__buf_1
XFILLER_46_93 VGND VGND VPWR VPWR sky130_fd_sc_hd__fill_1
XFILLER_90_589 VPWR VGND VPWR VGND sky130_ef_sc_hd__decap_40_12
XANTENNA__4226__S _4228_/S VGND VGND VPWR VPWR sky130_fd_sc_hd__diode_2
XFILLER_71_781 VGND VGND VPWR VPWR sky130_fd_sc_hd__fill_2
XFILLER_16_697 VGND VGND VPWR VPWR sky130_fd_sc_hd__fill_2
XTAP_TAPCELL_ROW_26_692 VGND VPWR sky130_fd_sc_hd__tapvpwrvgnd_1
X_2790_ _3050_/A _2790_/B VGND VGND VPWR VPWR _2790_/X sky130_fd_sc_hd__or2_1
XFILLER_8_841 VGND VGND VPWR VPWR sky130_fd_sc_hd__fill_1
XANTENNA__3366__A input5/X VGND VGND VPWR VPWR sky130_fd_sc_hd__diode_2
XANTENNA__5057__S _5059_/S VGND VGND VPWR VPWR sky130_fd_sc_hd__diode_2
X_4460_ _4881_/A _5225_/A VGND VGND VPWR VPWR _4472_/S sky130_fd_sc_hd__or2_4
XFILLER_7_373 VPWR VGND VPWR VGND sky130_ef_sc_hd__decap_40_12
Xhold307 _5884_/Q VGND VGND VPWR VPWR hold307/X sky130_fd_sc_hd__dlygate4sd3_1
XANTENNA__4896__S _4906_/S VGND VGND VPWR VPWR sky130_fd_sc_hd__diode_2
Xhold318 _3460_/X VGND VGND VPWR VPWR _5509_/D sky130_fd_sc_hd__dlygate4sd3_1
XFILLER_116_249 VGND VGND VPWR VPWR sky130_fd_sc_hd__fill_1
Xhold329 _5316_/Q VGND VGND VPWR VPWR hold329/X sky130_fd_sc_hd__dlygate4sd3_1
X_3411_ _4983_/A1 _3411_/A1 _3412_/S VGND VGND VPWR VPWR _3411_/X sky130_fd_sc_hd__mux2_1
X_4391_ _4929_/A1 _4391_/A1 _4396_/S VGND VGND VPWR VPWR _4391_/X sky130_fd_sc_hd__mux2_1
XFILLER_125_783 VGND VGND VPWR VPWR sky130_fd_sc_hd__fill_1
XFILLER_98_601 VPWR VGND VPWR VGND sky130_ef_sc_hd__decap_40_12
X_6130_ _6137_/CLK _6130_/D VGND VGND VPWR VPWR _6130_/Q sky130_fd_sc_hd__dfxtp_1
X_3342_ _5085_/A _5112_/B VGND VGND VPWR VPWR _3343_/C sky130_fd_sc_hd__nor2_1
XTAP_TAPCELL_ROW_55_1122 VGND VPWR sky130_fd_sc_hd__tapvpwrvgnd_1
XFILLER_98_645 VPWR VGND VPWR VGND sky130_ef_sc_hd__decap_40_12
XFILLER_97_111 VGND VGND VPWR VPWR sky130_fd_sc_hd__fill_1
X_6061_ _6242_/CLK _6061_/D VGND VGND VPWR VPWR _6061_/Q sky130_fd_sc_hd__dfxtp_1
X_3273_ _3801_/A _3278_/C VGND VGND VPWR VPWR _3273_/Y sky130_fd_sc_hd__nor2_1
XANTENNA__4197__A _4241_/A VGND VGND VPWR VPWR sky130_fd_sc_hd__diode_2
Xhold1018 _5376_/Q VGND VGND VPWR VPWR _3216_/A1 sky130_fd_sc_hd__dlygate4sd3_1
XANTENNA__4562__S1 _4789_/A VGND VGND VPWR VPWR sky130_fd_sc_hd__diode_2
Xhold1029 _3417_/X VGND VGND VPWR VPWR _5470_/D sky130_fd_sc_hd__dlygate4sd3_1
X_5012_ _5048_/A _5012_/B _5012_/C VGND VGND VPWR VPWR _5012_/X sky130_fd_sc_hd__or3_1
Xhold1007 _5704_/Q VGND VGND VPWR VPWR _3682_/A1 sky130_fd_sc_hd__dlygate4sd3_1
XFILLER_66_553 VGND VGND VPWR VPWR sky130_fd_sc_hd__fill_1
XFILLER_93_383 VGND VGND VPWR VPWR sky130_fd_sc_hd__fill_8
XFILLER_26_417 VGND VGND VPWR VPWR sky130_fd_sc_hd__fill_2
X_5914_ _6307_/CLK _5914_/D VGND VGND VPWR VPWR _5914_/Q sky130_fd_sc_hd__dfxtp_1
X_5845_ _6095_/CLK _5845_/D VGND VGND VPWR VPWR _5845_/Q sky130_fd_sc_hd__dfxtp_1
XTAP_TAPCELL_ROW_66_1295 VGND VPWR sky130_fd_sc_hd__tapvpwrvgnd_1
XTAP_TAPCELL_ROW_66_1284 VGND VPWR sky130_fd_sc_hd__tapvpwrvgnd_1
X_2988_ _3076_/A1 _2983_/X _2985_/X _2987_/X VGND VGND VPWR VPWR _2988_/X sky130_fd_sc_hd__a22o_1
X_5776_ _6315_/CLK _5776_/D VGND VGND VPWR VPWR _5776_/Q sky130_fd_sc_hd__dfxtp_1
XFILLER_135_503 VGND VGND VPWR VPWR sky130_fd_sc_hd__fill_1
XANTENNA__3276__A _3801_/A VGND VGND VPWR VPWR sky130_fd_sc_hd__diode_2
X_4727_ _4726_/X _4721_/X _4813_/S VGND VGND VPWR VPWR _4727_/X sky130_fd_sc_hd__mux2_1
XFILLER_107_227 VGND VGND VPWR VPWR sky130_fd_sc_hd__fill_1
X_4658_ hold31/A _5687_/Q _6093_/Q _5873_/Q _4795_/S _4794_/A VGND VGND VPWR VPWR
+ _4658_/X sky130_fd_sc_hd__mux4_1
XANTENNA_fanout115_X _5239_/A1 VGND VGND VPWR VPWR sky130_fd_sc_hd__diode_2
XFILLER_123_709 VPWR VGND VPWR VGND sky130_ef_sc_hd__decap_40_12
X_3609_ _3609_/A0 _5209_/A1 _3616_/S VGND VGND VPWR VPWR _3609_/X sky130_fd_sc_hd__mux2_1
Xhold830 _4926_/X VGND VGND VPWR VPWR _6263_/D sky130_fd_sc_hd__dlygate4sd3_1
Xhold863 _5315_/Q VGND VGND VPWR VPWR hold863/X sky130_fd_sc_hd__dlygate4sd3_1
Xhold852 _3538_/X VGND VGND VPWR VPWR _5581_/D sky130_fd_sc_hd__dlygate4sd3_1
Xhold841 _5729_/Q VGND VGND VPWR VPWR hold841/X sky130_fd_sc_hd__dlygate4sd3_1
XFILLER_1_505 VPWR VGND VPWR VGND sky130_ef_sc_hd__decap_40_12
X_4589_ _4813_/S _4588_/X _4582_/Y _3278_/A VGND VGND VPWR VPWR _4590_/B sky130_fd_sc_hd__o211a_1
Xhold896 _5518_/Q VGND VGND VPWR VPWR hold896/X sky130_fd_sc_hd__dlygate4sd3_1
XFILLER_89_645 VGND VGND VPWR VPWR sky130_fd_sc_hd__fill_1
Xhold885 _3892_/X VGND VGND VPWR VPWR _5871_/D sky130_fd_sc_hd__dlygate4sd3_1
X_6328_ _6417_/CLK _6328_/D VGND VGND VPWR VPWR _6328_/Q sky130_fd_sc_hd__dfxtp_2
Xhold874 _3389_/X VGND VGND VPWR VPWR _5448_/D sky130_fd_sc_hd__dlygate4sd3_1
XFILLER_131_753 VPWR VGND VPWR VGND sky130_ef_sc_hd__decap_40_12
XANTENNA__3215__S _3220_/S VGND VGND VPWR VPWR sky130_fd_sc_hd__diode_2
XFILLER_88_155 VGND VGND VPWR VPWR sky130_fd_sc_hd__fill_1
Xhold2220 _5267_/Q VGND VGND VPWR VPWR hold2220/X sky130_fd_sc_hd__dlygate4sd3_1
X_6259_ _6261_/CLK _6259_/D VGND VGND VPWR VPWR _6259_/Q sky130_fd_sc_hd__dfxtp_1
XANTENNA__4458__A1 _6262_/Q VGND VGND VPWR VPWR sky130_fd_sc_hd__diode_2
XFILLER_131_797 VPWR VGND VPWR VGND sky130_ef_sc_hd__decap_40_12
Xhold2253 _3517_/B VGND VGND VPWR VPWR _3465_/B sky130_fd_sc_hd__dlygate4sd3_1
Xhold2231 _5814_/Q VGND VGND VPWR VPWR hold2231/X sky130_fd_sc_hd__dlygate4sd3_1
Xhold2242 _3880_/B VGND VGND VPWR VPWR _3870_/A sky130_fd_sc_hd__dlygate4sd3_1
Xhold1530 _3444_/X VGND VGND VPWR VPWR _5494_/D sky130_fd_sc_hd__dlygate4sd3_1
XFILLER_91_309 VGND VGND VPWR VPWR sky130_fd_sc_hd__fill_2
Xhold1552 _3640_/X VGND VGND VPWR VPWR _5667_/D sky130_fd_sc_hd__dlygate4sd3_1
XTAP_TAPCELL_ROW_4_365 VGND VPWR sky130_fd_sc_hd__tapvpwrvgnd_1
XTAP_TAPCELL_ROW_4_354 VGND VPWR sky130_fd_sc_hd__tapvpwrvgnd_1
Xhold1541 _5695_/Q VGND VGND VPWR VPWR _3672_/A1 sky130_fd_sc_hd__dlygate4sd3_1
Xhold1574 _5876_/Q VGND VGND VPWR VPWR _3897_/A0 sky130_fd_sc_hd__dlygate4sd3_1
Xhold1585 _4455_/X VGND VGND VPWR VPWR _6066_/D sky130_fd_sc_hd__dlygate4sd3_1
XFILLER_45_715 VGND VGND VPWR VPWR sky130_fd_sc_hd__fill_2
XFILLER_17_417 VPWR VGND VPWR VGND sky130_ef_sc_hd__decap_40_12
Xhold1563 _3670_/X VGND VGND VPWR VPWR _5693_/D sky130_fd_sc_hd__dlygate4sd3_1
Xhold1596 _6295_/Q VGND VGND VPWR VPWR _4961_/A1 sky130_fd_sc_hd__dlygate4sd3_1
XFILLER_72_589 VGND VGND VPWR VPWR sky130_fd_sc_hd__fill_4
XTAP_TAPCELL_ROW_43_949 VGND VPWR sky130_fd_sc_hd__tapvpwrvgnd_1
XTAP_TAPCELL_ROW_43_938 VGND VPWR sky130_fd_sc_hd__tapvpwrvgnd_1
XPHY_EDGE_ROW_11_Right_11 VGND VGND VPWR VPWR sky130_fd_sc_hd__decap_3
XTAP_TAPCELL_ROW_23_640 VGND VPWR sky130_fd_sc_hd__tapvpwrvgnd_1
XANTENNA__3197__A1 _5228_/A0 VGND VGND VPWR VPWR sky130_fd_sc_hd__diode_2
XANTENNA__4394__A0 _4982_/A1 VGND VGND VPWR VPWR sky130_fd_sc_hd__diode_2
XTAP_TAPCELL_ROW_23_651 VGND VPWR sky130_fd_sc_hd__tapvpwrvgnd_1
XFILLER_32_40 VGND VGND VPWR VPWR sky130_fd_sc_hd__fill_2
XFILLER_126_525 VGND VGND VPWR VPWR sky130_fd_sc_hd__fill_4
XTAP_TAPCELL_ROW_97_1756 VGND VPWR sky130_fd_sc_hd__tapvpwrvgnd_1
XANTENNA__2944__A1 _3031_/A1 VGND VGND VPWR VPWR sky130_fd_sc_hd__diode_2
XFILLER_5_833 VGND VGND VPWR VPWR sky130_fd_sc_hd__fill_4
XFILLER_126_569 VPWR VGND VPWR VGND sky130_ef_sc_hd__decap_40_12
XFILLER_4_343 VPWR VGND VPWR VGND sky130_ef_sc_hd__decap_40_12
XFILLER_107_783 VGND VGND VPWR VPWR sky130_fd_sc_hd__fill_1
XFILLER_4_365 VPWR VGND VPWR VGND sky130_ef_sc_hd__decap_40_12
XFILLER_79_111 VGND VGND VPWR VPWR sky130_fd_sc_hd__fill_1
XPHY_EDGE_ROW_20_Right_20 VGND VGND VPWR VPWR sky130_fd_sc_hd__decap_3
XFILLER_122_753 VGND VGND VPWR VPWR sky130_fd_sc_hd__fill_2
XFILLER_95_615 VGND VGND VPWR VPWR sky130_fd_sc_hd__fill_1
XTAP_TAPCELL_ROW_128_2222 VGND VPWR sky130_fd_sc_hd__tapvpwrvgnd_1
XANTENNA__4449__B2 _4883_/A1 VGND VGND VPWR VPWR sky130_fd_sc_hd__diode_2
XFILLER_67_328 VGND VGND VPWR VPWR sky130_fd_sc_hd__fill_8
XANTENNA__3121__A1 _5232_/A0 VGND VGND VPWR VPWR sky130_fd_sc_hd__diode_2
XTAP_TAPCELL_ROW_50_1052 VGND VPWR sky130_fd_sc_hd__tapvpwrvgnd_1
XFILLER_91_821 VPWR VGND VPWR VGND sky130_ef_sc_hd__decap_40_12
XFILLER_48_597 VGND VGND VPWR VPWR sky130_fd_sc_hd__fill_4
XFILLER_48_586 VGND VGND VPWR VPWR sky130_fd_sc_hd__fill_2
XANTENNA__4745__A _4802_/A VGND VGND VPWR VPWR sky130_fd_sc_hd__diode_2
XFILLER_63_556 VGND VGND VPWR VPWR sky130_fd_sc_hd__fill_4
XFILLER_63_567 VGND VGND VPWR VPWR sky130_fd_sc_hd__fill_2
X_3960_ _5000_/A _5000_/B VGND VGND VPWR VPWR _5003_/B sky130_fd_sc_hd__or2_1
X_2911_ _5301_/Q _5374_/Q hold77/A _6143_/Q _2984_/S _2985_/A VGND VGND VPWR VPWR
+ _2911_/X sky130_fd_sc_hd__mux4_1
XTAP_TAPCELL_ROW_106_1896 VGND VPWR sky130_fd_sc_hd__tapvpwrvgnd_1
XTAP_TAPCELL_ROW_106_1885 VGND VPWR sky130_fd_sc_hd__tapvpwrvgnd_1
XFILLER_44_781 VPWR VGND VPWR VGND sky130_ef_sc_hd__decap_40_12
X_3891_ hold143/X _4484_/A0 _3899_/S VGND VGND VPWR VPWR _3891_/X sky130_fd_sc_hd__mux2_1
XANTENNA_hold2194_A _5343_/Q VGND VGND VPWR VPWR sky130_fd_sc_hd__diode_2
X_2842_ _6174_/Q _6198_/Q _3091_/S VGND VGND VPWR VPWR _2843_/B sky130_fd_sc_hd__mux2_1
XANTENNA__3188__A1 _5232_/A0 VGND VGND VPWR VPWR sky130_fd_sc_hd__diode_2
XANTENNA__4909__C1 _5176_/A VGND VGND VPWR VPWR sky130_fd_sc_hd__diode_2
X_5630_ _6382_/CLK _5630_/D VGND VGND VPWR VPWR _5630_/Q sky130_fd_sc_hd__dfxtp_1
X_5561_ _6252_/CLK _5561_/D VGND VGND VPWR VPWR _5561_/Q sky130_fd_sc_hd__dfxtp_1
X_2773_ _2768_/X _2772_/X _2995_/A VGND VGND VPWR VPWR _2773_/Y sky130_fd_sc_hd__o21ai_1
XFILLER_117_503 VGND VGND VPWR VPWR sky130_fd_sc_hd__fill_1
XANTENNA__2935__A1 _3036_/A1 VGND VGND VPWR VPWR sky130_fd_sc_hd__diode_2
X_5492_ _6129_/CLK _5492_/D VGND VGND VPWR VPWR _5492_/Q sky130_fd_sc_hd__dfxtp_1
X_4512_ hold433/X _5202_/A1 _4512_/S VGND VGND VPWR VPWR _4512_/X sky130_fd_sc_hd__mux2_1
XFILLER_105_709 VPWR VGND VPWR VGND sky130_ef_sc_hd__decap_40_12
Xhold115 _6137_/Q VGND VGND VPWR VPWR hold115/X sky130_fd_sc_hd__dlygate4sd3_1
Xhold104 _3440_/X VGND VGND VPWR VPWR _5490_/D sky130_fd_sc_hd__dlygate4sd3_1
XFILLER_8_693 VGND VGND VPWR VPWR sky130_fd_sc_hd__fill_4
Xhold126 _3797_/X VGND VGND VPWR VPWR _5804_/D sky130_fd_sc_hd__dlygate4sd3_1
Xhold159 _6135_/Q VGND VGND VPWR VPWR hold159/X sky130_fd_sc_hd__dlygate4sd3_1
Xhold148 _3613_/X VGND VGND VPWR VPWR _5644_/D sky130_fd_sc_hd__dlygate4sd3_1
X_4443_ _6256_/Q _3366_/X _4427_/B _2665_/Y _4442_/X VGND VGND VPWR VPWR _4443_/X
+ sky130_fd_sc_hd__a221o_2
Xhold137 _5951_/Q VGND VGND VPWR VPWR hold137/X sky130_fd_sc_hd__dlygate4sd3_1
X_4374_ _5045_/A1 _4374_/A1 _4376_/S VGND VGND VPWR VPWR _4374_/X sky130_fd_sc_hd__mux2_1
XFILLER_113_753 VPWR VGND VPWR VGND sky130_ef_sc_hd__decap_40_12
XANTENNA__5812__Q _5812_/Q VGND VGND VPWR VPWR sky130_fd_sc_hd__diode_2
X_3325_ _5328_/Q _3336_/A _3336_/B _3336_/C VGND VGND VPWR VPWR _3325_/X sky130_fd_sc_hd__or4_1
X_6113_ _6122_/CLK _6113_/D VGND VGND VPWR VPWR _6113_/Q sky130_fd_sc_hd__dfxtp_1
XFILLER_113_797 VPWR VGND VPWR VGND sky130_ef_sc_hd__decap_40_12
XANTENNA__3035__S _3062_/S VGND VGND VPWR VPWR sky130_fd_sc_hd__diode_2
X_6044_ _6403_/CLK _6044_/D VGND VGND VPWR VPWR _6044_/Q sky130_fd_sc_hd__dfxtp_1
XFILLER_58_328 VPWR VGND VPWR VGND sky130_ef_sc_hd__decap_40_12
XFILLER_58_317 VGND VGND VPWR VPWR sky130_fd_sc_hd__fill_2
X_3256_ _3354_/A1 _4189_/A0 _3258_/S VGND VGND VPWR VPWR _3256_/X sky130_fd_sc_hd__mux2_1
XANTENNA__3112__A1 _5237_/A0 VGND VGND VPWR VPWR sky130_fd_sc_hd__diode_2
XFILLER_85_136 VGND VGND VPWR VPWR sky130_fd_sc_hd__fill_4
X_3187_ hold59/X _5075_/A0 _3193_/S VGND VGND VPWR VPWR hold60/A sky130_fd_sc_hd__mux2_1
XFILLER_94_681 VPWR VGND VPWR VGND sky130_ef_sc_hd__decap_40_12
XANTENNA__4655__A _4794_/A VGND VGND VPWR VPWR sky130_fd_sc_hd__diode_2
XTAP_TAPCELL_ROW_68_1313 VGND VPWR sky130_fd_sc_hd__tapvpwrvgnd_1
XTAP_TAPCELL_ROW_1_313 VGND VPWR sky130_fd_sc_hd__tapvpwrvgnd_1
XFILLER_39_575 VGND VGND VPWR VPWR sky130_fd_sc_hd__fill_1
XTAP_TAPCELL_ROW_68_1324 VGND VPWR sky130_fd_sc_hd__tapvpwrvgnd_1
XFILLER_54_523 VGND VGND VPWR VPWR sky130_fd_sc_hd__fill_2
XTAP_TAPCELL_ROW_81_1513 VGND VPWR sky130_fd_sc_hd__tapvpwrvgnd_1
X_5828_ _6342_/CLK _5828_/D VGND VGND VPWR VPWR _5828_/Q sky130_fd_sc_hd__dfxtp_2
XFILLER_22_475 VGND VGND VPWR VPWR sky130_fd_sc_hd__fill_1
X_5759_ _6199_/CLK _5759_/D VGND VGND VPWR VPWR _5759_/Q sky130_fd_sc_hd__dfxtp_1
XANTENNA__4376__A0 _5047_/A1 VGND VGND VPWR VPWR sky130_fd_sc_hd__diode_2
XFILLER_10_637 VGND VGND VPWR VPWR sky130_fd_sc_hd__fill_4
XFILLER_108_569 VPWR VGND VPWR VGND sky130_ef_sc_hd__decap_40_12
XTAP_TAPCELL_ROW_79_1486 VGND VPWR sky130_fd_sc_hd__tapvpwrvgnd_1
XANTENNA__4128__B1 _3172_/B VGND VGND VPWR VPWR sky130_fd_sc_hd__diode_2
XFILLER_123_517 VPWR VGND VPWR VGND sky130_ef_sc_hd__decap_40_12
XANTENNA__3026__S1 _2962_/A VGND VGND VPWR VPWR sky130_fd_sc_hd__diode_2
XFILLER_2_825 VPWR VGND VPWR VGND sky130_ef_sc_hd__decap_40_12
XANTENNA_fanout92_A _4964_/A0 VGND VGND VPWR VPWR sky130_fd_sc_hd__diode_2
XTAP_TAPCELL_ROW_9_435 VGND VPWR sky130_fd_sc_hd__tapvpwrvgnd_1
Xhold671 _6315_/Q VGND VGND VPWR VPWR hold671/X sky130_fd_sc_hd__dlygate4sd3_1
Xhold660 _4345_/X VGND VGND VPWR VPWR _5990_/D sky130_fd_sc_hd__dlygate4sd3_1
XFILLER_131_561 VPWR VGND VPWR VGND sky130_ef_sc_hd__decap_40_12
Xhold693 _3461_/X VGND VGND VPWR VPWR _5510_/D sky130_fd_sc_hd__dlygate4sd3_1
XFILLER_104_753 VGND VGND VPWR VPWR sky130_fd_sc_hd__fill_2
XTAP_TAPCELL_ROW_92_1686 VGND VPWR sky130_fd_sc_hd__tapvpwrvgnd_1
XTAP_TAPCELL_ROW_92_1675 VGND VPWR sky130_fd_sc_hd__tapvpwrvgnd_1
XFILLER_1_357 VGND VGND VPWR VPWR sky130_fd_sc_hd__fill_1
Xhold682 _4383_/X VGND VGND VPWR VPWR _6023_/D sky130_fd_sc_hd__dlygate4sd3_1
XFILLER_103_285 VGND VGND VPWR VPWR sky130_fd_sc_hd__fill_8
XFILLER_77_626 VGND VGND VPWR VPWR sky130_fd_sc_hd__fill_4
XANTENNA__3103__A1 _5228_/A0 VGND VGND VPWR VPWR sky130_fd_sc_hd__diode_2
Xhold2061 _5063_/X VGND VGND VPWR VPWR _6355_/D sky130_fd_sc_hd__dlygate4sd3_1
Xhold2050 _3361_/X VGND VGND VPWR VPWR _5434_/D sky130_fd_sc_hd__dlygate4sd3_1
Xhold2072 _6417_/Q VGND VGND VPWR VPWR hold2072/X sky130_fd_sc_hd__dlygate4sd3_1
XANTENNA__2784__S _2984_/S VGND VGND VPWR VPWR sky130_fd_sc_hd__diode_2
XFILLER_85_681 VGND VGND VPWR VPWR sky130_fd_sc_hd__fill_8
XFILLER_73_821 VGND VGND VPWR VPWR sky130_fd_sc_hd__fill_4
Xhold2094 _6402_/Q VGND VGND VPWR VPWR _3952_/A sky130_fd_sc_hd__dlygate4sd3_1
XFILLER_45_501 VGND VGND VPWR VPWR sky130_fd_sc_hd__fill_1
Xhold2083 _5215_/S VGND VGND VPWR VPWR _5213_/S sky130_fd_sc_hd__dlygate4sd3_1
Xhold1360 _4329_/X VGND VGND VPWR VPWR _5975_/D sky130_fd_sc_hd__dlygate4sd3_1
XTAP_TAPCELL_ROW_123_2141 VGND VPWR sky130_fd_sc_hd__tapvpwrvgnd_1
Xhold1371 _2710_/X VGND VGND VPWR VPWR _5258_/D sky130_fd_sc_hd__dlygate4sd3_1
Xhold1382 _4375_/X VGND VGND VPWR VPWR _6016_/D sky130_fd_sc_hd__dlygate4sd3_1
XFILLER_17_225 VGND VGND VPWR VPWR sky130_fd_sc_hd__fill_1
XFILLER_18_737 VPWR VGND VPWR VGND sky130_ef_sc_hd__decap_40_12
XTAP_TAPCELL_ROW_28_721 VGND VPWR sky130_fd_sc_hd__tapvpwrvgnd_1
Xhold1393 _4189_/S VGND VGND VPWR VPWR _4274_/S sky130_fd_sc_hd__dlygate4sd3_1
XTAP_TAPCELL_ROW_123_2152 VGND VPWR sky130_fd_sc_hd__tapvpwrvgnd_1
XFILLER_45_556 VGND VGND VPWR VPWR sky130_fd_sc_hd__fill_4
XANTENNA__4603__A1 _4663_/A VGND VGND VPWR VPWR sky130_fd_sc_hd__diode_2
XFILLER_45_589 VGND VGND VPWR VPWR sky130_fd_sc_hd__fill_1
XFILLER_26_781 VPWR VGND VPWR VGND sky130_ef_sc_hd__decap_40_12
XFILLER_13_497 VGND VGND VPWR VPWR sky130_fd_sc_hd__fill_4
XFILLER_138_160 VGND VGND VPWR VPWR sky130_fd_sc_hd__fill_8
XANTENNA__3590__A1 _4517_/A1 VGND VGND VPWR VPWR sky130_fd_sc_hd__diode_2
XFILLER_5_641 VPWR VGND VPWR VGND sky130_ef_sc_hd__decap_40_12
XFILLER_5_685 VPWR VGND VPWR VGND sky130_ef_sc_hd__decap_40_12
XANTENNA__4765__S1 _4802_/A VGND VGND VPWR VPWR sky130_fd_sc_hd__diode_2
XFILLER_110_701 VPWR VGND VPWR VGND sky130_ef_sc_hd__decap_40_12
XFILLER_4_195 VGND VGND VPWR VPWR sky130_fd_sc_hd__fill_1
XFILLER_4_77 VGND VGND VPWR VPWR sky130_fd_sc_hd__fill_4
X_3110_ hold319/X _5235_/A0 _3112_/S VGND VGND VPWR VPWR _3110_/X sky130_fd_sc_hd__mux2_1
X_4090_ hold87/A _5957_/Q _4262_/S VGND VGND VPWR VPWR _4090_/X sky130_fd_sc_hd__mux2_1
XANTENNA__5070__S _5081_/S VGND VGND VPWR VPWR sky130_fd_sc_hd__diode_2
XTAP_TAPCELL_ROW_108_1914 VGND VPWR sky130_fd_sc_hd__tapvpwrvgnd_1
X_3041_ _3154_/A1 _3011_/A _3040_/X VGND VGND VPWR VPWR _3041_/X sky130_fd_sc_hd__a21o_1
XFILLER_67_169 VGND VGND VPWR VPWR sky130_fd_sc_hd__fill_4
XTAP_TAPCELL_ROW_108_1925 VGND VPWR sky130_fd_sc_hd__tapvpwrvgnd_1
XFILLER_82_139 VGND VGND VPWR VPWR sky130_fd_sc_hd__fill_1
XFILLER_48_372 VGND VGND VPWR VPWR sky130_fd_sc_hd__fill_2
XFILLER_91_673 VPWR VGND VPWR VGND sky130_ef_sc_hd__decap_40_12
XFILLER_63_364 VPWR VGND VPWR VGND sky130_ef_sc_hd__decap_40_12
X_4992_ hold512/X _5046_/A1 _4993_/S VGND VGND VPWR VPWR _4992_/X sky130_fd_sc_hd__mux2_1
XFILLER_17_781 VGND VGND VPWR VPWR sky130_fd_sc_hd__fill_2
XFILLER_36_589 VGND VGND VPWR VPWR sky130_fd_sc_hd__fill_2
X_3943_ _3945_/A _3943_/B VGND VGND VPWR VPWR _5152_/B sky130_fd_sc_hd__or2_1
XTAP_TAPCELL_ROW_63_1243 VGND VPWR sky130_fd_sc_hd__tapvpwrvgnd_1
XFILLER_51_559 VGND VGND VPWR VPWR sky130_fd_sc_hd__fill_1
XFILLER_51_548 VGND VGND VPWR VPWR sky130_fd_sc_hd__fill_1
X_3874_ _5211_/A1 _3874_/A1 _3879_/S VGND VGND VPWR VPWR _3874_/X sky130_fd_sc_hd__mux2_1
XANTENNA__4414__S _4416_/S VGND VGND VPWR VPWR sky130_fd_sc_hd__diode_2
XFILLER_137_609 VGND VGND VPWR VPWR sky130_fd_sc_hd__fill_4
X_2825_ _5417_/Q _5491_/Q _5347_/Q _5575_/Q _2963_/S _2962_/A VGND VGND VPWR VPWR
+ _2826_/B sky130_fd_sc_hd__mux4_1
X_5613_ _6294_/CLK _5613_/D VGND VGND VPWR VPWR _5613_/Q sky130_fd_sc_hd__dfxtp_1
Xclkbuf_3_2__f_clk clkbuf_0_clk/X VGND VGND VPWR VPWR clkload1/A sky130_fd_sc_hd__clkbuf_16
X_2756_ _2985_/A _2756_/B VGND VGND VPWR VPWR _2756_/X sky130_fd_sc_hd__or2_1
X_5544_ _6222_/CLK _5544_/D VGND VGND VPWR VPWR _5544_/Q sky130_fd_sc_hd__dfxtp_1
XFILLER_117_377 VGND VGND VPWR VPWR sky130_fd_sc_hd__fill_1
X_2687_ _2645_/A _2685_/A _2686_/Y VGND VGND VPWR VPWR _2687_/X sky130_fd_sc_hd__o21a_1
XANTENNA__3008__S1 _3005_/A VGND VGND VPWR VPWR sky130_fd_sc_hd__diode_2
XANTENNA__3581__A1 _4961_/A0 VGND VGND VPWR VPWR sky130_fd_sc_hd__diode_2
X_5475_ _6294_/CLK _5475_/D VGND VGND VPWR VPWR _5475_/Q sky130_fd_sc_hd__dfxtp_1
XFILLER_133_837 VGND VGND VPWR VPWR sky130_fd_sc_hd__fill_2
X_4426_ _5834_/Q input5/X input4/X VGND VGND VPWR VPWR _4426_/X sky130_fd_sc_hd__and3_1
XANTENNA__2767__S0 _2963_/S VGND VGND VPWR VPWR sky130_fd_sc_hd__diode_2
XFILLER_113_561 VPWR VGND VPWR VGND sky130_ef_sc_hd__decap_40_12
XFILLER_98_283 VGND VGND VPWR VPWR sky130_fd_sc_hd__fill_2
XFILLER_59_615 VGND VGND VPWR VPWR sky130_fd_sc_hd__fill_1
X_4357_ _4935_/A _4377_/B VGND VGND VPWR VPWR _4366_/S sky130_fd_sc_hd__nor2_4
X_3308_ hold568/X _5237_/A0 _3308_/S VGND VGND VPWR VPWR _3308_/X sky130_fd_sc_hd__mux2_1
XFILLER_86_434 VPWR VGND VPWR VGND sky130_ef_sc_hd__decap_40_12
XFILLER_59_659 VGND VGND VPWR VPWR sky130_fd_sc_hd__fill_1
X_4288_ hold924/X _4978_/A1 _4294_/S VGND VGND VPWR VPWR _4288_/X sky130_fd_sc_hd__mux2_1
X_3239_ _3617_/C _4503_/A _3801_/A VGND VGND VPWR VPWR _3239_/X sky130_fd_sc_hd__a21o_1
X_6027_ _6315_/CLK _6027_/D VGND VGND VPWR VPWR _6027_/Q sky130_fd_sc_hd__dfxtp_1
XFILLER_55_821 VPWR VGND VPWR VGND sky130_ef_sc_hd__decap_40_12
XFILLER_70_813 VGND VGND VPWR VPWR sky130_fd_sc_hd__fill_4
XFILLER_15_729 VPWR VGND VPWR VGND sky130_ef_sc_hd__decap_40_12
XFILLER_42_559 VGND VGND VPWR VPWR sky130_fd_sc_hd__fill_2
Xfanout65 _2641_/Y VGND VGND VPWR VPWR _3089_/C1 sky130_fd_sc_hd__clkbuf_8
XFILLER_10_401 VPWR VGND VPWR VGND sky130_ef_sc_hd__decap_40_12
XFILLER_23_762 VPWR VGND VPWR VGND sky130_ef_sc_hd__decap_40_12
Xfanout87 _6412_/Q VGND VGND VPWR VPWR _5210_/A1 sky130_fd_sc_hd__buf_4
XTAP_TAPCELL_ROW_33_790 VGND VPWR sky130_fd_sc_hd__tapvpwrvgnd_1
Xfanout76 _5215_/A1 VGND VGND VPWR VPWR _4521_/A1 sky130_fd_sc_hd__buf_4
Xfanout98 _5045_/A1 VGND VGND VPWR VPWR _4982_/A1 sky130_fd_sc_hd__clkbuf_4
XFILLER_10_445 VPWR VGND VPWR VGND sky130_ef_sc_hd__decap_40_12
XTAP_TAPCELL_ROW_94_1715 VGND VPWR sky130_fd_sc_hd__tapvpwrvgnd_1
XTAP_TAPCELL_ROW_94_1704 VGND VPWR sky130_fd_sc_hd__tapvpwrvgnd_1
XFILLER_10_489 VPWR VGND VPWR VGND sky130_ef_sc_hd__decap_40_12
XANTENNA__3572__A1 _3926_/A1 VGND VGND VPWR VPWR sky130_fd_sc_hd__diode_2
XFILLER_89_57 VGND VGND VPWR VPWR sky130_fd_sc_hd__fill_1
XFILLER_136_697 VGND VGND VPWR VPWR sky130_fd_sc_hd__fill_2
XFILLER_124_837 VGND VGND VPWR VPWR sky130_fd_sc_hd__fill_4
Xhold490 _5046_/X VGND VGND VPWR VPWR _6341_/D sky130_fd_sc_hd__dlygate4sd3_1
XANTENNA_fanout95_X _4984_/A1 VGND VGND VPWR VPWR sky130_fd_sc_hd__diode_2
XFILLER_2_699 VGND VGND VPWR VPWR sky130_fd_sc_hd__fill_1
XFILLER_46_810 VGND VGND VPWR VPWR sky130_fd_sc_hd__fill_2
XFILLER_18_501 VPWR VGND VPWR VGND sky130_ef_sc_hd__decap_40_12
XFILLER_38_83 VGND VGND VPWR VPWR sky130_fd_sc_hd__fill_1
XANTENNA__2835__B1 _3094_/C1 VGND VGND VPWR VPWR sky130_fd_sc_hd__diode_2
XFILLER_45_353 VGND VGND VPWR VPWR sky130_fd_sc_hd__fill_1
XFILLER_18_545 VPWR VGND VPWR VGND sky130_ef_sc_hd__decap_40_12
Xhold1190 _4504_/X VGND VGND VPWR VPWR _6108_/D sky130_fd_sc_hd__dlygate4sd3_1
XFILLER_45_375 VGND VGND VPWR VPWR sky130_fd_sc_hd__fill_2
XFILLER_18_589 VPWR VGND VPWR VGND sky130_ef_sc_hd__decap_40_12
XFILLER_33_515 VGND VGND VPWR VPWR sky130_fd_sc_hd__fill_2
XTAP_TAPCELL_ROW_103_1844 VGND VPWR sky130_fd_sc_hd__tapvpwrvgnd_1
XFILLER_60_367 VGND VGND VPWR VPWR sky130_fd_sc_hd__fill_1
XFILLER_119_609 VGND VGND VPWR VPWR sky130_fd_sc_hd__fill_4
XTAP_TAPCELL_ROW_136_2343 VGND VPWR sky130_fd_sc_hd__tapvpwrvgnd_1
X_3590_ _3590_/A0 _4517_/A1 _3595_/S VGND VGND VPWR VPWR _3590_/X sky130_fd_sc_hd__mux2_1
Xclkload35 _6345_/CLK VGND VGND VPWR VPWR clkload35/Y sky130_fd_sc_hd__clkinv_2
Xclkload24 _6334_/CLK VGND VGND VPWR VPWR clkload24/Y sky130_fd_sc_hd__clkinv_2
Xclkload13 _6068_/CLK VGND VGND VPWR VPWR clkload13/Y sky130_fd_sc_hd__inv_12
XTAP_TAPCELL_ROW_11_462 VGND VPWR sky130_fd_sc_hd__tapvpwrvgnd_1
XFILLER_127_653 VPWR VGND VPWR VGND sky130_ef_sc_hd__decap_40_12
XFILLER_126_152 VGND VGND VPWR VPWR sky130_fd_sc_hd__fill_4
XANTENNA__2997__S0 _2963_/S VGND VGND VPWR VPWR sky130_fd_sc_hd__diode_2
Xclkload68 _5841_/CLK VGND VGND VPWR VPWR clkload68/Y sky130_fd_sc_hd__inv_6
Xclkload57 _6060_/CLK VGND VGND VPWR VPWR clkload57/Y sky130_fd_sc_hd__inv_12
Xclkload46 _5803_/CLK VGND VGND VPWR VPWR clkload46/Y sky130_fd_sc_hd__inv_12
Xclkload79 _6365_/CLK VGND VGND VPWR VPWR clkload79/Y sky130_fd_sc_hd__clkinv_4
XFILLER_127_697 VPWR VGND VPWR VGND sky130_ef_sc_hd__decap_40_12
XFILLER_115_837 VGND VGND VPWR VPWR sky130_fd_sc_hd__fill_2
X_5260_ _6345_/CLK _5260_/D VGND VGND VPWR VPWR _5260_/Q sky130_fd_sc_hd__dfxtp_1
X_4211_ _6024_/Q _6015_/Q _4213_/S VGND VGND VPWR VPWR _4212_/B sky130_fd_sc_hd__mux2_1
X_5191_ _5191_/A _5191_/B VGND VGND VPWR VPWR _5191_/Y sky130_fd_sc_hd__nor2_1
XFILLER_122_391 VGND VGND VPWR VPWR sky130_fd_sc_hd__fill_1
XFILLER_110_531 VGND VGND VPWR VPWR sky130_fd_sc_hd__fill_1
XFILLER_68_456 VGND VGND VPWR VPWR sky130_fd_sc_hd__fill_1
X_4142_ _6276_/Q _6267_/Q _4257_/S VGND VGND VPWR VPWR _4142_/X sky130_fd_sc_hd__mux2_1
XFILLER_95_253 VGND VGND VPWR VPWR sky130_fd_sc_hd__fill_2
X_4073_ _5257_/Q _6046_/Q _6037_/Q _6345_/Q _4270_/S _4212_/A VGND VGND VPWR VPWR
+ _4073_/X sky130_fd_sc_hd__mux4_1
XANTENNA__4409__S _4416_/S VGND VGND VPWR VPWR sky130_fd_sc_hd__diode_2
X_3024_ _3020_/X _3022_/X _3023_/X _2641_/Y VGND VGND VPWR VPWR _3024_/X sky130_fd_sc_hd__a22o_1
XFILLER_83_437 VGND VGND VPWR VPWR sky130_fd_sc_hd__fill_1
XFILLER_55_128 VPWR VGND VPWR VGND sky130_ef_sc_hd__decap_40_12
XFILLER_36_320 VGND VGND VPWR VPWR sky130_fd_sc_hd__fill_1
XFILLER_37_821 VPWR VGND VPWR VGND sky130_ef_sc_hd__decap_40_12
XANTENNA__2921__S0 _3033_/S VGND VGND VPWR VPWR sky130_fd_sc_hd__diode_2
XFILLER_70_109 VGND VGND VPWR VPWR sky130_fd_sc_hd__fill_4
XFILLER_52_813 VPWR VGND VPWR VGND sky130_ef_sc_hd__decap_40_12
XTAP_TAPCELL_ROW_19_584 VGND VPWR sky130_fd_sc_hd__tapvpwrvgnd_1
XFILLER_51_345 VGND VGND VPWR VPWR sky130_fd_sc_hd__fill_1
XFILLER_24_559 VGND VGND VPWR VPWR sky130_fd_sc_hd__fill_1
X_4975_ _5050_/B _4975_/B VGND VGND VPWR VPWR _4984_/S sky130_fd_sc_hd__nor2_4
XANTENNA__5240__A1 _4445_/A VGND VGND VPWR VPWR sky130_fd_sc_hd__diode_2
X_3926_ hold706/X _3926_/A1 _3928_/S VGND VGND VPWR VPWR _3926_/X sky130_fd_sc_hd__mux2_1
XANTENNA_fanout142_A _4600_/A VGND VGND VPWR VPWR sky130_fd_sc_hd__diode_2
X_3857_ input7/X input8/X _4922_/B _4918_/A VGND VGND VPWR VPWR _3857_/X sky130_fd_sc_hd__or4b_1
XFILLER_50_29 VGND VGND VPWR VPWR sky130_fd_sc_hd__fill_4
Xclkload7 clkload7/A VGND VGND VPWR VPWR clkload7/Y sky130_fd_sc_hd__clkinvlp_4
X_2808_ _3089_/C1 _2807_/X _2804_/Y _2806_/Y VGND VGND VPWR VPWR _2808_/X sky130_fd_sc_hd__o2bb2a_1
XANTENNA__3003__B1 _2995_/A VGND VGND VPWR VPWR sky130_fd_sc_hd__diode_2
X_3788_ _4493_/B _4513_/B VGND VGND VPWR VPWR _3797_/S sky130_fd_sc_hd__nor2_4
X_5527_ _6437_/CLK _5527_/D VGND VGND VPWR VPWR _5527_/Q sky130_fd_sc_hd__dfxtp_1
XFILLER_117_152 VGND VGND VPWR VPWR sky130_fd_sc_hd__fill_1
X_2739_ _2663_/A _2736_/B _2738_/Y VGND VGND VPWR VPWR _5271_/D sky130_fd_sc_hd__o21a_1
XTAP_TAPCELL_ROW_76_1434 VGND VPWR sky130_fd_sc_hd__tapvpwrvgnd_1
XFILLER_118_697 VGND VGND VPWR VPWR sky130_fd_sc_hd__fill_2
XFILLER_106_837 VGND VGND VPWR VPWR sky130_fd_sc_hd__fill_4
XTAP_TAPCELL_ROW_76_1445 VGND VPWR sky130_fd_sc_hd__tapvpwrvgnd_1
XANTENNA__3306__A1 _5235_/A0 VGND VGND VPWR VPWR sky130_fd_sc_hd__diode_2
XFILLER_59_38 VGND VGND VPWR VPWR sky130_fd_sc_hd__fill_1
X_5458_ _5784_/CLK _5458_/D VGND VGND VPWR VPWR _5458_/Q sky130_fd_sc_hd__dfxtp_1
Xfanout200 _3836_/Y VGND VGND VPWR VPWR _4922_/C sky130_fd_sc_hd__clkbuf_4
XFILLER_59_401 VGND VGND VPWR VPWR sky130_fd_sc_hd__fill_1
X_4409_ _5052_/A1 hold673/X _4416_/S VGND VGND VPWR VPWR _4409_/X sky130_fd_sc_hd__mux2_1
X_5389_ _6420_/CLK _5389_/D VGND VGND VPWR VPWR _5389_/Q sky130_fd_sc_hd__dfxtp_1
XFILLER_87_765 VPWR VGND VPWR VGND sky130_ef_sc_hd__decap_40_12
XFILLER_59_445 VGND VGND VPWR VPWR sky130_fd_sc_hd__fill_2
XANTENNA__5059__A1 _5832_/Q VGND VGND VPWR VPWR sky130_fd_sc_hd__diode_2
XFILLER_101_553 VGND VGND VPWR VPWR sky130_fd_sc_hd__fill_4
XFILLER_86_253 VGND VGND VPWR VPWR sky130_fd_sc_hd__fill_1
XANTENNA__2628__A _2628_/A VGND VGND VPWR VPWR sky130_fd_sc_hd__diode_2
XFILLER_101_597 VPWR VGND VPWR VGND sky130_ef_sc_hd__decap_40_12
XFILLER_75_48 VGND VGND VPWR VPWR sky130_fd_sc_hd__fill_2
XFILLER_46_139 VGND VGND VPWR VPWR sky130_fd_sc_hd__fill_1
XANTENNA__4806__A1 _4811_/C1 VGND VGND VPWR VPWR sky130_fd_sc_hd__diode_2
XFILLER_74_459 VGND VGND VPWR VPWR sky130_fd_sc_hd__fill_1
XFILLER_27_353 VGND VGND VPWR VPWR sky130_fd_sc_hd__fill_4
XTAP_TAPCELL_ROW_120_2100 VGND VPWR sky130_fd_sc_hd__tapvpwrvgnd_1
XFILLER_54_161 VGND VGND VPWR VPWR sky130_fd_sc_hd__fill_1
XTAP_TAPCELL_ROW_38_871 VGND VPWR sky130_fd_sc_hd__tapvpwrvgnd_1
XFILLER_131_98 VGND VGND VPWR VPWR sky130_fd_sc_hd__fill_4
XFILLER_70_643 VGND VGND VPWR VPWR sky130_fd_sc_hd__fill_1
XFILLER_15_559 VGND VGND VPWR VPWR sky130_fd_sc_hd__fill_1
XFILLER_70_665 VGND VGND VPWR VPWR sky130_fd_sc_hd__fill_1
XANTENNA__4054__S _4257_/S VGND VGND VPWR VPWR sky130_fd_sc_hd__diode_2
XFILLER_30_529 VGND VGND VPWR VPWR sky130_fd_sc_hd__fill_2
XFILLER_11_721 VGND VGND VPWR VPWR sky130_fd_sc_hd__fill_4
XANTENNA__3793__A1 _5212_/A1 VGND VGND VPWR VPWR sky130_fd_sc_hd__diode_2
XANTENNA__3893__S _3899_/S VGND VGND VPWR VPWR sky130_fd_sc_hd__diode_2
XANTENNA__4989__S _4993_/S VGND VGND VPWR VPWR sky130_fd_sc_hd__diode_2
XFILLER_7_725 VGND VGND VPWR VPWR sky130_fd_sc_hd__fill_2
XFILLER_11_765 VPWR VGND VPWR VGND sky130_ef_sc_hd__decap_40_12
XTAP_TAPCELL_ROW_118_2073 VGND VPWR sky130_fd_sc_hd__tapvpwrvgnd_1
XFILLER_124_601 VPWR VGND VPWR VGND sky130_ef_sc_hd__decap_40_12
XFILLER_136_472 VGND VGND VPWR VPWR sky130_fd_sc_hd__fill_4
XFILLER_123_111 VGND VGND VPWR VPWR sky130_fd_sc_hd__fill_1
XFILLER_109_697 VPWR VGND VPWR VGND sky130_ef_sc_hd__decap_40_12
XFILLER_108_185 VGND VGND VPWR VPWR sky130_fd_sc_hd__fill_8
XTAP_TAPCELL_ROW_131_2262 VGND VPWR sky130_fd_sc_hd__tapvpwrvgnd_1
XFILLER_124_645 VPWR VGND VPWR VGND sky130_ef_sc_hd__decap_40_12
XFILLER_123_144 VGND VGND VPWR VPWR sky130_fd_sc_hd__fill_1
XFILLER_111_339 VGND VGND VPWR VPWR sky130_fd_sc_hd__fill_2
XFILLER_78_765 VPWR VGND VPWR VGND sky130_ef_sc_hd__decap_40_12
XFILLER_65_404 VGND VGND VPWR VPWR sky130_fd_sc_hd__fill_1
XFILLER_19_821 VPWR VGND VPWR VGND sky130_ef_sc_hd__decap_40_12
XTAP_TAPCELL_ROW_47_1002 VGND VPWR sky130_fd_sc_hd__tapvpwrvgnd_1
XFILLER_34_813 VPWR VGND VPWR VGND sky130_ef_sc_hd__decap_40_12
XTAP_TAPCELL_ROW_16_543 VGND VPWR sky130_fd_sc_hd__tapvpwrvgnd_1
XTAP_TAPCELL_ROW_60_1202 VGND VPWR sky130_fd_sc_hd__tapvpwrvgnd_1
XANTENNA__3233__B1 _3801_/A VGND VGND VPWR VPWR sky130_fd_sc_hd__diode_2
XFILLER_14_581 VGND VGND VPWR VPWR sky130_fd_sc_hd__fill_4
XFILLER_21_529 VPWR VGND VPWR VGND sky130_ef_sc_hd__decap_40_12
X_4760_ _4809_/A _4760_/B VGND VGND VPWR VPWR _4760_/X sky130_fd_sc_hd__or2_1
XANTENNA__4899__S _4906_/S VGND VGND VPWR VPWR sky130_fd_sc_hd__diode_2
XPHY_EDGE_ROW_112_Right_112 VGND VGND VPWR VPWR sky130_fd_sc_hd__decap_3
X_3711_ hold95/X _4978_/A1 _3717_/S VGND VGND VPWR VPWR hold96/A sky130_fd_sc_hd__mux2_1
X_4691_ _5800_/Q _5791_/Q _4801_/S VGND VGND VPWR VPWR _4691_/X sky130_fd_sc_hd__mux2_1
XANTENNA__3784__A1 _5213_/A1 VGND VGND VPWR VPWR sky130_fd_sc_hd__diode_2
X_6430_ _6434_/CLK _6430_/D VGND VGND VPWR VPWR _6430_/Q sky130_fd_sc_hd__dfxtp_1
Xclkload102 _6380_/CLK VGND VGND VPWR VPWR clkload102/Y sky130_fd_sc_hd__bufinv_16
X_3642_ hold371/X _4517_/A1 _3647_/S VGND VGND VPWR VPWR _3642_/X sky130_fd_sc_hd__mux2_1
X_6361_ _6428_/CLK _6361_/D VGND VGND VPWR VPWR _6361_/Q sky130_fd_sc_hd__dfxtp_1
XANTENNA__3536__A1 _5232_/A0 VGND VGND VPWR VPWR sky130_fd_sc_hd__diode_2
X_5312_ _6432_/CLK _5312_/D VGND VGND VPWR VPWR _5312_/Q sky130_fd_sc_hd__dfxtp_1
X_3573_ hold387/X _4521_/A1 _3574_/S VGND VGND VPWR VPWR _3573_/X sky130_fd_sc_hd__mux2_1
XPHY_EDGE_ROW_49_Right_49 VGND VGND VPWR VPWR sky130_fd_sc_hd__decap_3
X_6292_ _6292_/CLK _6292_/D VGND VGND VPWR VPWR _6292_/Q sky130_fd_sc_hd__dfxtp_1
XTAP_TAPCELL_ROW_58_1175 VGND VPWR sky130_fd_sc_hd__tapvpwrvgnd_1
XTAP_TAPCELL_ROW_58_1164 VGND VPWR sky130_fd_sc_hd__tapvpwrvgnd_1
XFILLER_5_290 VGND VGND VPWR VPWR sky130_fd_sc_hd__fill_2
X_5243_ _6252_/CLK _5243_/D VGND VGND VPWR VPWR _5243_/Q sky130_fd_sc_hd__dfxtp_1
XFILLER_130_637 VGND VGND VPWR VPWR sky130_fd_sc_hd__fill_4
X_5174_ _3958_/A _5172_/X _5173_/X _3949_/Y VGND VGND VPWR VPWR _5174_/X sky130_fd_sc_hd__o22a_1
XTAP_TAPCELL_ROW_71_1364 VGND VPWR sky130_fd_sc_hd__tapvpwrvgnd_1
XFILLER_29_19 VGND VGND VPWR VPWR sky130_fd_sc_hd__fill_2
Xhold19 hold19/A VGND VGND VPWR VPWR hold19/X sky130_fd_sc_hd__dlygate4sd3_1
XFILLER_84_713 VGND VGND VPWR VPWR sky130_fd_sc_hd__fill_4
XANTENNA__5820__Q _5820_/Q VGND VGND VPWR VPWR sky130_fd_sc_hd__diode_2
Xhold1904 _6290_/Q VGND VGND VPWR VPWR _4956_/A1 sky130_fd_sc_hd__dlygate4sd3_1
Xhold1926 _3155_/X VGND VGND VPWR VPWR _5336_/D sky130_fd_sc_hd__dlygate4sd3_1
Xhold1915 _5708_/Q VGND VGND VPWR VPWR _3686_/A1 sky130_fd_sc_hd__dlygate4sd3_1
X_4125_ _6021_/Q _6012_/Q _4213_/S VGND VGND VPWR VPWR _4126_/B sky130_fd_sc_hd__mux2_1
XANTENNA__3043__S _3072_/S VGND VGND VPWR VPWR sky130_fd_sc_hd__diode_2
Xhold1937 _6215_/Q VGND VGND VPWR VPWR _4864_/A1 sky130_fd_sc_hd__dlygate4sd3_1
XFILLER_83_223 VGND VGND VPWR VPWR sky130_fd_sc_hd__fill_1
Xhold1948 _6383_/Q VGND VGND VPWR VPWR _3998_/B sky130_fd_sc_hd__dlygate4sd3_1
XFILLER_56_415 VGND VGND VPWR VPWR sky130_fd_sc_hd__fill_1
Xhold1959 _5707_/Q VGND VGND VPWR VPWR _3685_/A1 sky130_fd_sc_hd__dlygate4sd3_1
XPHY_EDGE_ROW_58_Right_58 VGND VGND VPWR VPWR sky130_fd_sc_hd__decap_3
X_4056_ _6273_/Q _6264_/Q _4257_/S VGND VGND VPWR VPWR _4056_/X sky130_fd_sc_hd__mux2_1
XANTENNA__3472__A0 _4901_/A0 VGND VGND VPWR VPWR sky130_fd_sc_hd__diode_2
X_3007_ _3036_/A1 _3006_/X _3094_/C1 VGND VGND VPWR VPWR _3007_/Y sky130_fd_sc_hd__o21ai_1
XFILLER_71_429 VGND VGND VPWR VPWR sky130_fd_sc_hd__fill_2
XANTENNA__4663__A _4663_/A VGND VGND VPWR VPWR sky130_fd_sc_hd__diode_2
XTAP_TAPCELL_ROW_35_830 VGND VPWR sky130_fd_sc_hd__tapvpwrvgnd_1
XFILLER_101_57 VGND VGND VPWR VPWR sky130_fd_sc_hd__fill_2
XANTENNA__3279__A _3801_/A VGND VGND VPWR VPWR sky130_fd_sc_hd__diode_2
XANTENNA__5213__A1 _5213_/A1 VGND VGND VPWR VPWR sky130_fd_sc_hd__diode_2
X_4958_ _4958_/A0 _4958_/A1 _4964_/S VGND VGND VPWR VPWR _6292_/D sky130_fd_sc_hd__mux2_1
XANTENNA_fanout145_X _4600_/A VGND VGND VPWR VPWR sky130_fd_sc_hd__diode_2
XFILLER_12_529 VGND VGND VPWR VPWR sky130_fd_sc_hd__fill_2
XFILLER_24_389 VPWR VGND VPWR VGND sky130_ef_sc_hd__decap_40_12
XFILLER_138_737 VGND VGND VPWR VPWR sky130_fd_sc_hd__fill_1
X_4889_ hold847/X _4889_/A1 _4893_/S VGND VGND VPWR VPWR _4889_/X sky130_fd_sc_hd__mux2_1
XANTENNA__5267__Q _5267_/Q VGND VGND VPWR VPWR sky130_fd_sc_hd__diode_2
X_3909_ _4493_/A _4955_/B VGND VGND VPWR VPWR _3918_/S sky130_fd_sc_hd__nor2_4
XANTENNA__4972__A0 _4982_/A1 VGND VGND VPWR VPWR sky130_fd_sc_hd__diode_2
XFILLER_137_225 VGND VGND VPWR VPWR sky130_fd_sc_hd__fill_1
XFILLER_106_601 VPWR VGND VPWR VGND sky130_ef_sc_hd__decap_40_12
XPHY_EDGE_ROW_67_Right_67 VGND VGND VPWR VPWR sky130_fd_sc_hd__decap_3
XANTENNA__3218__S _3220_/S VGND VGND VPWR VPWR sky130_fd_sc_hd__diode_2
XFILLER_106_645 VPWR VGND VPWR VGND sky130_ef_sc_hd__decap_40_12
XFILLER_121_615 VGND VGND VPWR VPWR sky130_fd_sc_hd__fill_1
XANTENNA__4397__X _4406_/S VGND VGND VPWR VPWR sky130_fd_sc_hd__diode_2
XANTENNA__2629__Y _2629_/Y VGND VGND VPWR VPWR sky130_fd_sc_hd__diode_2
XANTENNA__4049__S _4237_/S VGND VGND VPWR VPWR sky130_fd_sc_hd__diode_2
XTAP_TAPCELL_ROW_89_1636 VGND VPWR sky130_fd_sc_hd__tapvpwrvgnd_1
XPHY_EDGE_ROW_76_Right_76 VGND VGND VPWR VPWR sky130_fd_sc_hd__decap_3
XFILLER_75_746 VGND VGND VPWR VPWR sky130_fd_sc_hd__fill_2
XFILLER_59_297 VGND VGND VPWR VPWR sky130_fd_sc_hd__fill_1
XFILLER_47_415 VGND VGND VPWR VPWR sky130_fd_sc_hd__fill_2
XFILLER_19_128 VGND VGND VPWR VPWR sky130_fd_sc_hd__fill_1
XFILLER_90_705 VGND VGND VPWR VPWR sky130_fd_sc_hd__fill_1
XANTENNA_fanout58_X _3958_/A VGND VGND VPWR VPWR sky130_fd_sc_hd__diode_2
XFILLER_19_85 VGND VGND VPWR VPWR sky130_fd_sc_hd__fill_2
XFILLER_74_278 VGND VGND VPWR VPWR sky130_fd_sc_hd__fill_1
XFILLER_16_813 VPWR VGND VPWR VGND sky130_ef_sc_hd__decap_40_12
XFILLER_15_334 VGND VGND VPWR VPWR sky130_fd_sc_hd__fill_2
XANTENNA_clkbuf_leaf_52_clk_A clkload6/A VGND VGND VPWR VPWR sky130_fd_sc_hd__diode_2
XANTENNA__3215__A0 _5232_/A0 VGND VGND VPWR VPWR sky130_fd_sc_hd__diode_2
XTAP_TAPCELL_ROW_100_1803 VGND VPWR sky130_fd_sc_hd__tapvpwrvgnd_1
XTAP_TAPCELL_ROW_13_502 VGND VPWR sky130_fd_sc_hd__tapvpwrvgnd_1
XANTENNA__4963__A0 _5215_/A1 VGND VGND VPWR VPWR sky130_fd_sc_hd__diode_2
XANTENNA__3766__A1 _4984_/A1 VGND VGND VPWR VPWR sky130_fd_sc_hd__diode_2
XTAP_TAPCELL_ROW_133_2302 VGND VPWR sky130_fd_sc_hd__tapvpwrvgnd_1
XPHY_EDGE_ROW_85_Right_85 VGND VGND VPWR VPWR sky130_fd_sc_hd__decap_3
XANTENNA_clkbuf_leaf_67_clk_A clkload5/A VGND VGND VPWR VPWR sky130_fd_sc_hd__diode_2
XFILLER_11_573 VPWR VGND VPWR VGND sky130_ef_sc_hd__decap_40_12
XFILLER_137_781 VGND VGND VPWR VPWR sky130_fd_sc_hd__fill_2
XANTENNA_clkbuf_leaf_110_clk_A clkload0/A VGND VGND VPWR VPWR sky130_fd_sc_hd__diode_2
XFILLER_98_805 VGND VGND VPWR VPWR sky130_fd_sc_hd__fill_4
XFILLER_112_637 VGND VGND VPWR VPWR sky130_fd_sc_hd__fill_4
XTAP_TAPCELL_ROW_111_1965 VGND VPWR sky130_fd_sc_hd__tapvpwrvgnd_1
XFILLER_97_348 VGND VGND VPWR VPWR sky130_fd_sc_hd__fill_4
XFILLER_3_783 VGND VGND VPWR VPWR sky130_fd_sc_hd__fill_1
XPHY_EDGE_ROW_94_Right_94 VGND VGND VPWR VPWR sky130_fd_sc_hd__decap_3
XPHY_EDGE_ROW_29_Left_168 VGND VGND VPWR VPWR sky130_fd_sc_hd__decap_3
XFILLER_120_681 VPWR VGND VPWR VGND sky130_ef_sc_hd__decap_40_12
XTAP_TAPCELL_ROW_53_1094 VGND VPWR sky130_fd_sc_hd__tapvpwrvgnd_1
X_5930_ _6341_/CLK hold74/X VGND VGND VPWR VPWR hold73/A sky130_fd_sc_hd__dfxtp_1
XFILLER_19_673 VPWR VGND VPWR VGND sky130_ef_sc_hd__decap_40_12
XFILLER_74_790 VPWR VGND VPWR VGND sky130_ef_sc_hd__decap_40_12
XFILLER_46_492 VGND VGND VPWR VPWR sky130_fd_sc_hd__fill_1
XFILLER_34_643 VGND VGND VPWR VPWR sky130_fd_sc_hd__fill_1
X_5861_ _6057_/CLK _5861_/D VGND VGND VPWR VPWR _5861_/Q sky130_fd_sc_hd__dfxtp_1
XFILLER_22_805 VGND VGND VPWR VPWR sky130_fd_sc_hd__fill_4
XPHY_EDGE_ROW_1_Left_140 VGND VGND VPWR VPWR sky130_fd_sc_hd__decap_3
X_5792_ _6122_/CLK _5792_/D VGND VGND VPWR VPWR _5792_/Q sky130_fd_sc_hd__dfxtp_1
XPHY_EDGE_ROW_38_Left_177 VGND VGND VPWR VPWR sky130_fd_sc_hd__decap_3
X_4812_ _2628_/A _4807_/X _4811_/X VGND VGND VPWR VPWR _4812_/Y sky130_fd_sc_hd__a21oi_1
X_4743_ _4799_/A _4735_/X _4742_/Y _3278_/A VGND VGND VPWR VPWR _4743_/X sky130_fd_sc_hd__a211o_1
XANTENNA__4954__A0 _4984_/A1 VGND VGND VPWR VPWR sky130_fd_sc_hd__diode_2
X_4674_ _4811_/C1 _4673_/X _4670_/Y _4672_/Y VGND VGND VPWR VPWR _4674_/X sky130_fd_sc_hd__o2bb2a_1
X_6413_ _6417_/CLK _6413_/D VGND VGND VPWR VPWR _6413_/Q sky130_fd_sc_hd__dfxtp_2
XFILLER_135_729 VPWR VGND VPWR VGND sky130_ef_sc_hd__decap_40_12
XFILLER_134_217 VGND VGND VPWR VPWR sky130_fd_sc_hd__fill_1
XFILLER_134_206 VGND VGND VPWR VPWR sky130_fd_sc_hd__fill_1
XFILLER_128_781 VPWR VGND VPWR VGND sky130_ef_sc_hd__decap_40_12
XANTENNA__5815__Q _5815_/Q VGND VGND VPWR VPWR sky130_fd_sc_hd__diode_2
X_3625_ hold886/X _3926_/A1 _3627_/S VGND VGND VPWR VPWR _3625_/X sky130_fd_sc_hd__mux2_1
XFILLER_134_239 VGND VGND VPWR VPWR sky130_fd_sc_hd__fill_1
X_3556_ _4515_/A1 _3556_/A1 _3562_/S VGND VGND VPWR VPWR _5595_/D sky130_fd_sc_hd__mux2_1
X_6344_ _6345_/CLK _6344_/D VGND VGND VPWR VPWR _6344_/Q sky130_fd_sc_hd__dfxtp_1
XFILLER_1_709 VPWR VGND VPWR VGND sky130_ef_sc_hd__decap_40_12
XFILLER_103_615 VGND VGND VPWR VPWR sky130_fd_sc_hd__fill_1
X_6275_ _6302_/CLK _6275_/D VGND VGND VPWR VPWR _6275_/Q sky130_fd_sc_hd__dfxtp_1
X_5226_ _5238_/A1 _5226_/A1 _5237_/S VGND VGND VPWR VPWR _5226_/X sky130_fd_sc_hd__mux2_1
XFILLER_115_497 VGND VGND VPWR VPWR sky130_fd_sc_hd__fill_4
X_3487_ _3487_/A0 _4903_/A0 _3490_/S VGND VGND VPWR VPWR _3487_/X sky130_fd_sc_hd__mux2_1
XPHY_EDGE_ROW_47_Left_186 VGND VGND VPWR VPWR sky130_fd_sc_hd__decap_3
Xhold1701 _6200_/Q VGND VGND VPWR VPWR _4848_/A1 sky130_fd_sc_hd__dlygate4sd3_1
XFILLER_84_510 VGND VGND VPWR VPWR sky130_fd_sc_hd__fill_1
X_5157_ _6395_/Q _5152_/B _3944_/A VGND VGND VPWR VPWR _5157_/Y sky130_fd_sc_hd__o21ai_1
Xhold1734 _3706_/X VGND VGND VPWR VPWR _5727_/D sky130_fd_sc_hd__dlygate4sd3_1
XFILLER_57_724 VGND VGND VPWR VPWR sky130_fd_sc_hd__fill_2
Xhold1723 _5778_/Q VGND VGND VPWR VPWR _3768_/A1 sky130_fd_sc_hd__dlygate4sd3_1
Xhold1712 _6303_/Q VGND VGND VPWR VPWR _4970_/A1 sky130_fd_sc_hd__dlygate4sd3_1
XANTENNA__4945__X _4954_/S VGND VGND VPWR VPWR sky130_fd_sc_hd__diode_2
XFILLER_29_426 VPWR VGND VPWR VGND sky130_ef_sc_hd__decap_40_12
Xhold1756 _6179_/Q VGND VGND VPWR VPWR _4825_/A1 sky130_fd_sc_hd__dlygate4sd3_1
Xhold1767 _3597_/X VGND VGND VPWR VPWR _5630_/D sky130_fd_sc_hd__dlygate4sd3_1
X_5088_ _5088_/A0 _6164_/Q _5094_/S VGND VGND VPWR VPWR _5088_/X sky130_fd_sc_hd__mux2_1
Xhold1745 _4399_/X VGND VGND VPWR VPWR _6037_/D sky130_fd_sc_hd__dlygate4sd3_1
X_4108_ _4252_/A1 _4107_/X _4252_/B1 VGND VGND VPWR VPWR _4108_/X sky130_fd_sc_hd__o21a_1
Xhold1778 _6282_/Q VGND VGND VPWR VPWR _4947_/A1 sky130_fd_sc_hd__dlygate4sd3_1
Xhold1789 _4865_/X VGND VGND VPWR VPWR _6216_/D sky130_fd_sc_hd__dlygate4sd3_1
XFILLER_44_418 VGND VGND VPWR VPWR sky130_fd_sc_hd__fill_2
X_4039_ _6299_/Q _6281_/Q _4258_/S VGND VGND VPWR VPWR _4040_/B sky130_fd_sc_hd__mux2_1
XANTENNA__3501__S _3503_/S VGND VGND VPWR VPWR sky130_fd_sc_hd__diode_2
XFILLER_71_248 VGND VGND VPWR VPWR sky130_fd_sc_hd__fill_1
XFILLER_112_89 VGND VGND VPWR VPWR sky130_fd_sc_hd__fill_1
XTAP_TAPCELL_ROW_84_1566 VGND VPWR sky130_fd_sc_hd__tapvpwrvgnd_1
XTAP_TAPCELL_ROW_84_1555 VGND VPWR sky130_fd_sc_hd__tapvpwrvgnd_1
XPHY_EDGE_ROW_56_Left_195 VGND VGND VPWR VPWR sky130_fd_sc_hd__decap_3
XFILLER_52_440 VGND VGND VPWR VPWR sky130_fd_sc_hd__fill_4
XFILLER_52_495 VGND VGND VPWR VPWR sky130_fd_sc_hd__fill_1
XFILLER_9_809 VPWR VGND VPWR VGND sky130_ef_sc_hd__decap_40_12
XFILLER_138_501 VGND VGND VPWR VPWR sky130_fd_sc_hd__fill_2
XFILLER_138_545 VPWR VGND VPWR VGND sky130_ef_sc_hd__decap_40_12
XANTENNA__2641__A _3027_/A VGND VGND VPWR VPWR sky130_fd_sc_hd__diode_2
XTAP_TAPCELL_ROW_115_2021 VGND VPWR sky130_fd_sc_hd__tapvpwrvgnd_1
XFILLER_138_589 VPWR VGND VPWR VGND sky130_ef_sc_hd__decap_40_12
XFILLER_119_781 VGND VGND VPWR VPWR sky130_fd_sc_hd__fill_2
XTAP_TAPCELL_ROW_115_2032 VGND VPWR sky130_fd_sc_hd__tapvpwrvgnd_1
XFILLER_115_3 VPWR VGND VPWR VGND sky130_ef_sc_hd__decap_40_12
XFILLER_4_525 VGND VGND VPWR VPWR sky130_fd_sc_hd__fill_4
XFILLER_137_86 VGND VGND VPWR VPWR sky130_fd_sc_hd__fill_2
XFILLER_106_475 VGND VGND VPWR VPWR sky130_fd_sc_hd__fill_1
XFILLER_4_569 VPWR VGND VPWR VGND sky130_ef_sc_hd__decap_40_12
XANTENNA__3920__A1 _4484_/A0 VGND VGND VPWR VPWR sky130_fd_sc_hd__diode_2
XFILLER_133_294 VGND VGND VPWR VPWR sky130_fd_sc_hd__fill_1
XFILLER_97_79 VGND VGND VPWR VPWR sky130_fd_sc_hd__fill_1
XANTENNA__5122__B1 _4007_/A VGND VGND VPWR VPWR sky130_fd_sc_hd__diode_2
XFILLER_121_445 VGND VGND VPWR VPWR sky130_fd_sc_hd__fill_1
XANTENNA__4855__X _4867_/S VGND VGND VPWR VPWR sky130_fd_sc_hd__diode_2
XFILLER_102_681 VPWR VGND VPWR VGND sky130_ef_sc_hd__decap_40_12
XFILLER_0_797 VGND VGND VPWR VPWR sky130_fd_sc_hd__fill_4
XANTENNA__3684__A0 _4488_/A0 VGND VGND VPWR VPWR sky130_fd_sc_hd__diode_2
XFILLER_63_705 VGND VGND VPWR VPWR sky130_fd_sc_hd__fill_1
XTAP_TAPCELL_ROW_126_2183 VGND VPWR sky130_fd_sc_hd__tapvpwrvgnd_1
XFILLER_90_513 VPWR VGND VPWR VGND sky130_ef_sc_hd__decap_40_12
XFILLER_75_576 VGND VGND VPWR VPWR sky130_fd_sc_hd__fill_8
XTAP_TAPCELL_ROW_126_2194 VGND VPWR sky130_fd_sc_hd__tapvpwrvgnd_1
XFILLER_90_557 VGND VGND VPWR VPWR sky130_fd_sc_hd__fill_2
XFILLER_46_83 VGND VGND VPWR VPWR sky130_fd_sc_hd__fill_1
XFILLER_16_643 VGND VGND VPWR VPWR sky130_fd_sc_hd__fill_1
XANTENNA__3739__A1 _5075_/A0 VGND VGND VPWR VPWR sky130_fd_sc_hd__diode_2
XANTENNA__4936__A0 _4976_/A1 VGND VGND VPWR VPWR sky130_fd_sc_hd__diode_2
XTAP_TAPCELL_ROW_26_693 VGND VPWR sky130_fd_sc_hd__tapvpwrvgnd_1
Xclkbuf_leaf_104_clk clkload0/A VGND VGND VPWR VPWR _6316_/CLK sky130_fd_sc_hd__clkbuf_8
XANTENNA__3366__B input4/X VGND VGND VPWR VPWR sky130_fd_sc_hd__diode_2
XFILLER_7_55 VGND VGND VPWR VPWR sky130_fd_sc_hd__fill_1
XFILLER_117_729 VPWR VGND VPWR VGND sky130_ef_sc_hd__decap_40_12
Xhold308 _3905_/X VGND VGND VPWR VPWR _5884_/D sky130_fd_sc_hd__dlygate4sd3_1
Xhold319 _5305_/Q VGND VGND VPWR VPWR hold319/X sky130_fd_sc_hd__dlygate4sd3_1
XFILLER_7_385 VGND VGND VPWR VPWR sky130_fd_sc_hd__fill_4
X_4390_ _4978_/A1 _4390_/A1 _4396_/S VGND VGND VPWR VPWR _4390_/X sky130_fd_sc_hd__mux2_1
X_3410_ _4982_/A1 hold986/X _3412_/S VGND VGND VPWR VPWR _5465_/D sky130_fd_sc_hd__mux2_1
XFILLER_98_613 VPWR VGND VPWR VGND sky130_ef_sc_hd__decap_40_12
XTAP_TAPCELL_ROW_55_1123 VGND VPWR sky130_fd_sc_hd__tapvpwrvgnd_1
X_3341_ _4013_/B _5123_/A _3988_/B VGND VGND VPWR VPWR _5112_/B sky130_fd_sc_hd__or3_4
XANTENNA__3911__A1 _5209_/A1 VGND VGND VPWR VPWR sky130_fd_sc_hd__diode_2
XANTENNA__5073__S _5081_/S VGND VGND VPWR VPWR sky130_fd_sc_hd__diode_2
XFILLER_124_272 VGND VGND VPWR VPWR sky130_fd_sc_hd__fill_1
XFILLER_98_657 VPWR VGND VPWR VGND sky130_ef_sc_hd__decap_40_12
X_6060_ _6060_/CLK _6060_/D VGND VGND VPWR VPWR _6060_/Q sky130_fd_sc_hd__dfxtp_1
XANTENNA__5113__B1 _5201_/B VGND VGND VPWR VPWR sky130_fd_sc_hd__diode_2
X_3272_ _4663_/A _4600_/A _3272_/C VGND VGND VPWR VPWR _3278_/C sky130_fd_sc_hd__and3_1
XFILLER_30_3 VPWR VGND VPWR VGND sky130_ef_sc_hd__decap_40_12
Xhold1019 _3216_/X VGND VGND VPWR VPWR _5376_/D sky130_fd_sc_hd__dlygate4sd3_1
X_5011_ _5029_/B _5110_/A _5011_/C VGND VGND VPWR VPWR _5012_/C sky130_fd_sc_hd__nor3_1
XANTENNA__3675__A0 _5213_/A1 VGND VGND VPWR VPWR sky130_fd_sc_hd__diode_2
Xhold1008 _5678_/Q VGND VGND VPWR VPWR _3652_/A0 sky130_fd_sc_hd__dlygate4sd3_1
XFILLER_94_841 VGND VGND VPWR VPWR sky130_fd_sc_hd__fill_1
XFILLER_39_768 VPWR VGND VPWR VGND sky130_ef_sc_hd__decap_40_12
XFILLER_66_587 VGND VGND VPWR VPWR sky130_fd_sc_hd__fill_1
XFILLER_38_278 VGND VGND VPWR VPWR sky130_fd_sc_hd__fill_1
X_5913_ _6310_/CLK _5913_/D VGND VGND VPWR VPWR _5913_/Q sky130_fd_sc_hd__dfxtp_1
XTAP_TAPCELL_ROW_66_1296 VGND VPWR sky130_fd_sc_hd__tapvpwrvgnd_1
XTAP_TAPCELL_ROW_66_1285 VGND VPWR sky130_fd_sc_hd__tapvpwrvgnd_1
X_5844_ _6094_/CLK _5844_/D VGND VGND VPWR VPWR _5844_/Q sky130_fd_sc_hd__dfxtp_1
XTAP_TAPCELL_ROW_45_980 VGND VPWR sky130_fd_sc_hd__tapvpwrvgnd_1
XFILLER_34_473 VGND VGND VPWR VPWR sky130_fd_sc_hd__fill_1
XFILLER_21_123 VGND VGND VPWR VPWR sky130_fd_sc_hd__fill_1
X_2987_ _3052_/A1 _2986_/X _3075_/C1 VGND VGND VPWR VPWR _2987_/X sky130_fd_sc_hd__o21a_1
XANTENNA__4152__S _4262_/S VGND VGND VPWR VPWR sky130_fd_sc_hd__diode_2
X_5775_ _6314_/CLK _5775_/D VGND VGND VPWR VPWR _5775_/Q sky130_fd_sc_hd__dfxtp_1
XFILLER_21_189 VGND VGND VPWR VPWR sky130_fd_sc_hd__fill_1
X_4726_ _4722_/X _4723_/X _4724_/X _4725_/X _2629_/Y _4663_/A VGND VGND VPWR VPWR
+ _4726_/X sky130_fd_sc_hd__mux4_1
X_4657_ _4791_/A1 _4656_/X _4792_/A1 VGND VGND VPWR VPWR _4657_/Y sky130_fd_sc_hd__o21ai_1
XFILLER_135_559 VGND VGND VPWR VPWR sky130_fd_sc_hd__fill_1
Xhold820 _4863_/X VGND VGND VPWR VPWR _6214_/D sky130_fd_sc_hd__dlygate4sd3_1
X_3608_ hold101/X _5208_/A1 _3616_/S VGND VGND VPWR VPWR _3608_/X sky130_fd_sc_hd__mux2_1
Xhold831 _6433_/Q VGND VGND VPWR VPWR hold831/X sky130_fd_sc_hd__dlygate4sd3_1
Xhold864 _3122_/X VGND VGND VPWR VPWR _5315_/D sky130_fd_sc_hd__dlygate4sd3_1
XANTENNA_fanout108_X _5040_/A1 VGND VGND VPWR VPWR sky130_fd_sc_hd__diode_2
X_6327_ _6417_/CLK _6327_/D VGND VGND VPWR VPWR _6327_/Q sky130_fd_sc_hd__dfxtp_2
Xhold842 _3709_/X VGND VGND VPWR VPWR _5729_/D sky130_fd_sc_hd__dlygate4sd3_1
XFILLER_1_517 VPWR VGND VPWR VGND sky130_ef_sc_hd__decap_40_12
Xhold853 _5718_/Q VGND VGND VPWR VPWR hold853/X sky130_fd_sc_hd__dlygate4sd3_1
XANTENNA__3902__A1 _5210_/A1 VGND VGND VPWR VPWR sky130_fd_sc_hd__diode_2
X_4588_ _4811_/C1 _4587_/X _4584_/Y _4586_/Y VGND VGND VPWR VPWR _4588_/X sky130_fd_sc_hd__o2bb2a_1
XFILLER_131_721 VGND VGND VPWR VPWR sky130_fd_sc_hd__fill_4
Xhold897 _3471_/X VGND VGND VPWR VPWR _5518_/D sky130_fd_sc_hd__dlygate4sd3_1
X_3539_ _3539_/A0 _5235_/A0 _3541_/S VGND VGND VPWR VPWR _3539_/X sky130_fd_sc_hd__mux2_1
XFILLER_89_635 VGND VGND VPWR VPWR sky130_fd_sc_hd__fill_2
Xhold886 _5654_/Q VGND VGND VPWR VPWR hold886/X sky130_fd_sc_hd__dlygate4sd3_1
Xhold875 _5745_/Q VGND VGND VPWR VPWR hold875/X sky130_fd_sc_hd__dlygate4sd3_1
XFILLER_131_765 VPWR VGND VPWR VGND sky130_ef_sc_hd__decap_40_12
XFILLER_130_253 VGND VGND VPWR VPWR sky130_fd_sc_hd__fill_1
XFILLER_103_467 VGND VGND VPWR VPWR sky130_fd_sc_hd__fill_2
XFILLER_103_445 VGND VGND VPWR VPWR sky130_fd_sc_hd__fill_1
X_6258_ _6261_/CLK _6258_/D VGND VGND VPWR VPWR _6258_/Q sky130_fd_sc_hd__dfxtp_1
XANTENNA__4458__A2 _3366_/X VGND VGND VPWR VPWR sky130_fd_sc_hd__diode_2
Xhold2221 _5830_/Q VGND VGND VPWR VPWR hold2221/X sky130_fd_sc_hd__dlygate4sd3_1
Xhold2210 _6385_/Q VGND VGND VPWR VPWR _2624_/A sky130_fd_sc_hd__dlygate4sd3_1
Xhold2254 _5252_/Q VGND VGND VPWR VPWR _3424_/C sky130_fd_sc_hd__dlygate4sd3_1
XFILLER_103_478 VGND VGND VPWR VPWR sky130_fd_sc_hd__fill_1
Xhold2232 _5819_/Q VGND VGND VPWR VPWR hold2232/X sky130_fd_sc_hd__dlygate4sd3_1
X_6189_ _6380_/CLK _6189_/D VGND VGND VPWR VPWR _6189_/Q sky130_fd_sc_hd__dfxtp_1
XANTENNA__3666__A0 _4521_/A1 VGND VGND VPWR VPWR sky130_fd_sc_hd__diode_2
Xhold2243 _5383_/Q VGND VGND VPWR VPWR _3668_/C sky130_fd_sc_hd__dlygate4sd3_1
X_5209_ _5209_/A0 _5209_/A1 _5213_/S VGND VGND VPWR VPWR _6411_/D sky130_fd_sc_hd__mux2_1
Xhold1553 _6365_/Q VGND VGND VPWR VPWR _5074_/A1 sky130_fd_sc_hd__dlygate4sd3_1
Xhold1531 _5547_/Q VGND VGND VPWR VPWR _3502_/A1 sky130_fd_sc_hd__dlygate4sd3_1
XFILLER_85_841 VGND VGND VPWR VPWR sky130_fd_sc_hd__fill_1
XFILLER_84_340 VGND VGND VPWR VPWR sky130_fd_sc_hd__fill_1
Xhold1520 _5685_/Q VGND VGND VPWR VPWR _3660_/A1 sky130_fd_sc_hd__dlygate4sd3_1
XTAP_TAPCELL_ROW_4_366 VGND VPWR sky130_fd_sc_hd__tapvpwrvgnd_1
XTAP_TAPCELL_ROW_4_355 VGND VPWR sky130_fd_sc_hd__tapvpwrvgnd_1
Xhold1542 _3672_/X VGND VGND VPWR VPWR _5695_/D sky130_fd_sc_hd__dlygate4sd3_1
Xhold1575 _3897_/X VGND VGND VPWR VPWR _5876_/D sky130_fd_sc_hd__dlygate4sd3_1
XFILLER_84_362 VGND VGND VPWR VPWR sky130_fd_sc_hd__fill_2
Xhold1564 _6031_/Q VGND VGND VPWR VPWR _4392_/A1 sky130_fd_sc_hd__dlygate4sd3_1
XFILLER_29_278 VGND VGND VPWR VPWR sky130_fd_sc_hd__fill_2
Xhold1586 _5979_/Q VGND VGND VPWR VPWR _4333_/A1 sky130_fd_sc_hd__dlygate4sd3_1
Xhold1597 _4961_/X VGND VGND VPWR VPWR _6295_/D sky130_fd_sc_hd__dlygate4sd3_1
XFILLER_72_535 VGND VGND VPWR VPWR sky130_fd_sc_hd__fill_1
XPHY_EDGE_ROW_64_Left_203 VGND VGND VPWR VPWR sky130_fd_sc_hd__decap_3
XANTENNA__2636__A _4241_/A VGND VGND VPWR VPWR sky130_fd_sc_hd__diode_2
XFILLER_17_429 VPWR VGND VPWR VGND sky130_ef_sc_hd__decap_40_12
XFILLER_29_289 VGND VGND VPWR VPWR sky130_fd_sc_hd__fill_8
XFILLER_38_790 VPWR VGND VPWR VGND sky130_ef_sc_hd__decap_40_12
XFILLER_16_42 VGND VGND VPWR VPWR sky130_fd_sc_hd__fill_1
XFILLER_53_782 VGND VGND VPWR VPWR sky130_fd_sc_hd__fill_2
XTAP_TAPCELL_ROW_43_939 VGND VPWR sky130_fd_sc_hd__tapvpwrvgnd_1
XFILLER_13_613 VGND VGND VPWR VPWR sky130_fd_sc_hd__fill_2
XFILLER_9_617 VPWR VGND VPWR VGND sky130_ef_sc_hd__decap_40_12
XTAP_TAPCELL_ROW_23_641 VGND VPWR sky130_fd_sc_hd__tapvpwrvgnd_1
XANTENNA__2642__Y _2642_/Y VGND VGND VPWR VPWR sky130_fd_sc_hd__diode_2
XTAP_TAPCELL_ROW_23_652 VGND VPWR sky130_fd_sc_hd__tapvpwrvgnd_1
XFILLER_12_189 VGND VGND VPWR VPWR sky130_fd_sc_hd__fill_4
XTAP_TAPCELL_ROW_97_1757 VGND VPWR sky130_fd_sc_hd__tapvpwrvgnd_1
XPHY_EDGE_ROW_73_Left_212 VGND VGND VPWR VPWR sky130_fd_sc_hd__decap_3
XFILLER_4_311 VGND VGND VPWR VPWR sky130_fd_sc_hd__fill_4
XFILLER_4_355 VGND VGND VPWR VPWR sky130_fd_sc_hd__fill_8
XFILLER_134_581 VGND VGND VPWR VPWR sky130_fd_sc_hd__fill_4
XFILLER_4_377 VPWR VGND VPWR VGND sky130_ef_sc_hd__decap_40_12
XTAP_TAPCELL_ROW_128_2223 VGND VPWR sky130_fd_sc_hd__tapvpwrvgnd_1
XANTENNA__4449__A2 _3366_/X VGND VGND VPWR VPWR sky130_fd_sc_hd__diode_2
XFILLER_67_318 VGND VGND VPWR VPWR sky130_fd_sc_hd__fill_2
XFILLER_0_561 VPWR VGND VPWR VGND sky130_ef_sc_hd__decap_40_12
XFILLER_76_841 VGND VGND VPWR VPWR sky130_fd_sc_hd__fill_1
XTAP_TAPCELL_ROW_50_1053 VGND VPWR sky130_fd_sc_hd__tapvpwrvgnd_1
XFILLER_48_521 VGND VGND VPWR VPWR sky130_fd_sc_hd__fill_2
XPHY_EDGE_ROW_82_Left_221 VGND VGND VPWR VPWR sky130_fd_sc_hd__decap_3
XFILLER_48_576 VGND VGND VPWR VPWR sky130_fd_sc_hd__fill_1
XANTENNA__2880__B2 _3096_/A1 VGND VGND VPWR VPWR sky130_fd_sc_hd__diode_2
XFILLER_91_833 VGND VGND VPWR VPWR sky130_fd_sc_hd__fill_4
XANTENNA__4237__S _4237_/S VGND VGND VPWR VPWR sky130_fd_sc_hd__diode_2
XANTENNA_clkload0_A clkload0/A VGND VGND VPWR VPWR sky130_fd_sc_hd__diode_2
XANTENNA__3409__A0 _5044_/A1 VGND VGND VPWR VPWR sky130_fd_sc_hd__diode_2
XFILLER_90_365 VGND VGND VPWR VPWR sky130_fd_sc_hd__fill_2
XTAP_TAPCELL_ROW_106_1897 VGND VPWR sky130_fd_sc_hd__tapvpwrvgnd_1
XTAP_TAPCELL_ROW_106_1886 VGND VPWR sky130_fd_sc_hd__tapvpwrvgnd_1
X_2910_ _2903_/X _2909_/X _2967_/S VGND VGND VPWR VPWR _2910_/X sky130_fd_sc_hd__mux2_1
XFILLER_44_793 VPWR VGND VPWR VGND sky130_ef_sc_hd__decap_40_12
XFILLER_16_473 VGND VGND VPWR VPWR sky130_fd_sc_hd__fill_2
X_3890_ _4503_/A _4483_/B VGND VGND VPWR VPWR _3899_/S sky130_fd_sc_hd__nor2_4
XFILLER_43_281 VGND VGND VPWR VPWR sky130_fd_sc_hd__fill_2
X_2841_ _6234_/Q _6210_/Q _6153_/Q _6222_/Q _3091_/S _3005_/A VGND VGND VPWR VPWR
+ _2841_/X sky130_fd_sc_hd__mux4_1
XFILLER_31_465 VGND VGND VPWR VPWR sky130_fd_sc_hd__fill_1
XFILLER_31_487 VGND VGND VPWR VPWR sky130_fd_sc_hd__fill_1
X_5560_ _6137_/CLK _5560_/D VGND VGND VPWR VPWR _5560_/Q sky130_fd_sc_hd__dfxtp_1
XPHY_EDGE_ROW_91_Left_230 VGND VGND VPWR VPWR sky130_fd_sc_hd__decap_3
X_2772_ _3031_/A1 _2771_/X _2770_/X _3089_/C1 VGND VGND VPWR VPWR _2772_/X sky130_fd_sc_hd__o211a_1
XFILLER_78_3 VPWR VGND VPWR VGND sky130_ef_sc_hd__decap_40_12
XANTENNA__4385__A1 _5046_/A1 VGND VGND VPWR VPWR sky130_fd_sc_hd__diode_2
X_5491_ _6369_/CLK _5491_/D VGND VGND VPWR VPWR _5491_/Q sky130_fd_sc_hd__dfxtp_1
X_4511_ _4511_/A0 _4521_/A1 _4512_/S VGND VGND VPWR VPWR _4511_/X sky130_fd_sc_hd__mux2_1
XFILLER_117_559 VGND VGND VPWR VPWR sky130_fd_sc_hd__fill_1
Xhold116 _4535_/X VGND VGND VPWR VPWR _6137_/D sky130_fd_sc_hd__dlygate4sd3_1
Xhold105 _5471_/Q VGND VGND VPWR VPWR hold105/X sky130_fd_sc_hd__dlygate4sd3_1
X_4442_ _6382_/Q _4994_/B _4445_/B _4846_/A0 VGND VGND VPWR VPWR _4442_/X sky130_fd_sc_hd__a22o_1
XFILLER_7_193 VGND VGND VPWR VPWR sky130_fd_sc_hd__fill_1
Xhold127 _6142_/Q VGND VGND VPWR VPWR hold127/X sky130_fd_sc_hd__dlygate4sd3_1
XFILLER_132_529 VGND VGND VPWR VPWR sky130_fd_sc_hd__fill_2
Xhold138 _4301_/X VGND VGND VPWR VPWR _5951_/D sky130_fd_sc_hd__dlygate4sd3_1
Xhold149 _6024_/Q VGND VGND VPWR VPWR hold149/X sky130_fd_sc_hd__dlygate4sd3_1
XFILLER_113_721 VGND VGND VPWR VPWR sky130_fd_sc_hd__fill_4
XFILLER_98_421 VGND VGND VPWR VPWR sky130_fd_sc_hd__fill_1
X_4373_ _4981_/A1 _4373_/A1 _4376_/S VGND VGND VPWR VPWR _4373_/X sky130_fd_sc_hd__mux2_1
XFILLER_113_765 VPWR VGND VPWR VGND sky130_ef_sc_hd__decap_40_12
X_3324_ _2650_/Y _5064_/A1 _5066_/A0 _2651_/Y _3317_/Y VGND VGND VPWR VPWR _3336_/C
+ sky130_fd_sc_hd__o221ai_1
X_6112_ _6125_/CLK _6112_/D VGND VGND VPWR VPWR _6112_/Q sky130_fd_sc_hd__dfxtp_1
XANTENNA__3360__A2 _5035_/C VGND VGND VPWR VPWR sky130_fd_sc_hd__diode_2
XFILLER_86_649 VGND VGND VPWR VPWR sky130_fd_sc_hd__fill_2
XFILLER_58_307 VGND VGND VPWR VPWR sky130_fd_sc_hd__fill_1
X_6043_ _6351_/CLK _6043_/D VGND VGND VPWR VPWR _6043_/Q sky130_fd_sc_hd__dfxtp_1
X_3255_ _3356_/A1 _5923_/Q _3258_/S VGND VGND VPWR VPWR _3255_/X sky130_fd_sc_hd__mux2_1
XFILLER_67_841 VGND VGND VPWR VPWR sky130_fd_sc_hd__fill_1
X_3186_ hold233/X _4886_/A1 _3193_/S VGND VGND VPWR VPWR _5349_/D sky130_fd_sc_hd__mux2_1
XTAP_TAPCELL_ROW_68_1314 VGND VPWR sky130_fd_sc_hd__tapvpwrvgnd_1
XTAP_TAPCELL_ROW_1_314 VGND VPWR sky130_fd_sc_hd__tapvpwrvgnd_1
XFILLER_94_693 VGND VGND VPWR VPWR sky130_fd_sc_hd__fill_4
XTAP_TAPCELL_ROW_68_1325 VGND VPWR sky130_fd_sc_hd__tapvpwrvgnd_1
XANTENNA_fanout172_A _4221_/S VGND VGND VPWR VPWR sky130_fd_sc_hd__diode_2
XTAP_TAPCELL_ROW_81_1514 VGND VPWR sky130_fd_sc_hd__tapvpwrvgnd_1
XFILLER_41_207 VGND VGND VPWR VPWR sky130_fd_sc_hd__fill_1
XFILLER_22_421 VPWR VGND VPWR VGND sky130_ef_sc_hd__decap_40_12
XFILLER_34_281 VGND VGND VPWR VPWR sky130_fd_sc_hd__fill_1
X_5827_ _6342_/CLK _5827_/D VGND VGND VPWR VPWR _5827_/Q sky130_fd_sc_hd__dfxtp_1
X_5758_ _6129_/CLK _5758_/D VGND VGND VPWR VPWR _5758_/Q sky130_fd_sc_hd__dfxtp_1
XTAP_TAPCELL_ROW_20_600 VGND VPWR sky130_fd_sc_hd__tapvpwrvgnd_1
XFILLER_136_813 VPWR VGND VPWR VGND sky130_ef_sc_hd__decap_40_12
X_4709_ _4706_/X _4707_/X _4708_/X _4792_/A1 VGND VGND VPWR VPWR _4709_/X sky130_fd_sc_hd__a22o_1
X_5689_ _6095_/CLK _5689_/D VGND VGND VPWR VPWR _5689_/Q sky130_fd_sc_hd__dfxtp_1
XANTENNA__4610__S _4778_/S VGND VGND VPWR VPWR sky130_fd_sc_hd__diode_2
XANTENNA__4128__A1 _4264_/A1 VGND VGND VPWR VPWR sky130_fd_sc_hd__diode_2
XTAP_TAPCELL_ROW_79_1487 VGND VPWR sky130_fd_sc_hd__tapvpwrvgnd_1
XFILLER_78_15 VPWR VGND VPWR VGND sky130_ef_sc_hd__decap_40_12
XFILLER_123_529 VPWR VGND VPWR VGND sky130_ef_sc_hd__decap_40_12
XFILLER_116_581 VGND VGND VPWR VPWR sky130_fd_sc_hd__fill_4
Xhold650 _3428_/X VGND VGND VPWR VPWR _5479_/D sky130_fd_sc_hd__dlygate4sd3_1
XTAP_TAPCELL_ROW_9_436 VGND VPWR sky130_fd_sc_hd__tapvpwrvgnd_1
Xhold672 _4983_/X VGND VGND VPWR VPWR _6315_/D sky130_fd_sc_hd__dlygate4sd3_1
XFILLER_2_837 VGND VGND VPWR VPWR sky130_fd_sc_hd__fill_4
Xhold661 _6106_/Q VGND VGND VPWR VPWR hold661/X sky130_fd_sc_hd__dlygate4sd3_1
XTAP_TAPCELL_ROW_92_1687 VGND VPWR sky130_fd_sc_hd__tapvpwrvgnd_1
XTAP_TAPCELL_ROW_92_1676 VGND VPWR sky130_fd_sc_hd__tapvpwrvgnd_1
Xhold683 _6111_/Q VGND VGND VPWR VPWR hold683/X sky130_fd_sc_hd__dlygate4sd3_1
Xhold694 _5772_/Q VGND VGND VPWR VPWR hold694/X sky130_fd_sc_hd__dlygate4sd3_1
XFILLER_131_573 VPWR VGND VPWR VGND sky130_ef_sc_hd__decap_40_12
XFILLER_103_253 VGND VGND VPWR VPWR sky130_fd_sc_hd__fill_1
Xhold2062 _6359_/Q VGND VGND VPWR VPWR _5067_/A1 sky130_fd_sc_hd__dlygate4sd3_1
Xhold2040 _6391_/Q VGND VGND VPWR VPWR _3941_/B sky130_fd_sc_hd__dlygate4sd3_1
XFILLER_58_841 VGND VGND VPWR VPWR sky130_fd_sc_hd__fill_1
XANTENNA__4300__A1 _5043_/A1 VGND VGND VPWR VPWR sky130_fd_sc_hd__diode_2
Xhold2051 _6058_/Q VGND VGND VPWR VPWR _4429_/B2 sky130_fd_sc_hd__dlygate4sd3_1
XFILLER_85_671 VGND VGND VPWR VPWR sky130_fd_sc_hd__fill_1
XFILLER_76_159 VGND VGND VPWR VPWR sky130_fd_sc_hd__fill_8
Xhold2095 _5187_/X VGND VGND VPWR VPWR _5188_/A2 sky130_fd_sc_hd__dlygate4sd3_1
Xhold1361 _6028_/Q VGND VGND VPWR VPWR _4389_/A1 sky130_fd_sc_hd__dlygate4sd3_1
Xhold2084 _5210_/X VGND VGND VPWR VPWR _6412_/D sky130_fd_sc_hd__dlygate4sd3_1
Xhold1350 _5697_/Q VGND VGND VPWR VPWR _3674_/A1 sky130_fd_sc_hd__dlygate4sd3_1
Xhold2073 _5215_/X VGND VGND VPWR VPWR _6417_/D sky130_fd_sc_hd__dlygate4sd3_1
Xhold1372 _5850_/Q VGND VGND VPWR VPWR _3868_/A1 sky130_fd_sc_hd__dlygate4sd3_1
XFILLER_18_749 VGND VGND VPWR VPWR sky130_fd_sc_hd__fill_4
Xhold1383 _5783_/Q VGND VGND VPWR VPWR _3773_/A1 sky130_fd_sc_hd__dlygate4sd3_1
XTAP_TAPCELL_ROW_28_722 VGND VPWR sky130_fd_sc_hd__tapvpwrvgnd_1
Xhold1394 _4103_/X VGND VGND VPWR VPWR _5921_/D sky130_fd_sc_hd__dlygate4sd3_1
XTAP_TAPCELL_ROW_123_2142 VGND VPWR sky130_fd_sc_hd__tapvpwrvgnd_1
XFILLER_84_192 VGND VGND VPWR VPWR sky130_fd_sc_hd__fill_4
XFILLER_33_719 VGND VGND VPWR VPWR sky130_fd_sc_hd__fill_8
XANTENNA__3896__S _3899_/S VGND VGND VPWR VPWR sky130_fd_sc_hd__diode_2
XFILLER_26_793 VPWR VGND VPWR VGND sky130_ef_sc_hd__decap_40_12
XFILLER_25_281 VGND VGND VPWR VPWR sky130_fd_sc_hd__fill_1
XFILLER_43_73 VGND VGND VPWR VPWR sky130_fd_sc_hd__fill_8
XFILLER_40_251 VGND VGND VPWR VPWR sky130_fd_sc_hd__fill_1
XFILLER_41_774 VGND VGND VPWR VPWR sky130_fd_sc_hd__fill_8
XFILLER_41_785 VPWR VGND VPWR VGND sky130_ef_sc_hd__decap_40_12
XFILLER_9_447 VGND VGND VPWR VPWR sky130_fd_sc_hd__fill_1
XFILLER_40_273 VGND VGND VPWR VPWR sky130_fd_sc_hd__fill_1
XFILLER_138_183 VGND VGND VPWR VPWR sky130_fd_sc_hd__fill_4
XFILLER_126_334 VGND VGND VPWR VPWR sky130_fd_sc_hd__fill_1
XFILLER_5_653 VPWR VGND VPWR VGND sky130_ef_sc_hd__decap_40_12
XFILLER_114_529 VGND VGND VPWR VPWR sky130_fd_sc_hd__fill_2
XANTENNA__3878__A0 _4521_/A1 VGND VGND VPWR VPWR sky130_fd_sc_hd__diode_2
XFILLER_5_697 VPWR VGND VPWR VGND sky130_ef_sc_hd__decap_40_12
XFILLER_110_713 VPWR VGND VPWR VGND sky130_ef_sc_hd__decap_40_12
XFILLER_110_757 VPWR VGND VPWR VGND sky130_ef_sc_hd__decap_40_12
XFILLER_49_841 VGND VGND VPWR VPWR sky130_fd_sc_hd__fill_1
XTAP_TAPCELL_ROW_108_1915 VGND VPWR sky130_fd_sc_hd__tapvpwrvgnd_1
X_3040_ _2735_/A _3025_/X _3039_/Y _2925_/S VGND VGND VPWR VPWR _3040_/X sky130_fd_sc_hd__o211a_1
XFILLER_64_811 VGND VGND VPWR VPWR sky130_fd_sc_hd__fill_1
XTAP_TAPCELL_ROW_108_1926 VGND VPWR sky130_fd_sc_hd__tapvpwrvgnd_1
XFILLER_64_833 VGND VGND VPWR VPWR sky130_fd_sc_hd__fill_2
XFILLER_91_641 VPWR VGND VPWR VGND sky130_ef_sc_hd__decap_40_12
XFILLER_91_685 VPWR VGND VPWR VGND sky130_ef_sc_hd__decap_40_12
XFILLER_63_376 VGND VGND VPWR VPWR sky130_fd_sc_hd__fill_8
X_4991_ hold532/X _5045_/A1 _4993_/S VGND VGND VPWR VPWR _4991_/X sky130_fd_sc_hd__mux2_1
X_3942_ _5142_/A _5142_/B VGND VGND VPWR VPWR _3943_/B sky130_fd_sc_hd__or2_1
XANTENNA__3802__B1 _5808_/D VGND VGND VPWR VPWR sky130_fd_sc_hd__diode_2
XTAP_TAPCELL_ROW_63_1244 VGND VPWR sky130_fd_sc_hd__tapvpwrvgnd_1
X_3873_ _4958_/A0 _3873_/A1 _3879_/S VGND VGND VPWR VPWR _5854_/D sky130_fd_sc_hd__mux2_1
X_2824_ _2817_/X _2823_/X _3083_/S VGND VGND VPWR VPWR _2824_/X sky130_fd_sc_hd__mux2_1
X_5612_ _6290_/CLK _5612_/D VGND VGND VPWR VPWR _5612_/Q sky130_fd_sc_hd__dfxtp_1
XANTENNA__4358__A1 _5051_/A1 VGND VGND VPWR VPWR sky130_fd_sc_hd__diode_2
XFILLER_118_813 VPWR VGND VPWR VGND sky130_ef_sc_hd__decap_40_12
X_5543_ _5571_/CLK _5543_/D VGND VGND VPWR VPWR _5543_/Q sky130_fd_sc_hd__dfxtp_1
X_2755_ _6069_/Q _6361_/Q _3016_/S VGND VGND VPWR VPWR _2756_/B sky130_fd_sc_hd__mux2_1
X_2686_ _2645_/A _2685_/A _5222_/A VGND VGND VPWR VPWR _2686_/Y sky130_fd_sc_hd__a21oi_1
XFILLER_105_507 VPWR VGND VPWR VGND sky130_ef_sc_hd__decap_40_12
X_5474_ _6298_/CLK hold86/X VGND VGND VPWR VPWR hold85/A sky130_fd_sc_hd__dfxtp_1
XANTENNA__3869__A0 _4964_/A0 VGND VGND VPWR VPWR sky130_fd_sc_hd__diode_2
X_4425_ _4425_/A1 _4457_/S _4420_/X _4424_/X VGND VGND VPWR VPWR _4425_/X sky130_fd_sc_hd__o22a_1
XANTENNA__5823__Q _5823_/Q VGND VGND VPWR VPWR sky130_fd_sc_hd__diode_2
XFILLER_99_741 VPWR VGND VPWR VGND sky130_ef_sc_hd__decap_40_12
XANTENNA__2767__S1 _2962_/A VGND VGND VPWR VPWR sky130_fd_sc_hd__diode_2
XANTENNA__4530__A1 _5232_/A0 VGND VGND VPWR VPWR sky130_fd_sc_hd__diode_2
X_4356_ hold566/X _5047_/A1 _4356_/S VGND VGND VPWR VPWR _4356_/X sky130_fd_sc_hd__mux2_1
XFILLER_113_573 VPWR VGND VPWR VGND sky130_ef_sc_hd__decap_40_12
X_3307_ hold989/X _5080_/A0 _3308_/S VGND VGND VPWR VPWR _3307_/X sky130_fd_sc_hd__mux2_1
XFILLER_99_785 VPWR VGND VPWR VGND sky130_ef_sc_hd__decap_40_12
XFILLER_100_201 VGND VGND VPWR VPWR sky130_fd_sc_hd__fill_1
XFILLER_86_446 VGND VGND VPWR VPWR sky130_fd_sc_hd__fill_2
X_4287_ hold629/X _5052_/A1 _4294_/S VGND VGND VPWR VPWR _4287_/X sky130_fd_sc_hd__mux2_1
XFILLER_74_608 VGND VGND VPWR VPWR sky130_fd_sc_hd__fill_2
X_3238_ _3617_/C _4503_/A VGND VGND VPWR VPWR _3243_/C sky130_fd_sc_hd__nor2_2
X_6026_ _6349_/CLK hold54/X VGND VGND VPWR VPWR hold53/A sky130_fd_sc_hd__dfxtp_1
XFILLER_104_57 VGND VGND VPWR VPWR sky130_fd_sc_hd__fill_1
XFILLER_82_630 VGND VGND VPWR VPWR sky130_fd_sc_hd__fill_2
XFILLER_55_833 VGND VGND VPWR VPWR sky130_fd_sc_hd__fill_4
X_3169_ _3172_/B _3172_/C VGND VGND VPWR VPWR _3171_/A sky130_fd_sc_hd__and2_1
XPHY_EDGE_ROW_126_Right_126 VGND VGND VPWR VPWR sky130_fd_sc_hd__decap_3
XFILLER_81_140 VGND VGND VPWR VPWR sky130_fd_sc_hd__fill_2
Xclkbuf_leaf_93_clk clkload2/A VGND VGND VPWR VPWR _6388_/CLK sky130_fd_sc_hd__clkbuf_8
XFILLER_70_836 VGND VGND VPWR VPWR sky130_fd_sc_hd__fill_2
XFILLER_54_387 VGND VGND VPWR VPWR sky130_fd_sc_hd__fill_4
XFILLER_42_505 VGND VGND VPWR VPWR sky130_fd_sc_hd__fill_4
XFILLER_81_195 VGND VGND VPWR VPWR sky130_fd_sc_hd__fill_1
XANTENNA__4605__S _4773_/S VGND VGND VPWR VPWR sky130_fd_sc_hd__diode_2
XANTENNA__4597__B2 _4811_/C1 VGND VGND VPWR VPWR sky130_fd_sc_hd__diode_2
XFILLER_23_774 VGND VGND VPWR VPWR sky130_fd_sc_hd__fill_8
XFILLER_23_785 VPWR VGND VPWR VGND sky130_ef_sc_hd__decap_40_12
Xfanout66 _2641_/Y VGND VGND VPWR VPWR _3075_/C1 sky130_fd_sc_hd__buf_4
Xfanout99 hold2235/X VGND VGND VPWR VPWR _5045_/A1 sky130_fd_sc_hd__buf_4
Xfanout88 _5209_/A1 VGND VGND VPWR VPWR _4515_/A1 sky130_fd_sc_hd__clkbuf_4
XANTENNA__4349__A1 _5052_/A1 VGND VGND VPWR VPWR sky130_fd_sc_hd__diode_2
XFILLER_10_413 VGND VGND VPWR VPWR sky130_fd_sc_hd__fill_4
XFILLER_13_21 VGND VGND VPWR VPWR sky130_fd_sc_hd__fill_1
XTAP_TAPCELL_ROW_33_791 VGND VPWR sky130_fd_sc_hd__tapvpwrvgnd_1
Xfanout77 hold2072/X VGND VGND VPWR VPWR _5215_/A1 sky130_fd_sc_hd__buf_4
XFILLER_10_457 VPWR VGND VPWR VGND sky130_ef_sc_hd__decap_40_12
XFILLER_6_417 VGND VGND VPWR VPWR sky130_fd_sc_hd__fill_2
XFILLER_136_643 VGND VGND VPWR VPWR sky130_fd_sc_hd__fill_1
XTAP_TAPCELL_ROW_94_1705 VGND VPWR sky130_fd_sc_hd__tapvpwrvgnd_1
XFILLER_124_805 VGND VGND VPWR VPWR sky130_fd_sc_hd__fill_4
XTAP_TAPCELL_ROW_94_1716 VGND VPWR sky130_fd_sc_hd__tapvpwrvgnd_1
XFILLER_123_315 VGND VGND VPWR VPWR sky130_fd_sc_hd__fill_1
XFILLER_2_601 VPWR VGND VPWR VGND sky130_ef_sc_hd__decap_40_12
Xhold480 _4520_/X VGND VGND VPWR VPWR _6123_/D sky130_fd_sc_hd__dlygate4sd3_1
XFILLER_8_3 VPWR VGND VPWR VGND sky130_ef_sc_hd__decap_40_12
XFILLER_2_645 VPWR VGND VPWR VGND sky130_ef_sc_hd__decap_40_12
XFILLER_1_122 VGND VGND VPWR VPWR sky130_fd_sc_hd__fill_1
XANTENNA__4521__A1 _4521_/A1 VGND VGND VPWR VPWR sky130_fd_sc_hd__diode_2
XFILLER_89_251 VGND VGND VPWR VPWR sky130_fd_sc_hd__fill_1
XFILLER_77_402 VGND VGND VPWR VPWR sky130_fd_sc_hd__fill_1
Xhold491 _5882_/Q VGND VGND VPWR VPWR hold491/X sky130_fd_sc_hd__dlygate4sd3_1
XANTENNA__3088__A1 _3086_/S VGND VGND VPWR VPWR sky130_fd_sc_hd__diode_2
XANTENNA__2835__A1 _3036_/A1 VGND VGND VPWR VPWR sky130_fd_sc_hd__diode_2
XFILLER_18_513 VPWR VGND VPWR VGND sky130_ef_sc_hd__decap_40_12
Xhold1180 _3659_/X VGND VGND VPWR VPWR _5684_/D sky130_fd_sc_hd__dlygate4sd3_1
Xhold1191 _5844_/Q VGND VGND VPWR VPWR _3862_/A1 sky130_fd_sc_hd__dlygate4sd3_1
XFILLER_18_557 VPWR VGND VPWR VGND sky130_ef_sc_hd__decap_40_12
Xclkbuf_leaf_84_clk clkload1/A VGND VGND VPWR VPWR _6122_/CLK sky130_fd_sc_hd__clkbuf_8
XANTENNA__4037__B1 _4252_/B1 VGND VGND VPWR VPWR sky130_fd_sc_hd__diode_2
XTAP_TAPCELL_ROW_103_1845 VGND VPWR sky130_fd_sc_hd__tapvpwrvgnd_1
XANTENNA__5200__A _5200_/A VGND VGND VPWR VPWR sky130_fd_sc_hd__diode_2
XFILLER_33_538 VGND VGND VPWR VPWR sky130_fd_sc_hd__fill_2
XFILLER_33_549 VGND VGND VPWR VPWR sky130_fd_sc_hd__fill_2
XFILLER_41_571 VGND VGND VPWR VPWR sky130_fd_sc_hd__fill_4
XTAP_TAPCELL_ROW_136_2344 VGND VPWR sky130_fd_sc_hd__tapvpwrvgnd_1
XTAP_TAPCELL_ROW_136_2333 VGND VPWR sky130_fd_sc_hd__tapvpwrvgnd_1
XFILLER_9_266 VGND VGND VPWR VPWR sky130_fd_sc_hd__fill_1
Xclkload14 _6302_/CLK VGND VGND VPWR VPWR clkload14/Y sky130_fd_sc_hd__clkinv_4
XTAP_TAPCELL_ROW_11_463 VGND VPWR sky130_fd_sc_hd__tapvpwrvgnd_1
Xclkload25 _5990_/CLK VGND VGND VPWR VPWR clkload25/Y sky130_fd_sc_hd__clkinvlp_4
XFILLER_127_665 VGND VGND VPWR VPWR sky130_fd_sc_hd__fill_4
XANTENNA__2997__S1 _2962_/A VGND VGND VPWR VPWR sky130_fd_sc_hd__diode_2
Xclkload69 _6065_/CLK VGND VGND VPWR VPWR clkload69/Y sky130_fd_sc_hd__inv_8
Xclkload36 _6405_/CLK VGND VGND VPWR VPWR clkload36/Y sky130_fd_sc_hd__clkinv_4
Xclkload58 _5850_/CLK VGND VGND VPWR VPWR clkload58/Y sky130_fd_sc_hd__inv_12
Xclkload47 _6414_/CLK VGND VGND VPWR VPWR clkload47/Y sky130_fd_sc_hd__clkinv_2
XFILLER_5_461 VPWR VGND VPWR VGND sky130_ef_sc_hd__decap_40_12
X_4210_ _4205_/X _4209_/X _4272_/S VGND VGND VPWR VPWR _4210_/Y sky130_fd_sc_hd__o21ai_1
XANTENNA__4512__A1 _5202_/A1 VGND VGND VPWR VPWR sky130_fd_sc_hd__diode_2
X_5190_ _5190_/A0 _5190_/A1 _5194_/S VGND VGND VPWR VPWR _5190_/X sky130_fd_sc_hd__mux2_1
XPHY_EDGE_ROW_10_Left_149 VGND VGND VPWR VPWR sky130_fd_sc_hd__decap_3
XANTENNA__5081__S _5081_/S VGND VGND VPWR VPWR sky130_fd_sc_hd__diode_2
XFILLER_96_755 VGND VGND VPWR VPWR sky130_fd_sc_hd__fill_1
XFILLER_95_221 VGND VGND VPWR VPWR sky130_fd_sc_hd__fill_1
X_4141_ _4241_/A _4141_/B VGND VGND VPWR VPWR _4141_/Y sky130_fd_sc_hd__nor2_1
XFILLER_49_660 VPWR VGND VPWR VGND sky130_ef_sc_hd__decap_40_12
X_4072_ _4264_/A1 _4071_/X _4205_/A VGND VGND VPWR VPWR _4072_/Y sky130_fd_sc_hd__o21ai_1
X_3023_ _5247_/Q _6252_/Q _5412_/Q _5510_/Q _3033_/S _3020_/A VGND VGND VPWR VPWR
+ _3023_/X sky130_fd_sc_hd__mux4_1
XFILLER_110_587 VGND VGND VPWR VPWR sky130_fd_sc_hd__fill_1
XFILLER_95_90 VGND VGND VPWR VPWR sky130_fd_sc_hd__fill_4
XFILLER_37_833 VGND VGND VPWR VPWR sky130_fd_sc_hd__fill_4
XFILLER_64_641 VGND VGND VPWR VPWR sky130_fd_sc_hd__fill_2
Xclkbuf_leaf_75_clk clkload2/A VGND VGND VPWR VPWR _5898_/CLK sky130_fd_sc_hd__clkbuf_8
XANTENNA__2921__S1 _3050_/A VGND VGND VPWR VPWR sky130_fd_sc_hd__diode_2
XFILLER_52_825 VPWR VGND VPWR VGND sky130_ef_sc_hd__decap_40_12
XANTENNA__4028__B1 _4149_/A VGND VGND VPWR VPWR sky130_fd_sc_hd__diode_2
XFILLER_51_335 VGND VGND VPWR VPWR sky130_fd_sc_hd__fill_1
X_4974_ _4984_/A1 _4974_/A1 _4974_/S VGND VGND VPWR VPWR _4974_/X sky130_fd_sc_hd__mux2_1
XTAP_TAPCELL_ROW_19_585 VGND VPWR sky130_fd_sc_hd__tapvpwrvgnd_1
XFILLER_24_538 VGND VGND VPWR VPWR sky130_fd_sc_hd__fill_1
XANTENNA__5818__Q _5818_/Q VGND VGND VPWR VPWR sky130_fd_sc_hd__diode_2
X_3925_ hold335/X _5213_/A1 _3928_/S VGND VGND VPWR VPWR _3925_/X sky130_fd_sc_hd__mux2_1
X_3856_ _3818_/S _3855_/X _3854_/Y _5222_/A VGND VGND VPWR VPWR _5841_/D sky130_fd_sc_hd__a211oi_1
XANTENNA_fanout135_A _5810_/Q VGND VGND VPWR VPWR sky130_fd_sc_hd__diode_2
XFILLER_20_755 VGND VGND VPWR VPWR sky130_fd_sc_hd__fill_1
Xclkload8 clkload8/A VGND VGND VPWR VPWR clkload8/Y sky130_fd_sc_hd__bufinv_16
XFILLER_118_643 VGND VGND VPWR VPWR sky130_fd_sc_hd__fill_1
X_2807_ _6172_/Q _6196_/Q _6184_/Q _5478_/Q _3091_/S _3005_/A VGND VGND VPWR VPWR
+ _2807_/X sky130_fd_sc_hd__mux4_1
XTAP_TAPCELL_ROW_30_750 VGND VPWR sky130_fd_sc_hd__tapvpwrvgnd_1
X_3787_ hold177/X _4964_/A0 _3787_/S VGND VGND VPWR VPWR _3787_/X sky130_fd_sc_hd__mux2_1
X_5526_ _5565_/CLK _5526_/D VGND VGND VPWR VPWR _5526_/Q sky130_fd_sc_hd__dfxtp_1
XFILLER_106_805 VGND VGND VPWR VPWR sky130_fd_sc_hd__fill_4
X_2738_ _2663_/A _2736_/B _5222_/A VGND VGND VPWR VPWR _2738_/Y sky130_fd_sc_hd__a21oi_1
XFILLER_3_409 VPWR VGND VPWR VGND sky130_ef_sc_hd__decap_40_12
XFILLER_133_613 VGND VGND VPWR VPWR sky130_fd_sc_hd__fill_2
XTAP_TAPCELL_ROW_76_1446 VGND VPWR sky130_fd_sc_hd__tapvpwrvgnd_1
XTAP_TAPCELL_ROW_76_1435 VGND VPWR sky130_fd_sc_hd__tapvpwrvgnd_1
X_5457_ _5908_/CLK _5457_/D VGND VGND VPWR VPWR _5457_/Q sky130_fd_sc_hd__dfxtp_1
X_2669_ hold333/X _4899_/A0 _5241_/S VGND VGND VPWR VPWR _2669_/X sky130_fd_sc_hd__mux2_1
X_4408_ _5051_/A1 _4408_/A1 _4416_/S VGND VGND VPWR VPWR _4408_/X sky130_fd_sc_hd__mux2_1
Xfanout201 _2682_/A VGND VGND VPWR VPWR _5200_/A sky130_fd_sc_hd__buf_4
X_5388_ _6408_/CLK _5388_/D VGND VGND VPWR VPWR _5388_/Q sky130_fd_sc_hd__dfxtp_1
X_4339_ hold749/X _5053_/A1 _4345_/S VGND VGND VPWR VPWR _4339_/X sky130_fd_sc_hd__mux2_1
XFILLER_87_777 VGND VGND VPWR VPWR sky130_fd_sc_hd__fill_4
XFILLER_47_619 VGND VGND VPWR VPWR sky130_fd_sc_hd__fill_1
XFILLER_86_276 VGND VGND VPWR VPWR sky130_fd_sc_hd__fill_1
X_6009_ _6345_/CLK _6009_/D VGND VGND VPWR VPWR _6009_/Q sky130_fd_sc_hd__dfxtp_1
XFILLER_28_811 VGND VGND VPWR VPWR sky130_fd_sc_hd__fill_1
XANTENNA__2817__A1 _3076_/A1 VGND VGND VPWR VPWR sky130_fd_sc_hd__diode_2
Xclkbuf_leaf_66_clk clkload5/A VGND VGND VPWR VPWR _6098_/CLK sky130_fd_sc_hd__clkbuf_8
XTAP_TAPCELL_ROW_120_2101 VGND VPWR sky130_fd_sc_hd__tapvpwrvgnd_1
XANTENNA__3490__A1 _4906_/A0 VGND VGND VPWR VPWR sky130_fd_sc_hd__diode_2
XFILLER_15_505 VPWR VGND VPWR VGND sky130_ef_sc_hd__decap_40_12
XTAP_TAPCELL_ROW_38_872 VGND VPWR sky130_fd_sc_hd__tapvpwrvgnd_1
XFILLER_54_195 VGND VGND VPWR VPWR sky130_fd_sc_hd__fill_1
XFILLER_70_699 VGND VGND VPWR VPWR sky130_fd_sc_hd__fill_1
XFILLER_10_210 VGND VGND VPWR VPWR sky130_fd_sc_hd__fill_2
XANTENNA__4990__A1 _5044_/A1 VGND VGND VPWR VPWR sky130_fd_sc_hd__diode_2
XFILLER_50_390 VGND VGND VPWR VPWR sky130_fd_sc_hd__fill_1
XTAP_TAPCELL_ROW_118_2074 VGND VPWR sky130_fd_sc_hd__tapvpwrvgnd_1
XTAP_TAPCELL_ROW_118_2063 VGND VPWR sky130_fd_sc_hd__tapvpwrvgnd_1
XFILLER_11_777 VGND VGND VPWR VPWR sky130_fd_sc_hd__fill_4
XFILLER_124_613 VPWR VGND VPWR VGND sky130_ef_sc_hd__decap_40_12
XFILLER_40_85 VGND VGND VPWR VPWR sky130_fd_sc_hd__fill_2
XTAP_TAPCELL_ROW_131_2263 VGND VPWR sky130_fd_sc_hd__tapvpwrvgnd_1
XFILLER_124_657 VPWR VGND VPWR VGND sky130_ef_sc_hd__decap_40_12
XFILLER_2_475 VGND VGND VPWR VPWR sky130_fd_sc_hd__fill_1
XANTENNA__2819__A _3050_/A VGND VGND VPWR VPWR sky130_fd_sc_hd__diode_2
XFILLER_123_189 VGND VGND VPWR VPWR sky130_fd_sc_hd__fill_1
XFILLER_120_841 VGND VGND VPWR VPWR sky130_fd_sc_hd__fill_1
XFILLER_78_755 VGND VGND VPWR VPWR sky130_fd_sc_hd__fill_1
XFILLER_49_61 VGND VGND VPWR VPWR sky130_fd_sc_hd__fill_2
XFILLER_78_777 VPWR VGND VPWR VGND sky130_ef_sc_hd__decap_40_12
XFILLER_77_243 VGND VGND VPWR VPWR sky130_fd_sc_hd__fill_1
XFILLER_93_725 VGND VGND VPWR VPWR sky130_fd_sc_hd__fill_2
XFILLER_77_287 VGND VGND VPWR VPWR sky130_fd_sc_hd__fill_1
XFILLER_65_438 VGND VGND VPWR VPWR sky130_fd_sc_hd__fill_8
XFILLER_19_833 VGND VGND VPWR VPWR sky130_fd_sc_hd__fill_4
Xclkbuf_leaf_57_clk clkload5/A VGND VGND VPWR VPWR _6236_/CLK sky130_fd_sc_hd__clkbuf_8
XFILLER_1_57 VPWR VGND VPWR VGND sky130_ef_sc_hd__decap_40_12
XANTENNA__3481__A1 _4445_/A VGND VGND VPWR VPWR sky130_fd_sc_hd__diode_2
XFILLER_80_419 VGND VGND VPWR VPWR sky130_fd_sc_hd__fill_1
XTAP_TAPCELL_ROW_47_1003 VGND VPWR sky130_fd_sc_hd__tapvpwrvgnd_1
XFILLER_45_151 VGND VGND VPWR VPWR sky130_fd_sc_hd__fill_1
XFILLER_18_354 VGND VGND VPWR VPWR sky130_fd_sc_hd__fill_8
XFILLER_18_365 VPWR VGND VPWR VGND sky130_ef_sc_hd__decap_40_12
XFILLER_34_825 VPWR VGND VPWR VGND sky130_ef_sc_hd__decap_40_12
XTAP_TAPCELL_ROW_16_533 VGND VPWR sky130_fd_sc_hd__tapvpwrvgnd_1
XFILLER_33_346 VGND VGND VPWR VPWR sky130_fd_sc_hd__fill_4
XANTENNA__3369__B input5/X VGND VGND VPWR VPWR sky130_fd_sc_hd__diode_2
XTAP_TAPCELL_ROW_16_544 VGND VPWR sky130_fd_sc_hd__tapvpwrvgnd_1
XTAP_TAPCELL_ROW_60_1203 VGND VPWR sky130_fd_sc_hd__tapvpwrvgnd_1
XANTENNA__4430__B1 _3801_/B VGND VGND VPWR VPWR sky130_fd_sc_hd__diode_2
X_3710_ hold635/X _5040_/A1 _3717_/S VGND VGND VPWR VPWR _3710_/X sky130_fd_sc_hd__mux2_1
XANTENNA__4981__A1 _4981_/A1 VGND VGND VPWR VPWR sky130_fd_sc_hd__diode_2
X_4690_ _6121_/Q _6112_/Q _4801_/S VGND VGND VPWR VPWR _4690_/X sky130_fd_sc_hd__mux2_1
XANTENNA__5076__S _5081_/S VGND VGND VPWR VPWR sky130_fd_sc_hd__diode_2
XANTENNA__2992__B1 _3027_/A VGND VGND VPWR VPWR sky130_fd_sc_hd__diode_2
Xclkload103 _6241_/CLK VGND VGND VPWR VPWR clkload103/X sky130_fd_sc_hd__clkbuf_4
X_3641_ hold357/X _4958_/A0 _3647_/S VGND VGND VPWR VPWR _3641_/X sky130_fd_sc_hd__mux2_1
XFILLER_127_451 VGND VGND VPWR VPWR sky130_fd_sc_hd__fill_8
X_3572_ _3572_/A0 _3926_/A1 _3574_/S VGND VGND VPWR VPWR _3572_/X sky130_fd_sc_hd__mux2_1
X_6360_ _6386_/CLK _6360_/D VGND VGND VPWR VPWR _6360_/Q sky130_fd_sc_hd__dfxtp_1
X_5311_ _6365_/CLK _5311_/D VGND VGND VPWR VPWR _5311_/Q sky130_fd_sc_hd__dfxtp_1
XFILLER_115_613 VGND VGND VPWR VPWR sky130_fd_sc_hd__fill_2
XFILLER_6_781 VPWR VGND VPWR VGND sky130_ef_sc_hd__decap_40_12
XFILLER_114_123 VGND VGND VPWR VPWR sky130_fd_sc_hd__fill_2
X_6291_ _6294_/CLK _6291_/D VGND VGND VPWR VPWR _6291_/Q sky130_fd_sc_hd__dfxtp_1
XTAP_TAPCELL_ROW_58_1176 VGND VPWR sky130_fd_sc_hd__tapvpwrvgnd_1
XTAP_TAPCELL_ROW_58_1165 VGND VPWR sky130_fd_sc_hd__tapvpwrvgnd_1
X_5242_ _6248_/CLK _5242_/D VGND VGND VPWR VPWR _5242_/Q sky130_fd_sc_hd__dfxtp_1
XFILLER_102_307 VGND VGND VPWR VPWR sky130_fd_sc_hd__fill_1
XFILLER_111_841 VGND VGND VPWR VPWR sky130_fd_sc_hd__fill_1
XANTENNA__2729__A _3085_/A VGND VGND VPWR VPWR sky130_fd_sc_hd__diode_2
X_5173_ _5173_/A _5173_/B VGND VGND VPWR VPWR _5173_/X sky130_fd_sc_hd__and2_1
Xhold1905 _4956_/X VGND VGND VPWR VPWR _6290_/D sky130_fd_sc_hd__dlygate4sd3_1
XTAP_TAPCELL_ROW_71_1365 VGND VPWR sky130_fd_sc_hd__tapvpwrvgnd_1
Xhold1916 _3686_/X VGND VGND VPWR VPWR _5708_/D sky130_fd_sc_hd__dlygate4sd3_1
Xhold1927 _5906_/Q VGND VGND VPWR VPWR _3930_/A1 sky130_fd_sc_hd__dlygate4sd3_1
X_4124_ _4119_/X _4123_/X _4272_/S VGND VGND VPWR VPWR _4124_/Y sky130_fd_sc_hd__o21ai_1
XFILLER_96_585 VGND VGND VPWR VPWR sky130_fd_sc_hd__fill_2
Xhold1938 _4864_/X VGND VGND VPWR VPWR _6215_/D sky130_fd_sc_hd__dlygate4sd3_1
XFILLER_84_736 VGND VGND VPWR VPWR sky130_fd_sc_hd__fill_4
XFILLER_68_298 VGND VGND VPWR VPWR sky130_fd_sc_hd__fill_1
XFILLER_68_276 VGND VGND VPWR VPWR sky130_fd_sc_hd__fill_4
Xhold1949 _5095_/X VGND VGND VPWR VPWR _6383_/D sky130_fd_sc_hd__dlygate4sd3_1
Xinput1 i2c_scl_i VGND VGND VPWR VPWR input1/X sky130_fd_sc_hd__buf_1
Xclkbuf_leaf_48_clk clkload6/A VGND VGND VPWR VPWR _6242_/CLK sky130_fd_sc_hd__clkbuf_8
X_4055_ _4241_/A _4055_/B VGND VGND VPWR VPWR _4055_/Y sky130_fd_sc_hd__nor2_1
X_3006_ _6158_/Q _6227_/Q _3062_/S VGND VGND VPWR VPWR _3006_/X sky130_fd_sc_hd__mux2_1
XFILLER_91_290 VPWR VGND VPWR VGND sky130_ef_sc_hd__decap_40_12
XFILLER_64_493 VGND VGND VPWR VPWR sky130_fd_sc_hd__fill_1
XTAP_TAPCELL_ROW_35_820 VGND VPWR sky130_fd_sc_hd__tapvpwrvgnd_1
XTAP_TAPCELL_ROW_35_831 VGND VPWR sky130_fd_sc_hd__tapvpwrvgnd_1
X_4957_ _5209_/A1 _4957_/A1 _4964_/S VGND VGND VPWR VPWR _4957_/X sky130_fd_sc_hd__mux2_1
XANTENNA__3224__B2 _4803_/S VGND VGND VPWR VPWR sky130_fd_sc_hd__diode_2
XANTENNA__3224__A1 _3278_/A VGND VGND VPWR VPWR sky130_fd_sc_hd__diode_2
XFILLER_138_727 VGND VGND VPWR VPWR sky130_fd_sc_hd__fill_1
X_4888_ hold363/X _4901_/A0 _4893_/S VGND VGND VPWR VPWR _4888_/X sky130_fd_sc_hd__mux2_1
XANTENNA_fanout138_X _4663_/A VGND VGND VPWR VPWR sky130_fd_sc_hd__diode_2
X_3908_ _3908_/A0 _5202_/A1 _3908_/S VGND VGND VPWR VPWR _3908_/X sky130_fd_sc_hd__mux2_1
XFILLER_138_749 VGND VGND VPWR VPWR sky130_fd_sc_hd__fill_2
X_3839_ _5085_/A _3839_/B VGND VGND VPWR VPWR _5833_/D sky130_fd_sc_hd__or2_1
XFILLER_20_585 VGND VGND VPWR VPWR sky130_fd_sc_hd__fill_2
XFILLER_106_613 VPWR VGND VPWR VGND sky130_ef_sc_hd__decap_40_12
X_5509_ _6254_/CLK _5509_/D VGND VGND VPWR VPWR _5509_/Q sky130_fd_sc_hd__dfxtp_1
XFILLER_106_657 VPWR VGND VPWR VGND sky130_ef_sc_hd__decap_40_12
XANTENNA__4488__A0 _4488_/A0 VGND VGND VPWR VPWR sky130_fd_sc_hd__diode_2
XFILLER_120_137 VGND VGND VPWR VPWR sky130_fd_sc_hd__fill_2
XFILLER_102_841 VGND VGND VPWR VPWR sky130_fd_sc_hd__fill_1
XTAP_TAPCELL_ROW_89_1637 VGND VPWR sky130_fd_sc_hd__tapvpwrvgnd_1
XFILLER_87_596 VGND VGND VPWR VPWR sky130_fd_sc_hd__fill_1
Xclkbuf_leaf_39_clk clkload4/A VGND VGND VPWR VPWR _6429_/CLK sky130_fd_sc_hd__clkbuf_8
XFILLER_47_449 VGND VGND VPWR VPWR sky130_fd_sc_hd__fill_1
XANTENNA__3463__A1 _5816_/Q VGND VGND VPWR VPWR sky130_fd_sc_hd__diode_2
XFILLER_90_717 VPWR VGND VPWR VGND sky130_ef_sc_hd__decap_40_12
XFILLER_62_419 VGND VGND VPWR VPWR sky130_fd_sc_hd__fill_1
XFILLER_16_825 VPWR VGND VPWR VGND sky130_ef_sc_hd__decap_40_12
XFILLER_27_162 VGND VGND VPWR VPWR sky130_fd_sc_hd__fill_4
XANTENNA__4074__A1_N _4271_/S1 VGND VGND VPWR VPWR sky130_fd_sc_hd__diode_2
XFILLER_15_368 VPWR VGND VPWR VGND sky130_ef_sc_hd__decap_40_12
XFILLER_35_74 VGND VGND VPWR VPWR sky130_fd_sc_hd__fill_1
XTAP_TAPCELL_ROW_100_1804 VGND VPWR sky130_fd_sc_hd__tapvpwrvgnd_1
XFILLER_31_839 VGND VGND VPWR VPWR sky130_fd_sc_hd__fill_1
XFILLER_129_727 VGND VGND VPWR VPWR sky130_fd_sc_hd__fill_1
XFILLER_11_541 VPWR VGND VPWR VGND sky130_ef_sc_hd__decap_40_12
XFILLER_30_349 VGND VGND VPWR VPWR sky130_fd_sc_hd__fill_4
XFILLER_128_215 VGND VGND VPWR VPWR sky130_fd_sc_hd__fill_1
XFILLER_7_501 VGND VGND VPWR VPWR sky130_fd_sc_hd__fill_2
XFILLER_11_585 VPWR VGND VPWR VGND sky130_ef_sc_hd__decap_40_12
XFILLER_109_451 VGND VGND VPWR VPWR sky130_fd_sc_hd__fill_1
XTAP_TAPCELL_ROW_111_1966 VGND VPWR sky130_fd_sc_hd__tapvpwrvgnd_1
XFILLER_120_693 VGND VGND VPWR VPWR sky130_fd_sc_hd__fill_4
XFILLER_93_500 VGND VGND VPWR VPWR sky130_fd_sc_hd__fill_4
XFILLER_78_585 VGND VGND VPWR VPWR sky130_fd_sc_hd__fill_1
XFILLER_76_70 VGND VGND VPWR VPWR sky130_fd_sc_hd__fill_4
XTAP_TAPCELL_ROW_53_1095 VGND VPWR sky130_fd_sc_hd__tapvpwrvgnd_1
XFILLER_81_706 VGND VGND VPWR VPWR sky130_fd_sc_hd__fill_2
XFILLER_19_641 VPWR VGND VPWR VGND sky130_ef_sc_hd__decap_40_12
XANTENNA__3454__A1 _4445_/A VGND VGND VPWR VPWR sky130_fd_sc_hd__diode_2
XFILLER_65_279 VGND VGND VPWR VPWR sky130_fd_sc_hd__fill_1
XFILLER_19_685 VPWR VGND VPWR VGND sky130_ef_sc_hd__decap_40_12
X_5860_ _6098_/CLK _5860_/D VGND VGND VPWR VPWR _5860_/Q sky130_fd_sc_hd__dfxtp_1
X_4811_ _4811_/A1 _4810_/X _4809_/X _4811_/C1 VGND VGND VPWR VPWR _4811_/X sky130_fd_sc_hd__o211a_1
XANTENNA__3206__A1 _5237_/A0 VGND VGND VPWR VPWR sky130_fd_sc_hd__diode_2
X_5791_ _6121_/CLK _5791_/D VGND VGND VPWR VPWR _5791_/Q sky130_fd_sc_hd__dfxtp_1
XANTENNA__4403__A0 _4981_/A1 VGND VGND VPWR VPWR sky130_fd_sc_hd__diode_2
X_4742_ _4799_/A _4742_/B VGND VGND VPWR VPWR _4742_/Y sky130_fd_sc_hd__nor2_1
X_4673_ _5714_/Q _5705_/Q _5696_/Q _5900_/Q _4810_/S _4809_/A VGND VGND VPWR VPWR
+ _4673_/X sky130_fd_sc_hd__mux4_1
X_3624_ hold244/X _5213_/A1 _3627_/S VGND VGND VPWR VPWR _3624_/X sky130_fd_sc_hd__mux2_1
X_6412_ _6414_/CLK _6412_/D VGND VGND VPWR VPWR _6412_/Q sky130_fd_sc_hd__dfxtp_1
XFILLER_128_793 VPWR VGND VPWR VGND sky130_ef_sc_hd__decap_40_12
XANTENNA__2812__S0 _2984_/S VGND VGND VPWR VPWR sky130_fd_sc_hd__diode_2
X_3555_ _4484_/A0 _4565_/A0 _3562_/S VGND VGND VPWR VPWR _5594_/D sky130_fd_sc_hd__mux2_1
X_6343_ _6408_/CLK _6343_/D VGND VGND VPWR VPWR _6343_/Q sky130_fd_sc_hd__dfxtp_1
X_3486_ _3486_/A0 _4889_/A1 _3490_/S VGND VGND VPWR VPWR _3486_/X sky130_fd_sc_hd__mux2_1
XFILLER_89_839 VGND VGND VPWR VPWR sky130_fd_sc_hd__fill_1
X_6274_ _6310_/CLK _6274_/D VGND VGND VPWR VPWR _6274_/Q sky130_fd_sc_hd__dfxtp_1
X_5225_ _5225_/A _5225_/B VGND VGND VPWR VPWR _5237_/S sky130_fd_sc_hd__or2_4
XFILLER_102_115 VGND VGND VPWR VPWR sky130_fd_sc_hd__fill_1
XPHY_EDGE_ROW_102_Left_241 VGND VGND VPWR VPWR sky130_fd_sc_hd__decap_3
Xhold1702 _4848_/X VGND VGND VPWR VPWR _6200_/D sky130_fd_sc_hd__dlygate4sd3_1
XFILLER_69_563 VGND VGND VPWR VPWR sky130_fd_sc_hd__fill_1
XFILLER_69_541 VGND VGND VPWR VPWR sky130_fd_sc_hd__fill_8
XFILLER_130_479 VPWR VGND VPWR VGND sky130_ef_sc_hd__decap_40_12
XFILLER_111_671 VGND VGND VPWR VPWR sky130_fd_sc_hd__fill_1
X_5156_ _5152_/A _5160_/A _5155_/Y _2682_/A VGND VGND VPWR VPWR _5156_/X sky130_fd_sc_hd__o211a_1
XFILLER_56_213 VGND VGND VPWR VPWR sky130_fd_sc_hd__fill_4
XFILLER_56_29 VGND VGND VPWR VPWR sky130_fd_sc_hd__fill_1
XANTENNA__3693__A1 _4517_/A1 VGND VGND VPWR VPWR sky130_fd_sc_hd__diode_2
Xhold1724 _3768_/X VGND VGND VPWR VPWR _5778_/D sky130_fd_sc_hd__dlygate4sd3_1
Xhold1713 _4970_/X VGND VGND VPWR VPWR _6303_/D sky130_fd_sc_hd__dlygate4sd3_1
Xhold1735 _6041_/Q VGND VGND VPWR VPWR _4403_/A1 sky130_fd_sc_hd__dlygate4sd3_1
Xhold1746 _6193_/Q VGND VGND VPWR VPWR _4840_/A1 sky130_fd_sc_hd__dlygate4sd3_1
Xhold1768 _6296_/Q VGND VGND VPWR VPWR _4962_/A1 sky130_fd_sc_hd__dlygate4sd3_1
Xhold1757 _4825_/X VGND VGND VPWR VPWR _6179_/D sky130_fd_sc_hd__dlygate4sd3_1
X_5087_ _5087_/A0 _5087_/A1 _5094_/S VGND VGND VPWR VPWR _5087_/X sky130_fd_sc_hd__mux2_1
XFILLER_56_235 VGND VGND VPWR VPWR sky130_fd_sc_hd__fill_1
X_4107_ _4107_/A0 _4107_/A1 _4237_/S VGND VGND VPWR VPWR _4107_/X sky130_fd_sc_hd__mux2_1
XFILLER_29_438 VGND VGND VPWR VPWR sky130_fd_sc_hd__fill_8
XFILLER_29_449 VGND VGND VPWR VPWR sky130_fd_sc_hd__fill_4
XANTENNA__3445__A1 _5232_/A0 VGND VGND VPWR VPWR sky130_fd_sc_hd__diode_2
XFILLER_56_257 VGND VGND VPWR VPWR sky130_fd_sc_hd__fill_2
X_4038_ _4149_/A _4033_/X _4035_/Y _4037_/Y VGND VGND VPWR VPWR _4038_/X sky130_fd_sc_hd__o2bb2a_1
Xhold1779 _4947_/X VGND VGND VPWR VPWR _6282_/D sky130_fd_sc_hd__dlygate4sd3_1
XANTENNA__4642__B1 _4663_/A VGND VGND VPWR VPWR sky130_fd_sc_hd__diode_2
XFILLER_37_471 VGND VGND VPWR VPWR sky130_fd_sc_hd__fill_1
XTAP_TAPCELL_ROW_84_1567 VGND VPWR sky130_fd_sc_hd__tapvpwrvgnd_1
XTAP_TAPCELL_ROW_84_1556 VGND VPWR sky130_fd_sc_hd__tapvpwrvgnd_1
XPHY_EDGE_ROW_111_Left_250 VGND VGND VPWR VPWR sky130_fd_sc_hd__decap_3
XFILLER_13_839 VGND VGND VPWR VPWR sky130_fd_sc_hd__fill_1
X_5989_ _5990_/CLK _5989_/D VGND VGND VPWR VPWR _5989_/Q sky130_fd_sc_hd__dfxtp_1
XFILLER_40_647 VGND VGND VPWR VPWR sky130_fd_sc_hd__fill_1
XFILLER_138_557 VGND VGND VPWR VPWR sky130_fd_sc_hd__fill_2
XTAP_TAPCELL_ROW_115_2022 VGND VPWR sky130_fd_sc_hd__tapvpwrvgnd_1
XANTENNA__2708__A0 _5823_/Q VGND VGND VPWR VPWR sky130_fd_sc_hd__diode_2
XFILLER_108_3 VPWR VGND VPWR VGND sky130_ef_sc_hd__decap_40_12
XFILLER_97_47 VGND VGND VPWR VPWR sky130_fd_sc_hd__fill_1
XFILLER_95_809 VPWR VGND VPWR VGND sky130_ef_sc_hd__decap_40_12
XANTENNA__3899__S _3899_/S VGND VGND VPWR VPWR sky130_fd_sc_hd__diode_2
XANTENNA_fanout70_X _4271_/S1 VGND VGND VPWR VPWR sky130_fd_sc_hd__diode_2
XFILLER_102_693 VGND VGND VPWR VPWR sky130_fd_sc_hd__fill_4
XANTENNA_input28_A s_axil_wstrb[0] VGND VGND VPWR VPWR sky130_fd_sc_hd__diode_2
XANTENNA__4584__A _4809_/A VGND VGND VPWR VPWR sky130_fd_sc_hd__diode_2
XTAP_TAPCELL_ROW_126_2184 VGND VPWR sky130_fd_sc_hd__tapvpwrvgnd_1
XFILLER_47_279 VGND VGND VPWR VPWR sky130_fd_sc_hd__fill_1
XTAP_TAPCELL_ROW_126_2195 VGND VPWR sky130_fd_sc_hd__tapvpwrvgnd_1
XANTENNA__3436__A1 _4905_/A0 VGND VGND VPWR VPWR sky130_fd_sc_hd__diode_2
XFILLER_90_525 VGND VGND VPWR VPWR sky130_fd_sc_hd__fill_4
XFILLER_71_783 VGND VGND VPWR VPWR sky130_fd_sc_hd__fill_1
XFILLER_16_699 VGND VGND VPWR VPWR sky130_fd_sc_hd__fill_1
XTAP_TAPCELL_ROW_26_683 VGND VPWR sky130_fd_sc_hd__tapvpwrvgnd_1
XFILLER_129_502 VGND VGND VPWR VPWR sky130_fd_sc_hd__fill_2
XTAP_TAPCELL_ROW_26_694 VGND VPWR sky130_fd_sc_hd__tapvpwrvgnd_1
XFILLER_129_557 VGND VGND VPWR VPWR sky130_fd_sc_hd__fill_2
XFILLER_11_393 VPWR VGND VPWR VGND sky130_ef_sc_hd__decap_40_12
XFILLER_125_741 VPWR VGND VPWR VGND sky130_ef_sc_hd__decap_40_12
Xhold309 _5412_/Q VGND VGND VPWR VPWR hold309/X sky130_fd_sc_hd__dlygate4sd3_1
XFILLER_125_785 VPWR VGND VPWR VGND sky130_ef_sc_hd__decap_40_12
XTAP_TAPCELL_ROW_55_1124 VGND VPWR sky130_fd_sc_hd__tapvpwrvgnd_1
X_3340_ _5918_/Q _5123_/A _3988_/B VGND VGND VPWR VPWR _5201_/A sky130_fd_sc_hd__nor3_4
XFILLER_98_625 VPWR VGND VPWR VGND sky130_ef_sc_hd__decap_40_12
XFILLER_98_669 VPWR VGND VPWR VGND sky130_ef_sc_hd__decap_40_12
XFILLER_86_809 VGND VGND VPWR VPWR sky130_fd_sc_hd__fill_2
X_5010_ _5010_/A _5010_/B _5013_/C VGND VGND VPWR VPWR _5011_/C sky130_fd_sc_hd__or3_1
X_3271_ _4600_/A _3272_/C _3270_/Y VGND VGND VPWR VPWR _5398_/D sky130_fd_sc_hd__o21a_1
XFILLER_23_3 VPWR VGND VPWR VGND sky130_ef_sc_hd__decap_40_12
XFILLER_39_714 VGND VGND VPWR VPWR sky130_fd_sc_hd__fill_4
Xhold1009 _3652_/X VGND VGND VPWR VPWR _5678_/D sky130_fd_sc_hd__dlygate4sd3_1
XFILLER_81_503 VGND VGND VPWR VPWR sky130_fd_sc_hd__fill_1
XFILLER_26_419 VGND VGND VPWR VPWR sky130_fd_sc_hd__fill_1
XANTENNA__3427__A1 _4883_/A1 VGND VGND VPWR VPWR sky130_fd_sc_hd__diode_2
XFILLER_62_750 VGND VGND VPWR VPWR sky130_fd_sc_hd__fill_1
X_5912_ clkload8/A _5912_/D VGND VGND VPWR VPWR _5912_/Q sky130_fd_sc_hd__dfxtp_1
XFILLER_34_452 VGND VGND VPWR VPWR sky130_fd_sc_hd__fill_1
X_5843_ _6057_/CLK _5843_/D VGND VGND VPWR VPWR _5843_/Q sky130_fd_sc_hd__dfxtp_1
XTAP_TAPCELL_ROW_66_1297 VGND VPWR sky130_fd_sc_hd__tapvpwrvgnd_1
XTAP_TAPCELL_ROW_66_1286 VGND VPWR sky130_fd_sc_hd__tapvpwrvgnd_1
XTAP_TAPCELL_ROW_45_981 VGND VPWR sky130_fd_sc_hd__tapvpwrvgnd_1
XTAP_TAPCELL_ROW_45_970 VGND VPWR sky130_fd_sc_hd__tapvpwrvgnd_1
XFILLER_21_102 VGND VGND VPWR VPWR sky130_fd_sc_hd__fill_2
XFILLER_10_809 VGND VGND VPWR VPWR sky130_fd_sc_hd__fill_2
XANTENNA__4927__A1 _5052_/A1 VGND VGND VPWR VPWR sky130_fd_sc_hd__diode_2
X_2986_ _5234_/A1 hold329/X _3072_/S VGND VGND VPWR VPWR _2986_/X sky130_fd_sc_hd__mux2_1
X_5774_ _6314_/CLK _5774_/D VGND VGND VPWR VPWR _5774_/Q sky130_fd_sc_hd__dfxtp_1
XANTENNA__5826__Q _5826_/Q VGND VGND VPWR VPWR sky130_fd_sc_hd__diode_2
X_4725_ hold67/A _5662_/Q _4808_/S VGND VGND VPWR VPWR _4725_/X sky130_fd_sc_hd__mux2_1
XFILLER_135_505 VPWR VGND VPWR VGND sky130_ef_sc_hd__decap_40_12
X_4656_ _5846_/Q _5624_/Q _4795_/S VGND VGND VPWR VPWR _4656_/X sky130_fd_sc_hd__mux2_1
Xhold821 _5417_/Q VGND VGND VPWR VPWR hold821/X sky130_fd_sc_hd__dlygate4sd3_1
X_3607_ _3607_/A _4955_/B VGND VGND VPWR VPWR _3616_/S sky130_fd_sc_hd__nor2_4
Xhold810 _3644_/X VGND VGND VPWR VPWR _5671_/D sky130_fd_sc_hd__dlygate4sd3_1
X_4587_ hold57/A _5702_/Q _5693_/Q _5897_/Q _4808_/S _4809_/A VGND VGND VPWR VPWR
+ _4587_/X sky130_fd_sc_hd__mux4_1
Xhold832 _5236_/X VGND VGND VPWR VPWR _6433_/D sky130_fd_sc_hd__dlygate4sd3_1
XFILLER_89_614 VGND VGND VPWR VPWR sky130_fd_sc_hd__fill_2
X_3538_ hold851/X _5234_/A0 _3541_/S VGND VGND VPWR VPWR _3538_/X sky130_fd_sc_hd__mux2_1
X_6326_ _6382_/CLK _6326_/D VGND VGND VPWR VPWR _6326_/Q sky130_fd_sc_hd__dfxtp_1
Xhold843 _5447_/Q VGND VGND VPWR VPWR hold843/X sky130_fd_sc_hd__dlygate4sd3_1
Xhold854 _3697_/X VGND VGND VPWR VPWR _5718_/D sky130_fd_sc_hd__dlygate4sd3_1
Xhold898 _5347_/Q VGND VGND VPWR VPWR hold898/X sky130_fd_sc_hd__dlygate4sd3_1
XANTENNA_clkbuf_leaf_51_clk_A clkload6/A VGND VGND VPWR VPWR sky130_fd_sc_hd__diode_2
XFILLER_89_625 VGND VGND VPWR VPWR sky130_fd_sc_hd__fill_2
Xhold887 _3625_/X VGND VGND VPWR VPWR _5654_/D sky130_fd_sc_hd__dlygate4sd3_1
Xhold865 _5963_/Q VGND VGND VPWR VPWR hold865/X sky130_fd_sc_hd__dlygate4sd3_1
Xhold876 _3727_/X VGND VGND VPWR VPWR _5745_/D sky130_fd_sc_hd__dlygate4sd3_1
XFILLER_1_529 VPWR VGND VPWR VGND sky130_ef_sc_hd__decap_40_12
XFILLER_131_777 VGND VGND VPWR VPWR sky130_fd_sc_hd__fill_4
X_3469_ _5241_/A1 _3469_/A1 _3477_/S VGND VGND VPWR VPWR _5516_/D sky130_fd_sc_hd__mux2_1
XFILLER_77_809 VPWR VGND VPWR VGND sky130_ef_sc_hd__decap_40_12
X_6257_ _6261_/CLK _6257_/D VGND VGND VPWR VPWR _6257_/Q sky130_fd_sc_hd__dfxtp_1
Xhold2211 _5103_/X VGND VGND VPWR VPWR _6385_/D sky130_fd_sc_hd__dlygate4sd3_1
XANTENNA__3860__X _3869_/S VGND VGND VPWR VPWR sky130_fd_sc_hd__diode_2
Xhold2200 _5398_/Q VGND VGND VPWR VPWR hold2200/X sky130_fd_sc_hd__dlygate4sd3_1
Xhold2255 _5254_/Q VGND VGND VPWR VPWR _3113_/A sky130_fd_sc_hd__dlygate4sd3_1
XANTENNA__4863__A0 _4889_/A1 VGND VGND VPWR VPWR sky130_fd_sc_hd__diode_2
X_6188_ _6237_/CLK _6188_/D VGND VGND VPWR VPWR _6188_/Q sky130_fd_sc_hd__dfxtp_1
Xhold1510 _5423_/Q VGND VGND VPWR VPWR _3305_/A0 sky130_fd_sc_hd__dlygate4sd3_1
Xhold2233 _5811_/Q VGND VGND VPWR VPWR hold2233/X sky130_fd_sc_hd__dlygate4sd3_1
Xhold2244 _3563_/S VGND VGND VPWR VPWR _3562_/S sky130_fd_sc_hd__dlygate4sd3_1
Xhold2222 _5828_/Q VGND VGND VPWR VPWR hold2222/X sky130_fd_sc_hd__dlygate4sd3_1
X_5208_ _5208_/A0 _5208_/A1 _5213_/S VGND VGND VPWR VPWR _6410_/D sky130_fd_sc_hd__mux2_1
Xhold1543 _6425_/Q VGND VGND VPWR VPWR _5228_/A1 sky130_fd_sc_hd__dlygate4sd3_1
Xhold1532 _3502_/X VGND VGND VPWR VPWR _5547_/D sky130_fd_sc_hd__dlygate4sd3_1
Xhold1521 _6368_/Q VGND VGND VPWR VPWR _5077_/A1 sky130_fd_sc_hd__dlygate4sd3_1
X_5139_ _3958_/A _5138_/X _5137_/Y _5142_/B VGND VGND VPWR VPWR _5140_/B sky130_fd_sc_hd__a2bb2o_1
XTAP_TAPCELL_ROW_4_367 VGND VPWR sky130_fd_sc_hd__tapvpwrvgnd_1
XTAP_TAPCELL_ROW_4_356 VGND VPWR sky130_fd_sc_hd__tapvpwrvgnd_1
Xhold1554 _5074_/X VGND VGND VPWR VPWR _6365_/D sky130_fd_sc_hd__dlygate4sd3_1
Xhold1576 _6178_/Q VGND VGND VPWR VPWR _4824_/A1 sky130_fd_sc_hd__dlygate4sd3_1
XANTENNA_clkbuf_leaf_66_clk_A clkload5/A VGND VGND VPWR VPWR sky130_fd_sc_hd__diode_2
XANTENNA__3512__S _3516_/S VGND VGND VPWR VPWR sky130_fd_sc_hd__diode_2
XFILLER_29_257 VGND VGND VPWR VPWR sky130_fd_sc_hd__fill_1
Xhold1565 _4392_/X VGND VGND VPWR VPWR _6031_/D sky130_fd_sc_hd__dlygate4sd3_1
Xhold1598 _5600_/Q VGND VGND VPWR VPWR _4733_/A0 sky130_fd_sc_hd__dlygate4sd3_1
XANTENNA__3418__A1 _5211_/A1 VGND VGND VPWR VPWR sky130_fd_sc_hd__diode_2
XFILLER_84_396 VGND VGND VPWR VPWR sky130_fd_sc_hd__fill_1
Xhold1587 _6184_/Q VGND VGND VPWR VPWR _4831_/A1 sky130_fd_sc_hd__dlygate4sd3_1
XFILLER_45_739 VGND VGND VPWR VPWR sky130_fd_sc_hd__fill_4
XFILLER_25_441 VGND VGND VPWR VPWR sky130_fd_sc_hd__fill_4
XFILLER_12_113 VGND VGND VPWR VPWR sky130_fd_sc_hd__fill_1
XFILLER_9_629 VPWR VGND VPWR VGND sky130_ef_sc_hd__decap_40_12
XFILLER_13_669 VGND VGND VPWR VPWR sky130_fd_sc_hd__fill_2
XTAP_TAPCELL_ROW_23_642 VGND VPWR sky130_fd_sc_hd__tapvpwrvgnd_1
XFILLER_32_42 VGND VGND VPWR VPWR sky130_fd_sc_hd__fill_1
XTAP_TAPCELL_ROW_97_1758 VGND VPWR sky130_fd_sc_hd__tapvpwrvgnd_1
XFILLER_107_741 VPWR VGND VPWR VGND sky130_ef_sc_hd__decap_40_12
XANTENNA__2798__S _3030_/S VGND VGND VPWR VPWR sky130_fd_sc_hd__diode_2
XANTENNA__4579__A _4802_/A VGND VGND VPWR VPWR sky130_fd_sc_hd__diode_2
XANTENNA__3354__B1 _5201_/B VGND VGND VPWR VPWR sky130_fd_sc_hd__diode_2
XFILLER_107_785 VPWR VGND VPWR VGND sky130_ef_sc_hd__decap_40_12
XFILLER_79_124 VGND VGND VPWR VPWR sky130_fd_sc_hd__fill_4
XANTENNA_clkbuf_leaf_19_clk_A clkload3/A VGND VGND VPWR VPWR sky130_fd_sc_hd__diode_2
XFILLER_4_389 VPWR VGND VPWR VGND sky130_ef_sc_hd__decap_40_12
XFILLER_122_755 VGND VGND VPWR VPWR sky130_fd_sc_hd__fill_1
XTAP_TAPCELL_ROW_128_2224 VGND VPWR sky130_fd_sc_hd__tapvpwrvgnd_1
XTAP_TAPCELL_ROW_128_2213 VGND VPWR sky130_fd_sc_hd__tapvpwrvgnd_1
XFILLER_95_617 VPWR VGND VPWR VGND sky130_ef_sc_hd__decap_40_12
XANTENNA__4854__A0 _4906_/A0 VGND VGND VPWR VPWR sky130_fd_sc_hd__diode_2
XFILLER_88_680 VGND VGND VPWR VPWR sky130_fd_sc_hd__fill_2
XFILLER_0_573 VPWR VGND VPWR VGND sky130_ef_sc_hd__decap_40_12
XANTENNA__3657__A1 _5202_/A1 VGND VGND VPWR VPWR sky130_fd_sc_hd__diode_2
XFILLER_102_490 VGND VGND VPWR VPWR sky130_fd_sc_hd__fill_1
XTAP_TAPCELL_ROW_50_1054 VGND VPWR sky130_fd_sc_hd__tapvpwrvgnd_1
XTAP_TAPCELL_ROW_50_1043 VGND VPWR sky130_fd_sc_hd__tapvpwrvgnd_1
XFILLER_48_533 VGND VGND VPWR VPWR sky130_fd_sc_hd__fill_2
XFILLER_63_503 VGND VGND VPWR VPWR sky130_fd_sc_hd__fill_1
XTAP_TAPCELL_ROW_106_1887 VGND VPWR sky130_fd_sc_hd__tapvpwrvgnd_1
XFILLER_73_82 VGND VGND VPWR VPWR sky130_fd_sc_hd__fill_1
X_2840_ hold8/X _3011_/A _2839_/X VGND VGND VPWR VPWR hold9/A sky130_fd_sc_hd__a21o_1
X_2771_ _5748_/Q _5272_/Q _3030_/S VGND VGND VPWR VPWR _2771_/X sky130_fd_sc_hd__mux2_1
XFILLER_117_505 VPWR VGND VPWR VGND sky130_ef_sc_hd__decap_40_12
X_5490_ _5583_/CLK _5490_/D VGND VGND VPWR VPWR _5490_/Q sky130_fd_sc_hd__dfxtp_1
X_4510_ hold287/X _5214_/A1 _4512_/S VGND VGND VPWR VPWR _4510_/X sky130_fd_sc_hd__mux2_1
X_4441_ _4441_/A1 _4457_/S _4438_/X _4440_/X VGND VGND VPWR VPWR _4441_/X sky130_fd_sc_hd__o22a_1
Xhold106 _3418_/X VGND VGND VPWR VPWR _5471_/D sky130_fd_sc_hd__dlygate4sd3_1
Xhold117 _6350_/Q VGND VGND VPWR VPWR hold117/X sky130_fd_sc_hd__dlygate4sd3_1
Xhold128 _4540_/X VGND VGND VPWR VPWR _6142_/D sky130_fd_sc_hd__dlygate4sd3_1
XPHY_EDGE_ROW_9_Right_9 VGND VGND VPWR VPWR sky130_fd_sc_hd__decap_3
Xhold139 _6119_/Q VGND VGND VPWR VPWR hold139/X sky130_fd_sc_hd__dlygate4sd3_1
XANTENNA__3896__A1 _4961_/A0 VGND VGND VPWR VPWR sky130_fd_sc_hd__diode_2
X_4372_ _4980_/A1 _4372_/A1 _4376_/S VGND VGND VPWR VPWR _4372_/X sky130_fd_sc_hd__mux2_1
X_6111_ _6120_/CLK _6111_/D VGND VGND VPWR VPWR _6111_/Q sky130_fd_sc_hd__dfxtp_1
XFILLER_112_221 VGND VGND VPWR VPWR sky130_fd_sc_hd__fill_1
X_3323_ _2650_/Y _5064_/A1 _3316_/X _3318_/X _3322_/X VGND VGND VPWR VPWR _3336_/B
+ sky130_fd_sc_hd__a2111o_1
XFILLER_59_809 VPWR VGND VPWR VGND sky130_ef_sc_hd__decap_40_12
XFILLER_113_777 VGND VGND VPWR VPWR sky130_fd_sc_hd__fill_4
XANTENNA__4845__A0 _4445_/A VGND VGND VPWR VPWR sky130_fd_sc_hd__diode_2
XPHY_EDGE_ROW_107_Right_107 VGND VGND VPWR VPWR sky130_fd_sc_hd__decap_3
X_6042_ _6345_/CLK _6042_/D VGND VGND VPWR VPWR _6042_/Q sky130_fd_sc_hd__dfxtp_1
X_3254_ _3358_/A1 _5922_/Q _3258_/S VGND VGND VPWR VPWR _3254_/X sky130_fd_sc_hd__mux2_1
XFILLER_100_449 VGND VGND VPWR VPWR sky130_fd_sc_hd__fill_1
X_3185_ _3185_/A0 _4846_/A0 _3193_/S VGND VGND VPWR VPWR _3185_/X sky130_fd_sc_hd__mux2_1
XFILLER_66_352 VGND VGND VPWR VPWR sky130_fd_sc_hd__fill_2
XTAP_TAPCELL_ROW_1_315 VGND VPWR sky130_fd_sc_hd__tapvpwrvgnd_1
XTAP_TAPCELL_ROW_68_1326 VGND VPWR sky130_fd_sc_hd__tapvpwrvgnd_1
XTAP_TAPCELL_ROW_68_1315 VGND VPWR sky130_fd_sc_hd__tapvpwrvgnd_1
XFILLER_54_525 VGND VGND VPWR VPWR sky130_fd_sc_hd__fill_1
XANTENNA_fanout165_A _4221_/S VGND VGND VPWR VPWR sky130_fd_sc_hd__diode_2
XTAP_TAPCELL_ROW_81_1515 VGND VPWR sky130_fd_sc_hd__tapvpwrvgnd_1
XFILLER_81_388 VGND VGND VPWR VPWR sky130_fd_sc_hd__fill_2
XFILLER_81_366 VGND VGND VPWR VPWR sky130_fd_sc_hd__fill_4
XFILLER_35_783 VGND VGND VPWR VPWR sky130_fd_sc_hd__fill_1
XFILLER_22_433 VPWR VGND VPWR VGND sky130_ef_sc_hd__decap_40_12
X_5826_ _6338_/CLK _5826_/D VGND VGND VPWR VPWR _5826_/Q sky130_fd_sc_hd__dfxtp_1
XFILLER_22_477 VPWR VGND VPWR VGND sky130_ef_sc_hd__decap_40_12
X_2969_ _6076_/Q _6368_/Q _3072_/S VGND VGND VPWR VPWR _2970_/B sky130_fd_sc_hd__mux2_1
X_5757_ _6137_/CLK _5757_/D VGND VGND VPWR VPWR _5757_/Q sky130_fd_sc_hd__dfxtp_1
XTAP_TAPCELL_ROW_20_601 VGND VPWR sky130_fd_sc_hd__tapvpwrvgnd_1
XFILLER_136_825 VPWR VGND VPWR VGND sky130_ef_sc_hd__decap_40_12
XANTENNA_fanout120_X _4886_/A1 VGND VGND VPWR VPWR sky130_fd_sc_hd__diode_2
X_4708_ hold606/X hold147/X _5635_/Q _5725_/Q _4790_/S _4789_/A VGND VGND VPWR VPWR
+ _4708_/X sky130_fd_sc_hd__mux4_1
X_5688_ _6097_/CLK _5688_/D VGND VGND VPWR VPWR _5688_/Q sky130_fd_sc_hd__dfxtp_1
XANTENNA__3507__S _3516_/S VGND VGND VPWR VPWR sky130_fd_sc_hd__diode_2
XTAP_TAPCELL_ROW_79_1488 VGND VPWR sky130_fd_sc_hd__tapvpwrvgnd_1
XFILLER_2_805 VGND VGND VPWR VPWR sky130_fd_sc_hd__fill_4
X_4639_ hold61/A _5659_/Q _4808_/S VGND VGND VPWR VPWR _4640_/B sky130_fd_sc_hd__mux2_1
XFILLER_118_67 VGND VGND VPWR VPWR sky130_fd_sc_hd__fill_1
Xhold640 _4869_/X VGND VGND VPWR VPWR _6219_/D sky130_fd_sc_hd__dlygate4sd3_1
XANTENNA__3887__A1 _3926_/A1 VGND VGND VPWR VPWR sky130_fd_sc_hd__diode_2
XFILLER_78_27 VGND VGND VPWR VPWR sky130_fd_sc_hd__fill_1
XTAP_TAPCELL_ROW_9_437 VGND VPWR sky130_fd_sc_hd__tapvpwrvgnd_1
Xhold662 _4501_/X VGND VGND VPWR VPWR _6106_/D sky130_fd_sc_hd__dlygate4sd3_1
Xhold651 _5956_/Q VGND VGND VPWR VPWR hold651/X sky130_fd_sc_hd__dlygate4sd3_1
XFILLER_131_541 VPWR VGND VPWR VGND sky130_ef_sc_hd__decap_40_12
XFILLER_104_755 VGND VGND VPWR VPWR sky130_fd_sc_hd__fill_1
XTAP_TAPCELL_ROW_92_1677 VGND VPWR sky130_fd_sc_hd__tapvpwrvgnd_1
Xhold673 _6046_/Q VGND VGND VPWR VPWR hold673/X sky130_fd_sc_hd__dlygate4sd3_1
Xhold684 _4507_/X VGND VGND VPWR VPWR _6111_/D sky130_fd_sc_hd__dlygate4sd3_1
XFILLER_1_337 VPWR VGND VPWR VGND sky130_ef_sc_hd__decap_40_12
Xhold695 _3761_/X VGND VGND VPWR VPWR _5772_/D sky130_fd_sc_hd__dlygate4sd3_1
X_6309_ _6316_/CLK _6309_/D VGND VGND VPWR VPWR _6309_/Q sky130_fd_sc_hd__dfxtp_1
XFILLER_131_585 VPWR VGND VPWR VGND sky130_ef_sc_hd__decap_40_12
Xhold2030 _6061_/Q VGND VGND VPWR VPWR _4441_/A1 sky130_fd_sc_hd__dlygate4sd3_1
XFILLER_49_319 VGND VGND VPWR VPWR sky130_fd_sc_hd__fill_2
XANTENNA__3639__A1 _4484_/A0 VGND VGND VPWR VPWR sky130_fd_sc_hd__diode_2
XFILLER_94_15 VPWR VGND VPWR VGND sky130_ef_sc_hd__decap_40_12
XANTENNA__4836__A0 _4901_/A0 VGND VGND VPWR VPWR sky130_fd_sc_hd__diode_2
Xhold2063 _5067_/X VGND VGND VPWR VPWR _6359_/D sky130_fd_sc_hd__dlygate4sd3_1
Xhold2041 _5136_/X VGND VGND VPWR VPWR _6391_/D sky130_fd_sc_hd__dlygate4sd3_1
Xhold2052 _4429_/X VGND VGND VPWR VPWR _6058_/D sky130_fd_sc_hd__dlygate4sd3_1
XANTENNA_fanout78_A _5214_/A1 VGND VGND VPWR VPWR sky130_fd_sc_hd__diode_2
XFILLER_94_37 VGND VGND VPWR VPWR sky130_fd_sc_hd__fill_2
Xhold1340 _5728_/Q VGND VGND VPWR VPWR _4787_/A3 sky130_fd_sc_hd__dlygate4sd3_1
Xhold2085 _6257_/Q VGND VGND VPWR VPWR _5178_/A1 sky130_fd_sc_hd__dlygate4sd3_1
Xhold2096 _5188_/Y VGND VGND VPWR VPWR _6402_/D sky130_fd_sc_hd__dlygate4sd3_1
XFILLER_57_341 VGND VGND VPWR VPWR sky130_fd_sc_hd__fill_1
Xhold2074 _6416_/Q VGND VGND VPWR VPWR hold2074/X sky130_fd_sc_hd__dlygate4sd3_1
Xhold1351 _3674_/X VGND VGND VPWR VPWR _5697_/D sky130_fd_sc_hd__dlygate4sd3_1
Xhold1395 _6424_/Q VGND VGND VPWR VPWR _5227_/A1 sky130_fd_sc_hd__dlygate4sd3_1
Xhold1373 _3868_/X VGND VGND VPWR VPWR _5850_/D sky130_fd_sc_hd__dlygate4sd3_1
Xhold1362 _4389_/X VGND VGND VPWR VPWR _6028_/D sky130_fd_sc_hd__dlygate4sd3_1
Xhold1384 _3773_/X VGND VGND VPWR VPWR _5783_/D sky130_fd_sc_hd__dlygate4sd3_1
XTAP_TAPCELL_ROW_28_723 VGND VPWR sky130_fd_sc_hd__tapvpwrvgnd_1
XTAP_TAPCELL_ROW_123_2143 VGND VPWR sky130_fd_sc_hd__tapvpwrvgnd_1
XFILLER_41_797 VPWR VGND VPWR VGND sky130_ef_sc_hd__decap_40_12
XFILLER_5_665 VGND VGND VPWR VPWR sky130_fd_sc_hd__fill_4
XFILLER_122_585 VGND VGND VPWR VPWR sky130_fd_sc_hd__fill_2
XFILLER_110_725 VPWR VGND VPWR VGND sky130_ef_sc_hd__decap_40_12
XANTENNA__4827__A0 _4905_/A0 VGND VGND VPWR VPWR sky130_fd_sc_hd__diode_2
XFILLER_110_769 VPWR VGND VPWR VGND sky130_ef_sc_hd__decap_40_12
XFILLER_48_341 VGND VGND VPWR VPWR sky130_fd_sc_hd__fill_2
XFILLER_36_503 VGND VGND VPWR VPWR sky130_fd_sc_hd__fill_1
XTAP_TAPCELL_ROW_108_1927 VGND VPWR sky130_fd_sc_hd__tapvpwrvgnd_1
XTAP_TAPCELL_ROW_108_1916 VGND VPWR sky130_fd_sc_hd__tapvpwrvgnd_1
XANTENNA__2991__S _3077_/S VGND VGND VPWR VPWR sky130_fd_sc_hd__diode_2
XFILLER_91_653 VPWR VGND VPWR VGND sky130_ef_sc_hd__decap_40_12
XFILLER_90_141 VGND VGND VPWR VPWR sky130_fd_sc_hd__fill_2
XFILLER_91_697 VPWR VGND VPWR VGND sky130_ef_sc_hd__decap_40_12
X_4990_ _4990_/A0 _5044_/A1 _4993_/S VGND VGND VPWR VPWR _4990_/X sky130_fd_sc_hd__mux2_1
XFILLER_17_783 VGND VGND VPWR VPWR sky130_fd_sc_hd__fill_1
XANTENNA__5079__S _5081_/S VGND VGND VPWR VPWR sky130_fd_sc_hd__diode_2
X_3941_ _5137_/A _3941_/B _5127_/A _6389_/Q VGND VGND VPWR VPWR _5142_/B sky130_fd_sc_hd__or4_2
XANTENNA__3802__A1 _3237_/A VGND VGND VPWR VPWR sky130_fd_sc_hd__diode_2
XTAP_TAPCELL_ROW_63_1245 VGND VPWR sky130_fd_sc_hd__tapvpwrvgnd_1
X_3872_ _4515_/A1 _3872_/A1 _3879_/S VGND VGND VPWR VPWR _5853_/D sky130_fd_sc_hd__mux2_1
X_2823_ _2819_/X _2821_/X _2822_/X _3096_/A1 VGND VGND VPWR VPWR _2823_/X sky130_fd_sc_hd__a22o_1
X_5611_ _6095_/CLK _5611_/D VGND VGND VPWR VPWR _5611_/Q sky130_fd_sc_hd__dfxtp_1
X_5542_ _6437_/CLK _5542_/D VGND VGND VPWR VPWR _5542_/Q sky130_fd_sc_hd__dfxtp_1
X_2754_ hold89/A _5369_/Q _5357_/Q _6138_/Q _3016_/S _3044_/A VGND VGND VPWR VPWR
+ _2754_/X sky130_fd_sc_hd__mux4_1
XFILLER_118_825 VPWR VGND VPWR VGND sky130_ef_sc_hd__decap_40_12
XFILLER_129_184 VGND VGND VPWR VPWR sky130_fd_sc_hd__fill_1
X_2685_ _2685_/A _2685_/B VGND VGND VPWR VPWR _5252_/D sky130_fd_sc_hd__nor2_1
X_5473_ _6290_/CLK _5473_/D VGND VGND VPWR VPWR _5473_/Q sky130_fd_sc_hd__dfxtp_1
XFILLER_133_839 VGND VGND VPWR VPWR sky130_fd_sc_hd__fill_1
XFILLER_132_305 VGND VGND VPWR VPWR sky130_fd_sc_hd__fill_1
XFILLER_105_519 VPWR VGND VPWR VGND sky130_ef_sc_hd__decap_40_12
X_4424_ _6374_/Q _4994_/B _4427_/B _5805_/Q _4421_/X VGND VGND VPWR VPWR _4424_/X
+ sky130_fd_sc_hd__a221o_2
XFILLER_113_541 VPWR VGND VPWR VGND sky130_ef_sc_hd__decap_40_12
XFILLER_99_753 VPWR VGND VPWR VGND sky130_ef_sc_hd__decap_40_12
X_4355_ hold415/X _5046_/A1 _4356_/S VGND VGND VPWR VPWR _4355_/X sky130_fd_sc_hd__mux2_1
XFILLER_101_725 VGND VGND VPWR VPWR sky130_fd_sc_hd__fill_2
XFILLER_99_797 VPWR VGND VPWR VGND sky130_ef_sc_hd__decap_40_12
X_3306_ hold469/X _5235_/A0 _3308_/S VGND VGND VPWR VPWR _3306_/X sky130_fd_sc_hd__mux2_1
XFILLER_113_585 VPWR VGND VPWR VGND sky130_ef_sc_hd__decap_40_12
XANTENNA__4818__A0 _4883_/A1 VGND VGND VPWR VPWR sky130_fd_sc_hd__diode_2
X_4286_ _4286_/A0 _4976_/A1 _4294_/S VGND VGND VPWR VPWR _4286_/X sky130_fd_sc_hd__mux2_1
XANTENNA__3062__S _3062_/S VGND VGND VPWR VPWR sky130_fd_sc_hd__diode_2
X_3237_ _3237_/A _3237_/B _4503_/A VGND VGND VPWR VPWR _5382_/D sky130_fd_sc_hd__and3_1
X_6025_ _6349_/CLK _6025_/D VGND VGND VPWR VPWR _6025_/Q sky130_fd_sc_hd__dfxtp_1
XANTENNA__4294__A1 _4984_/A1 VGND VGND VPWR VPWR sky130_fd_sc_hd__diode_2
XFILLER_67_694 VGND VGND VPWR VPWR sky130_fd_sc_hd__fill_2
X_3168_ _5085_/A _3168_/B _3172_/C VGND VGND VPWR VPWR _3168_/Y sky130_fd_sc_hd__nor3_1
XFILLER_66_193 VGND VGND VPWR VPWR sky130_fd_sc_hd__fill_2
XFILLER_54_344 VGND VGND VPWR VPWR sky130_fd_sc_hd__fill_4
XFILLER_15_709 VPWR VGND VPWR VGND sky130_ef_sc_hd__decap_40_12
X_3099_ hold81/X _3011_/A _3098_/X VGND VGND VPWR VPWR hold82/A sky130_fd_sc_hd__a21o_1
XFILLER_54_377 VGND VGND VPWR VPWR sky130_fd_sc_hd__fill_2
XANTENNA_fanout168_X _4257_/S VGND VGND VPWR VPWR sky130_fd_sc_hd__diode_2
Xfanout56 _5175_/S VGND VGND VPWR VPWR _5160_/A sky130_fd_sc_hd__clkbuf_4
Xfanout67 _2641_/Y VGND VGND VPWR VPWR _3096_/A1 sky130_fd_sc_hd__buf_4
X_5809_ _6060_/CLK _5809_/D VGND VGND VPWR VPWR _5809_/Q sky130_fd_sc_hd__dfxtp_1
Xfanout78 _5214_/A1 VGND VGND VPWR VPWR _3926_/A1 sky130_fd_sc_hd__buf_4
Xfanout89 hold2086/X VGND VGND VPWR VPWR _5209_/A1 sky130_fd_sc_hd__buf_4
XFILLER_23_797 VPWR VGND VPWR VGND sky130_ef_sc_hd__decap_40_12
XANTENNA__4621__S _4778_/S VGND VGND VPWR VPWR sky130_fd_sc_hd__diode_2
XANTENNA__3557__A0 _4958_/A0 VGND VGND VPWR VPWR sky130_fd_sc_hd__diode_2
XANTENNA__4754__C1 _4811_/C1 VGND VGND VPWR VPWR sky130_fd_sc_hd__diode_2
XFILLER_10_469 VGND VGND VPWR VPWR sky130_fd_sc_hd__fill_4
XTAP_TAPCELL_ROW_33_792 VGND VPWR sky130_fd_sc_hd__tapvpwrvgnd_1
XFILLER_129_66 VGND VGND VPWR VPWR sky130_fd_sc_hd__fill_1
XTAP_TAPCELL_ROW_94_1706 VGND VPWR sky130_fd_sc_hd__tapvpwrvgnd_1
XTAP_TAPCELL_ROW_94_1717 VGND VPWR sky130_fd_sc_hd__tapvpwrvgnd_1
XFILLER_136_699 VGND VGND VPWR VPWR sky130_fd_sc_hd__fill_1
XFILLER_2_613 VPWR VGND VPWR VGND sky130_ef_sc_hd__decap_40_12
XFILLER_116_390 VGND VGND VPWR VPWR sky130_fd_sc_hd__fill_2
Xhold470 _3306_/X VGND VGND VPWR VPWR _5424_/D sky130_fd_sc_hd__dlygate4sd3_1
XFILLER_2_657 VPWR VGND VPWR VGND sky130_ef_sc_hd__decap_40_12
Xhold481 _6122_/Q VGND VGND VPWR VPWR hold481/X sky130_fd_sc_hd__dlygate4sd3_1
Xhold492 _3903_/X VGND VGND VPWR VPWR _5882_/D sky130_fd_sc_hd__dlygate4sd3_1
XFILLER_1_167 VGND VGND VPWR VPWR sky130_fd_sc_hd__fill_1
XANTENNA__2648__Y _3237_/A VGND VGND VPWR VPWR sky130_fd_sc_hd__diode_2
XFILLER_104_585 VGND VGND VPWR VPWR sky130_fd_sc_hd__fill_2
Xhold1170 _3484_/X VGND VGND VPWR VPWR _5530_/D sky130_fd_sc_hd__dlygate4sd3_1
XFILLER_57_171 VGND VGND VPWR VPWR sky130_fd_sc_hd__fill_1
XFILLER_18_525 VGND VGND VPWR VPWR sky130_fd_sc_hd__fill_4
XFILLER_38_74 VGND VGND VPWR VPWR sky130_fd_sc_hd__fill_1
Xhold1192 _5562_/Q VGND VGND VPWR VPWR _3519_/A1 sky130_fd_sc_hd__dlygate4sd3_1
Xhold1181 _5577_/Q VGND VGND VPWR VPWR _3534_/A0 sky130_fd_sc_hd__dlygate4sd3_1
XANTENNA_input10_A s_axil_bready VGND VGND VPWR VPWR sky130_fd_sc_hd__diode_2
XFILLER_18_569 VPWR VGND VPWR VGND sky130_ef_sc_hd__decap_40_12
XANTENNA__5234__A0 _5234_/A0 VGND VGND VPWR VPWR sky130_fd_sc_hd__diode_2
XFILLER_61_837 VGND VGND VPWR VPWR sky130_fd_sc_hd__fill_2
XANTENNA__3700__S _3707_/S VGND VGND VPWR VPWR sky130_fd_sc_hd__diode_2
XFILLER_45_377 VGND VGND VPWR VPWR sky130_fd_sc_hd__fill_1
XFILLER_45_366 VGND VGND VPWR VPWR sky130_fd_sc_hd__fill_1
XANTENNA__4037__A1 _4252_/A1 VGND VGND VPWR VPWR sky130_fd_sc_hd__diode_2
XTAP_TAPCELL_ROW_103_1846 VGND VPWR sky130_fd_sc_hd__tapvpwrvgnd_1
XFILLER_14_753 VGND VGND VPWR VPWR sky130_fd_sc_hd__fill_2
XFILLER_41_561 VGND VGND VPWR VPWR sky130_fd_sc_hd__fill_2
XTAP_TAPCELL_ROW_136_2345 VGND VPWR sky130_fd_sc_hd__tapvpwrvgnd_1
XTAP_TAPCELL_ROW_136_2334 VGND VPWR sky130_fd_sc_hd__tapvpwrvgnd_1
XANTENNA__4531__S _4535_/S VGND VGND VPWR VPWR sky130_fd_sc_hd__diode_2
XFILLER_13_296 VGND VGND VPWR VPWR sky130_fd_sc_hd__fill_1
Xclkload26 _6341_/CLK VGND VGND VPWR VPWR clkload26/Y sky130_fd_sc_hd__clkinv_4
Xclkload15 _6315_/CLK VGND VGND VPWR VPWR clkload15/Y sky130_fd_sc_hd__clkinv_4
XTAP_TAPCELL_ROW_11_464 VGND VPWR sky130_fd_sc_hd__tapvpwrvgnd_1
Xclkload37 _6409_/CLK VGND VGND VPWR VPWR clkload37/Y sky130_fd_sc_hd__clkinvlp_4
Xclkload59 _6418_/CLK VGND VGND VPWR VPWR clkload59/Y sky130_fd_sc_hd__inv_6
Xclkload48 _6121_/CLK VGND VGND VPWR VPWR clkload48/Y sky130_fd_sc_hd__clkinv_4
XFILLER_115_839 VGND VGND VPWR VPWR sky130_fd_sc_hd__fill_1
XFILLER_5_473 VPWR VGND VPWR VGND sky130_ef_sc_hd__decap_40_12
XFILLER_130_809 VGND VGND VPWR VPWR sky130_fd_sc_hd__fill_2
XANTENNA__2986__S _3072_/S VGND VGND VPWR VPWR sky130_fd_sc_hd__diode_2
XFILLER_48_5 VGND VGND VPWR VPWR sky130_fd_sc_hd__fill_2
XANTENNA__4767__A _4802_/A VGND VGND VPWR VPWR sky130_fd_sc_hd__diode_2
XFILLER_96_701 VPWR VGND VPWR VGND sky130_ef_sc_hd__decap_40_12
X_4140_ _4970_/A1 _6285_/Q _4257_/S VGND VGND VPWR VPWR _4141_/B sky130_fd_sc_hd__mux2_1
XFILLER_110_533 VPWR VGND VPWR VGND sky130_ef_sc_hd__decap_40_12
XFILLER_68_436 VGND VGND VPWR VPWR sky130_fd_sc_hd__fill_1
XANTENNA__4276__A1 _5051_/A1 VGND VGND VPWR VPWR sky130_fd_sc_hd__diode_2
X_4071_ _6001_/Q _5992_/Q _4270_/S VGND VGND VPWR VPWR _4071_/X sky130_fd_sc_hd__mux2_1
X_3022_ _3036_/A1 _3021_/X _3094_/C1 VGND VGND VPWR VPWR _3022_/X sky130_fd_sc_hd__o21a_1
XFILLER_95_277 VGND VGND VPWR VPWR sky130_fd_sc_hd__fill_2
XFILLER_64_675 VGND VGND VPWR VPWR sky130_fd_sc_hd__fill_4
XFILLER_52_837 VGND VGND VPWR VPWR sky130_fd_sc_hd__fill_4
XANTENNA__4028__A1 _4264_/A1 VGND VGND VPWR VPWR sky130_fd_sc_hd__diode_2
XFILLER_64_697 VGND VGND VPWR VPWR sky130_fd_sc_hd__fill_1
XFILLER_63_196 VGND VGND VPWR VPWR sky130_fd_sc_hd__fill_4
XFILLER_51_325 VGND VGND VPWR VPWR sky130_fd_sc_hd__fill_2
XFILLER_51_314 VGND VGND VPWR VPWR sky130_fd_sc_hd__fill_4
X_4973_ _4983_/A1 _4973_/A1 _4974_/S VGND VGND VPWR VPWR _4973_/X sky130_fd_sc_hd__mux2_1
XTAP_TAPCELL_ROW_19_586 VGND VPWR sky130_fd_sc_hd__tapvpwrvgnd_1
XFILLER_36_399 VGND VGND VPWR VPWR sky130_fd_sc_hd__fill_4
XANTENNA__4007__A _4007_/A VGND VGND VPWR VPWR sky130_fd_sc_hd__diode_2
X_3924_ hold743/X _4488_/A0 _3928_/S VGND VGND VPWR VPWR _3924_/X sky130_fd_sc_hd__mux2_1
XFILLER_20_701 VPWR VGND VPWR VGND sky130_ef_sc_hd__decap_40_12
X_3855_ _4912_/A _3813_/B _3854_/B1 VGND VGND VPWR VPWR _3855_/X sky130_fd_sc_hd__a21bo_1
Xclkload9 clkload9/A VGND VGND VPWR VPWR clkload9/Y sky130_fd_sc_hd__clkinv_2
X_2806_ _3031_/A1 _2805_/X _3085_/A VGND VGND VPWR VPWR _2806_/Y sky130_fd_sc_hd__o21ai_1
XANTENNA_fanout128_A _4903_/A0 VGND VGND VPWR VPWR sky130_fd_sc_hd__diode_2
X_3786_ hold441/X _5215_/A1 _3787_/S VGND VGND VPWR VPWR _3786_/X sky130_fd_sc_hd__mux2_1
XTAP_TAPCELL_ROW_30_751 VGND VPWR sky130_fd_sc_hd__tapvpwrvgnd_1
X_5525_ _6252_/CLK _5525_/D VGND VGND VPWR VPWR _5525_/Q sky130_fd_sc_hd__dfxtp_1
X_2737_ _2735_/A _2735_/B _2736_/Y VGND VGND VPWR VPWR _5270_/D sky130_fd_sc_hd__o21a_1
XFILLER_118_699 VGND VGND VPWR VPWR sky130_fd_sc_hd__fill_1
X_2668_ _4894_/A _4881_/A VGND VGND VPWR VPWR _5241_/S sky130_fd_sc_hd__nor2_8
XTAP_TAPCELL_ROW_76_1447 VGND VPWR sky130_fd_sc_hd__tapvpwrvgnd_1
XTAP_TAPCELL_ROW_76_1436 VGND VPWR sky130_fd_sc_hd__tapvpwrvgnd_1
X_5456_ _5784_/CLK _5456_/D VGND VGND VPWR VPWR _5456_/Q sky130_fd_sc_hd__dfxtp_1
XFILLER_133_669 VGND VGND VPWR VPWR sky130_fd_sc_hd__fill_2
XFILLER_121_809 VPWR VGND VPWR VGND sky130_ef_sc_hd__decap_40_12
XANTENNA__5161__C1 _2682_/A VGND VGND VPWR VPWR sky130_fd_sc_hd__diode_2
X_4407_ _5050_/A _5038_/B VGND VGND VPWR VPWR _4416_/S sky130_fd_sc_hd__or2_4
XFILLER_132_157 VGND VGND VPWR VPWR sky130_fd_sc_hd__fill_4
XFILLER_99_561 VPWR VGND VPWR VGND sky130_ef_sc_hd__decap_40_12
Xfanout202 _2682_/A VGND VGND VPWR VPWR _5034_/B sky130_fd_sc_hd__buf_4
X_5387_ _6408_/CLK _5387_/D VGND VGND VPWR VPWR _5387_/Q sky130_fd_sc_hd__dfxtp_1
XFILLER_59_447 VGND VGND VPWR VPWR sky130_fd_sc_hd__fill_1
X_4338_ hold131/X _5040_/A1 _4345_/S VGND VGND VPWR VPWR _4338_/X sky130_fd_sc_hd__mux2_1
XFILLER_115_57 VGND VGND VPWR VPWR sky130_fd_sc_hd__fill_1
X_4269_ _6044_/Q _6352_/Q _4270_/S VGND VGND VPWR VPWR _4269_/X sky130_fd_sc_hd__mux2_1
XANTENNA_input2_A i2c_sda_i VGND VGND VPWR VPWR sky130_fd_sc_hd__diode_2
XFILLER_74_417 VGND VGND VPWR VPWR sky130_fd_sc_hd__fill_2
X_6008_ _6351_/CLK _6008_/D VGND VGND VPWR VPWR _6008_/Q sky130_fd_sc_hd__dfxtp_1
XFILLER_27_300 VGND VGND VPWR VPWR sky130_fd_sc_hd__fill_2
XFILLER_67_491 VGND VGND VPWR VPWR sky130_fd_sc_hd__fill_2
XANTENNA__3520__S _3529_/S VGND VGND VPWR VPWR sky130_fd_sc_hd__diode_2
XTAP_TAPCELL_ROW_120_2102 VGND VPWR sky130_fd_sc_hd__tapvpwrvgnd_1
XFILLER_82_472 VGND VGND VPWR VPWR sky130_fd_sc_hd__fill_4
XFILLER_15_517 VPWR VGND VPWR VGND sky130_ef_sc_hd__decap_40_12
XTAP_TAPCELL_ROW_38_873 VGND VPWR sky130_fd_sc_hd__tapvpwrvgnd_1
XTAP_TAPCELL_ROW_87_1598 VGND VPWR sky130_fd_sc_hd__tapvpwrvgnd_1
XFILLER_43_837 VGND VGND VPWR VPWR sky130_fd_sc_hd__fill_2
XANTENNA__4114__S1 _4241_/A VGND VGND VPWR VPWR sky130_fd_sc_hd__diode_2
XFILLER_138_3 VPWR VGND VPWR VGND sky130_ef_sc_hd__decap_40_12
XANTENNA__4351__S _4356_/S VGND VGND VPWR VPWR sky130_fd_sc_hd__diode_2
XTAP_TAPCELL_ROW_118_2064 VGND VPWR sky130_fd_sc_hd__tapvpwrvgnd_1
XFILLER_7_727 VGND VGND VPWR VPWR sky130_fd_sc_hd__fill_1
XTAP_TAPCELL_ROW_118_2075 VGND VPWR sky130_fd_sc_hd__tapvpwrvgnd_1
XFILLER_124_625 VPWR VGND VPWR VGND sky130_ef_sc_hd__decap_40_12
XANTENNA__2753__A1 _5237_/A0 VGND VGND VPWR VPWR sky130_fd_sc_hd__diode_2
XTAP_TAPCELL_ROW_131_2264 VGND VPWR sky130_fd_sc_hd__tapvpwrvgnd_1
XFILLER_124_669 VPWR VGND VPWR VGND sky130_ef_sc_hd__decap_40_12
XFILLER_123_113 VGND VGND VPWR VPWR sky130_fd_sc_hd__fill_4
XFILLER_112_809 VGND VGND VPWR VPWR sky130_fd_sc_hd__fill_2
XFILLER_2_421 VPWR VGND VPWR VGND sky130_ef_sc_hd__decap_40_12
XANTENNA__3491__A _4881_/A VGND VGND VPWR VPWR sky130_fd_sc_hd__diode_2
XANTENNA__3702__A0 _5211_/A1 VGND VGND VPWR VPWR sky130_fd_sc_hd__diode_2
XFILLER_104_382 VGND VGND VPWR VPWR sky130_fd_sc_hd__fill_1
XFILLER_78_789 VPWR VGND VPWR VGND sky130_ef_sc_hd__decap_40_12
XFILLER_92_214 VGND VGND VPWR VPWR sky130_fd_sc_hd__fill_1
XFILLER_92_225 VGND VGND VPWR VPWR sky130_fd_sc_hd__fill_4
XFILLER_1_69 VPWR VGND VPWR VGND sky130_ef_sc_hd__decap_40_12
XANTENNA__4526__S _4535_/S VGND VGND VPWR VPWR sky130_fd_sc_hd__diode_2
XANTENNA__3430__S _3437_/S VGND VGND VPWR VPWR sky130_fd_sc_hd__diode_2
XFILLER_46_664 VGND VGND VPWR VPWR sky130_fd_sc_hd__fill_1
XTAP_TAPCELL_ROW_47_1004 VGND VPWR sky130_fd_sc_hd__tapvpwrvgnd_1
XFILLER_18_377 VPWR VGND VPWR VGND sky130_ef_sc_hd__decap_40_12
XFILLER_34_837 VGND VGND VPWR VPWR sky130_fd_sc_hd__fill_4
XANTENNA__3769__A0 _5040_/A1 VGND VGND VPWR VPWR sky130_fd_sc_hd__diode_2
XTAP_TAPCELL_ROW_16_534 VGND VPWR sky130_fd_sc_hd__tapvpwrvgnd_1
XTAP_TAPCELL_ROW_16_545 VGND VPWR sky130_fd_sc_hd__tapvpwrvgnd_1
XTAP_TAPCELL_ROW_60_1204 VGND VPWR sky130_fd_sc_hd__tapvpwrvgnd_1
XFILLER_81_93 VGND VGND VPWR VPWR sky130_fd_sc_hd__fill_1
XFILLER_41_391 VGND VGND VPWR VPWR sky130_fd_sc_hd__fill_1
XANTENNA__2992__A1 _2642_/Y VGND VGND VPWR VPWR sky130_fd_sc_hd__diode_2
Xclkload104 _6233_/CLK VGND VGND VPWR VPWR clkload104/Y sky130_fd_sc_hd__bufinv_16
X_3640_ _3640_/A0 _5209_/A1 _3647_/S VGND VGND VPWR VPWR _3640_/X sky130_fd_sc_hd__mux2_1
XANTENNA__4261__S _4262_/S VGND VGND VPWR VPWR sky130_fd_sc_hd__diode_2
X_3571_ hold365/X _4961_/A0 _3574_/S VGND VGND VPWR VPWR _3571_/X sky130_fd_sc_hd__mux2_1
XANTENNA__4194__B1 _4252_/B1 VGND VGND VPWR VPWR sky130_fd_sc_hd__diode_2
X_5310_ _6432_/CLK _5310_/D VGND VGND VPWR VPWR _5310_/Q sky130_fd_sc_hd__dfxtp_1
XANTENNA__2744__A1 _5228_/A0 VGND VGND VPWR VPWR sky130_fd_sc_hd__diode_2
X_6290_ _6290_/CLK _6290_/D VGND VGND VPWR VPWR _6290_/Q sky130_fd_sc_hd__dfxtp_1
XFILLER_53_3 VGND VGND VPWR VPWR sky130_fd_sc_hd__fill_1
XFILLER_103_809 VPWR VGND VPWR VGND sky130_ef_sc_hd__decap_40_12
XTAP_TAPCELL_ROW_58_1177 VGND VPWR sky130_fd_sc_hd__tapvpwrvgnd_1
XTAP_TAPCELL_ROW_58_1166 VGND VPWR sky130_fd_sc_hd__tapvpwrvgnd_1
XFILLER_6_793 VPWR VGND VPWR VGND sky130_ef_sc_hd__decap_40_12
X_5241_ hold679/X _5241_/A1 _5241_/S VGND VGND VPWR VPWR _5241_/X sky130_fd_sc_hd__mux2_1
XFILLER_115_669 VGND VGND VPWR VPWR sky130_fd_sc_hd__fill_2
XFILLER_69_712 VPWR VGND VPWR VGND sky130_ef_sc_hd__decap_40_12
XANTENNA_clkbuf_3_0__f_clk_A clkbuf_0_clk/X VGND VGND VPWR VPWR sky130_fd_sc_hd__diode_2
XANTENNA__4497__A1 _5211_/A1 VGND VGND VPWR VPWR sky130_fd_sc_hd__diode_2
XFILLER_96_531 VGND VGND VPWR VPWR sky130_fd_sc_hd__fill_1
X_5172_ _5178_/A1 _5172_/A1 _5194_/S VGND VGND VPWR VPWR _5172_/X sky130_fd_sc_hd__mux2_1
XTAP_TAPCELL_ROW_71_1366 VGND VPWR sky130_fd_sc_hd__tapvpwrvgnd_1
Xhold1917 _6375_/Q VGND VGND VPWR VPWR _5087_/A0 sky130_fd_sc_hd__dlygate4sd3_1
X_4123_ _4264_/A1 _4122_/X _4121_/X _4271_/S1 VGND VGND VPWR VPWR _4123_/X sky130_fd_sc_hd__o211a_1
Xhold1906 _5259_/Q VGND VGND VPWR VPWR _2711_/A1 sky130_fd_sc_hd__dlygate4sd3_1
Xhold1939 _5557_/Q VGND VGND VPWR VPWR _3513_/A1 sky130_fd_sc_hd__dlygate4sd3_1
Xhold1928 _3930_/X VGND VGND VPWR VPWR _5906_/D sky130_fd_sc_hd__dlygate4sd3_1
Xinput2 i2c_sda_i VGND VGND VPWR VPWR input2/X sky130_fd_sc_hd__buf_1
X_4054_ _6300_/Q _6282_/Q _4257_/S VGND VGND VPWR VPWR _4055_/B sky130_fd_sc_hd__mux2_1
X_3005_ _3005_/A _3005_/B VGND VGND VPWR VPWR _3005_/Y sky130_fd_sc_hd__nor2_1
XFILLER_83_225 VGND VGND VPWR VPWR sky130_fd_sc_hd__fill_4
XFILLER_101_15 VGND VGND VPWR VPWR sky130_fd_sc_hd__fill_8
XFILLER_92_781 VPWR VGND VPWR VGND sky130_ef_sc_hd__decap_40_12
XANTENNA__5829__Q _5829_/Q VGND VGND VPWR VPWR sky130_fd_sc_hd__diode_2
XFILLER_52_645 VGND VGND VPWR VPWR sky130_fd_sc_hd__fill_1
XFILLER_25_837 VGND VGND VPWR VPWR sky130_fd_sc_hd__fill_2
XTAP_TAPCELL_ROW_35_821 VGND VPWR sky130_fd_sc_hd__tapvpwrvgnd_1
XTAP_TAPCELL_ROW_35_832 VGND VPWR sky130_fd_sc_hd__tapvpwrvgnd_1
XFILLER_101_59 VGND VGND VPWR VPWR sky130_fd_sc_hd__fill_1
X_4956_ _5208_/A1 _4956_/A1 _4964_/S VGND VGND VPWR VPWR _4956_/X sky130_fd_sc_hd__mux2_1
X_4887_ hold33/X _4887_/A1 _4893_/S VGND VGND VPWR VPWR hold34/A sky130_fd_sc_hd__mux2_1
XFILLER_20_531 VGND VGND VPWR VPWR sky130_fd_sc_hd__fill_1
X_3907_ _3907_/A0 _5215_/A1 _3908_/S VGND VGND VPWR VPWR _3907_/X sky130_fd_sc_hd__mux2_1
X_3838_ _3838_/A0 input12/X _3852_/B VGND VGND VPWR VPWR _3839_/B sky130_fd_sc_hd__mux2_1
XANTENNA__4171__S _4262_/S VGND VGND VPWR VPWR sky130_fd_sc_hd__diode_2
XANTENNA__4185__B1 _3172_/B VGND VGND VPWR VPWR sky130_fd_sc_hd__diode_2
XFILLER_118_452 VGND VGND VPWR VPWR sky130_fd_sc_hd__fill_2
X_5508_ _6435_/CLK _5508_/D VGND VGND VPWR VPWR hold99/A sky130_fd_sc_hd__dfxtp_1
XFILLER_106_625 VPWR VGND VPWR VGND sky130_ef_sc_hd__decap_40_12
XANTENNA__3932__A0 _4978_/A1 VGND VGND VPWR VPWR sky130_fd_sc_hd__diode_2
X_3769_ _5040_/A1 _4049_/A0 _3776_/S VGND VGND VPWR VPWR _3769_/X sky130_fd_sc_hd__mux2_1
XFILLER_3_229 VGND VGND VPWR VPWR sky130_fd_sc_hd__fill_1
XFILLER_121_617 VPWR VGND VPWR VGND sky130_ef_sc_hd__decap_40_12
XANTENNA__3515__S _3516_/S VGND VGND VPWR VPWR sky130_fd_sc_hd__diode_2
XFILLER_106_669 VPWR VGND VPWR VGND sky130_ef_sc_hd__decap_40_12
XFILLER_79_509 VGND VGND VPWR VPWR sky130_fd_sc_hd__fill_1
X_5439_ _6057_/CLK _5439_/D VGND VGND VPWR VPWR _5439_/Q sky130_fd_sc_hd__dfxtp_1
XFILLER_10_67 VGND VGND VPWR VPWR sky130_fd_sc_hd__fill_1
XFILLER_120_105 VGND VGND VPWR VPWR sky130_fd_sc_hd__fill_1
XFILLER_86_27 VGND VGND VPWR VPWR sky130_fd_sc_hd__fill_1
XFILLER_101_341 VGND VGND VPWR VPWR sky130_fd_sc_hd__fill_2
XANTENNA_input5_X input5/X VGND VGND VPWR VPWR sky130_fd_sc_hd__diode_2
XFILLER_19_21 VGND VGND VPWR VPWR sky130_fd_sc_hd__fill_1
XFILLER_101_374 VGND VGND VPWR VPWR sky130_fd_sc_hd__fill_8
XTAP_TAPCELL_ROW_89_1638 VGND VPWR sky130_fd_sc_hd__tapvpwrvgnd_1
XFILLER_75_726 VGND VGND VPWR VPWR sky130_fd_sc_hd__fill_2
XFILLER_74_214 VGND VGND VPWR VPWR sky130_fd_sc_hd__fill_4
XFILLER_47_417 VGND VGND VPWR VPWR sky130_fd_sc_hd__fill_1
XFILLER_74_247 VGND VGND VPWR VPWR sky130_fd_sc_hd__fill_4
XFILLER_90_729 VPWR VGND VPWR VGND sky130_ef_sc_hd__decap_40_12
XFILLER_16_837 VGND VGND VPWR VPWR sky130_fd_sc_hd__fill_4
XFILLER_27_185 VGND VGND VPWR VPWR sky130_fd_sc_hd__fill_2
XFILLER_70_453 VGND VGND VPWR VPWR sky130_fd_sc_hd__fill_1
XANTENNA__4099__S0 _4213_/S VGND VGND VPWR VPWR sky130_fd_sc_hd__diode_2
XFILLER_42_133 VGND VGND VPWR VPWR sky130_fd_sc_hd__fill_4
XTAP_TAPCELL_ROW_100_1805 VGND VPWR sky130_fd_sc_hd__tapvpwrvgnd_1
XFILLER_70_475 VGND VGND VPWR VPWR sky130_fd_sc_hd__fill_1
XANTENNA__3757__Y _3766_/S VGND VGND VPWR VPWR sky130_fd_sc_hd__diode_2
XFILLER_42_199 VGND VGND VPWR VPWR sky130_fd_sc_hd__fill_2
XFILLER_23_391 VGND VGND VPWR VPWR sky130_fd_sc_hd__fill_1
XFILLER_11_553 VGND VGND VPWR VPWR sky130_fd_sc_hd__fill_4
XFILLER_128_249 VGND VGND VPWR VPWR sky130_fd_sc_hd__fill_2
XFILLER_7_557 VGND VGND VPWR VPWR sky130_fd_sc_hd__fill_2
XFILLER_11_597 VPWR VGND VPWR VGND sky130_ef_sc_hd__decap_40_12
XFILLER_137_783 VGND VGND VPWR VPWR sky130_fd_sc_hd__fill_1
XANTENNA__2726__A1 _3030_/S VGND VGND VPWR VPWR sky130_fd_sc_hd__diode_2
XANTENNA__4271__S0 _4212_/A VGND VGND VPWR VPWR sky130_fd_sc_hd__diode_2
XFILLER_3_741 VPWR VGND VPWR VGND sky130_ef_sc_hd__decap_40_12
XANTENNA__4479__A1 _5213_/A1 VGND VGND VPWR VPWR sky130_fd_sc_hd__diode_2
XFILLER_3_785 VPWR VGND VPWR VGND sky130_ef_sc_hd__decap_40_12
XTAP_TAPCELL_ROW_111_1967 VGND VPWR sky130_fd_sc_hd__tapvpwrvgnd_1
XFILLER_78_531 VGND VGND VPWR VPWR sky130_fd_sc_hd__fill_1
XTAP_TAPCELL_ROW_53_1096 VGND VPWR sky130_fd_sc_hd__tapvpwrvgnd_1
XFILLER_38_417 VGND VGND VPWR VPWR sky130_fd_sc_hd__fill_2
XFILLER_81_729 VGND VGND VPWR VPWR sky130_fd_sc_hd__fill_1
XFILLER_81_718 VGND VGND VPWR VPWR sky130_fd_sc_hd__fill_1
XFILLER_18_141 VGND VGND VPWR VPWR sky130_fd_sc_hd__fill_4
XANTENNA__4256__S _4257_/S VGND VGND VPWR VPWR sky130_fd_sc_hd__diode_2
XFILLER_19_653 VPWR VGND VPWR VGND sky130_ef_sc_hd__decap_40_12
XFILLER_80_217 VGND VGND VPWR VPWR sky130_fd_sc_hd__fill_2
XFILLER_19_697 VPWR VGND VPWR VGND sky130_ef_sc_hd__decap_40_12
XFILLER_33_111 VGND VGND VPWR VPWR sky130_fd_sc_hd__fill_1
X_4810_ _5701_/Q _5905_/Q _4810_/S VGND VGND VPWR VPWR _4810_/X sky130_fd_sc_hd__mux2_1
X_5790_ _6114_/CLK _5790_/D VGND VGND VPWR VPWR _5790_/Q sky130_fd_sc_hd__dfxtp_1
X_4741_ _4791_/B1 _4740_/X _4737_/Y _4739_/Y VGND VGND VPWR VPWR _4742_/B sky130_fd_sc_hd__o2bb2a_1
X_4672_ _2629_/Y _4671_/X _2628_/A VGND VGND VPWR VPWR _4672_/Y sky130_fd_sc_hd__o21ai_1
XFILLER_135_709 VPWR VGND VPWR VGND sky130_ef_sc_hd__decap_40_12
X_6411_ _6417_/CLK _6411_/D VGND VGND VPWR VPWR _6411_/Q sky130_fd_sc_hd__dfxtp_1
X_3623_ _3623_/A0 _4488_/A0 _3627_/S VGND VGND VPWR VPWR _3623_/X sky130_fd_sc_hd__mux2_1
XANTENNA__4167__B1 _3172_/B VGND VGND VPWR VPWR sky130_fd_sc_hd__diode_2
X_6342_ _6342_/CLK _6342_/D VGND VGND VPWR VPWR _6342_/Q sky130_fd_sc_hd__dfxtp_1
X_3554_ _4955_/A _4513_/A VGND VGND VPWR VPWR _3563_/S sky130_fd_sc_hd__or2_4
X_3485_ _3485_/A0 _4901_/A0 _3490_/S VGND VGND VPWR VPWR _3485_/X sky130_fd_sc_hd__mux2_1
XFILLER_103_617 VPWR VGND VPWR VGND sky130_ef_sc_hd__decap_40_12
X_6273_ _6300_/CLK _6273_/D VGND VGND VPWR VPWR _6273_/Q sky130_fd_sc_hd__dfxtp_1
XANTENNA__3390__A1 _4984_/A1 VGND VGND VPWR VPWR sky130_fd_sc_hd__diode_2
X_5224_ _5048_/A _5119_/Y _5224_/B1 _5034_/B VGND VGND VPWR VPWR _5224_/X sky130_fd_sc_hd__o211a_1
Xhold1703 _5553_/Q VGND VGND VPWR VPWR _3509_/A1 sky130_fd_sc_hd__dlygate4sd3_1
XANTENNA__4890__A1 _4903_/A0 VGND VGND VPWR VPWR sky130_fd_sc_hd__diode_2
XANTENNA_fanout195_A _3091_/S VGND VGND VPWR VPWR sky130_fd_sc_hd__diode_2
Xhold1714 _5858_/Q VGND VGND VPWR VPWR _3877_/A1 sky130_fd_sc_hd__dlygate4sd3_1
X_5155_ _5160_/A _5155_/B VGND VGND VPWR VPWR _5155_/Y sky130_fd_sc_hd__nand2_1
Xhold1725 _5694_/Q VGND VGND VPWR VPWR _3671_/A1 sky130_fd_sc_hd__dlygate4sd3_1
Xhold1758 _5546_/Q VGND VGND VPWR VPWR _3501_/A1 sky130_fd_sc_hd__dlygate4sd3_1
Xhold1747 _4840_/X VGND VGND VPWR VPWR _6193_/D sky130_fd_sc_hd__dlygate4sd3_1
Xhold1769 _4962_/X VGND VGND VPWR VPWR _6296_/D sky130_fd_sc_hd__dlygate4sd3_1
X_5086_ _5086_/A0 _6162_/Q _5094_/S VGND VGND VPWR VPWR _5086_/X sky130_fd_sc_hd__mux2_1
X_4106_ _4251_/A _4106_/B VGND VGND VPWR VPWR _4106_/X sky130_fd_sc_hd__or2_1
Xhold1736 _4403_/X VGND VGND VPWR VPWR _6041_/D sky130_fd_sc_hd__dlygate4sd3_1
X_4037_ _4252_/A1 _4036_/X _4252_/B1 VGND VGND VPWR VPWR _4037_/Y sky130_fd_sc_hd__o21ai_1
XANTENNA__4166__S _4213_/S VGND VGND VPWR VPWR sky130_fd_sc_hd__diode_2
XANTENNA__2879__S1 _3050_/A VGND VGND VPWR VPWR sky130_fd_sc_hd__diode_2
XFILLER_65_781 VGND VGND VPWR VPWR sky130_fd_sc_hd__fill_2
XANTENNA__4642__A1 _4811_/A1 VGND VGND VPWR VPWR sky130_fd_sc_hd__diode_2
XTAP_TAPCELL_ROW_84_1557 VGND VPWR sky130_fd_sc_hd__tapvpwrvgnd_1
XFILLER_80_762 VPWR VGND VPWR VGND sky130_ef_sc_hd__decap_40_12
XFILLER_72_29 VGND VGND VPWR VPWR sky130_fd_sc_hd__fill_2
XFILLER_64_291 VGND VGND VPWR VPWR sky130_fd_sc_hd__fill_1
XFILLER_52_431 VGND VGND VPWR VPWR sky130_fd_sc_hd__fill_1
XANTENNA__5198__A2 _4007_/A VGND VGND VPWR VPWR sky130_fd_sc_hd__diode_2
XANTENNA_fanout150_X _4773_/S VGND VGND VPWR VPWR sky130_fd_sc_hd__diode_2
X_5988_ _5988_/CLK hold19/X VGND VGND VPWR VPWR hold18/A sky130_fd_sc_hd__dfxtp_1
X_4939_ _5042_/A1 _4939_/A1 _4944_/S VGND VGND VPWR VPWR _4939_/X sky130_fd_sc_hd__mux2_1
XFILLER_138_503 VGND VGND VPWR VPWR sky130_fd_sc_hd__fill_1
XANTENNA__4158__B1 _4205_/A VGND VGND VPWR VPWR sky130_fd_sc_hd__diode_2
XFILLER_119_783 VGND VGND VPWR VPWR sky130_fd_sc_hd__fill_1
XTAP_TAPCELL_ROW_115_2023 VGND VPWR sky130_fd_sc_hd__tapvpwrvgnd_1
XFILLER_21_44 VGND VGND VPWR VPWR sky130_fd_sc_hd__fill_1
XFILLER_137_55 VGND VGND VPWR VPWR sky130_fd_sc_hd__fill_1
XFILLER_106_433 VGND VGND VPWR VPWR sky130_fd_sc_hd__fill_2
XFILLER_21_77 VGND VGND VPWR VPWR sky130_fd_sc_hd__fill_4
XFILLER_137_77 VGND VGND VPWR VPWR sky130_fd_sc_hd__fill_1
XFILLER_134_753 VGND VGND VPWR VPWR sky130_fd_sc_hd__fill_2
XFILLER_97_15 VPWR VGND VPWR VGND sky130_ef_sc_hd__decap_40_12
XFILLER_106_488 VGND VGND VPWR VPWR sky130_fd_sc_hd__fill_1
XANTENNA__4330__A0 _4929_/A1 VGND VGND VPWR VPWR sky130_fd_sc_hd__diode_2
XTAP_TAPCELL_ROW_7_398 VGND VPWR sky130_fd_sc_hd__tapvpwrvgnd_1
XANTENNA__2892__B1 _3094_/C1 VGND VGND VPWR VPWR sky130_fd_sc_hd__diode_2
XFILLER_48_759 VPWR VGND VPWR VGND sky130_ef_sc_hd__decap_40_12
XTAP_TAPCELL_ROW_126_2196 VGND VPWR sky130_fd_sc_hd__tapvpwrvgnd_1
XTAP_TAPCELL_ROW_126_2185 VGND VPWR sky130_fd_sc_hd__tapvpwrvgnd_1
XFILLER_16_601 VPWR VGND VPWR VGND sky130_ef_sc_hd__decap_40_12
XANTENNA__3841__C1 _5200_/A VGND VGND VPWR VPWR sky130_fd_sc_hd__diode_2
XFILLER_16_645 VPWR VGND VPWR VGND sky130_ef_sc_hd__decap_40_12
XFILLER_71_773 VGND VGND VPWR VPWR sky130_fd_sc_hd__fill_8
XTAP_TAPCELL_ROW_26_684 VGND VPWR sky130_fd_sc_hd__tapvpwrvgnd_1
XTAP_TAPCELL_ROW_26_695 VGND VPWR sky130_fd_sc_hd__tapvpwrvgnd_1
XFILLER_8_811 VGND VGND VPWR VPWR sky130_fd_sc_hd__fill_1
XFILLER_117_709 VPWR VGND VPWR VGND sky130_ef_sc_hd__decap_40_12
XFILLER_125_753 VPWR VGND VPWR VGND sky130_ef_sc_hd__decap_40_12
XTAP_TAPCELL_ROW_55_1125 VGND VPWR sky130_fd_sc_hd__tapvpwrvgnd_1
XFILLER_125_797 VPWR VGND VPWR VGND sky130_ef_sc_hd__decap_40_12
XFILLER_98_637 VGND VGND VPWR VPWR sky130_fd_sc_hd__fill_4
X_3270_ _3801_/A _3270_/B VGND VGND VPWR VPWR _3270_/Y sky130_fd_sc_hd__nor2_1
XANTENNA__3124__A1 _5235_/A0 VGND VGND VPWR VPWR sky130_fd_sc_hd__diode_2
XFILLER_97_147 VGND VGND VPWR VPWR sky130_fd_sc_hd__fill_1
XANTENNA__4872__A1 _5241_/A1 VGND VGND VPWR VPWR sky130_fd_sc_hd__diode_2
XFILLER_78_394 VGND VGND VPWR VPWR sky130_fd_sc_hd__fill_1
XFILLER_16_3 VPWR VGND VPWR VGND sky130_ef_sc_hd__decap_40_12
XFILLER_39_737 VGND VGND VPWR VPWR sky130_fd_sc_hd__fill_1
XFILLER_66_589 VGND VGND VPWR VPWR sky130_fd_sc_hd__fill_4
XFILLER_81_537 VGND VGND VPWR VPWR sky130_fd_sc_hd__fill_4
XFILLER_47_770 VPWR VGND VPWR VGND sky130_ef_sc_hd__decap_40_12
XFILLER_19_461 VPWR VGND VPWR VGND sky130_ef_sc_hd__decap_40_12
X_5911_ clkload8/A _5911_/D VGND VGND VPWR VPWR _5911_/Q sky130_fd_sc_hd__dfxtp_1
XTAP_TAPCELL_ROW_66_1287 VGND VPWR sky130_fd_sc_hd__tapvpwrvgnd_1
X_5842_ _6404_/CLK _5842_/D VGND VGND VPWR VPWR _5842_/Q sky130_fd_sc_hd__dfxtp_1
XFILLER_61_250 VGND VGND VPWR VPWR sky130_fd_sc_hd__fill_1
XTAP_TAPCELL_ROW_45_982 VGND VPWR sky130_fd_sc_hd__tapvpwrvgnd_1
XTAP_TAPCELL_ROW_45_971 VGND VPWR sky130_fd_sc_hd__tapvpwrvgnd_1
XANTENNA__4388__A0 _4976_/A1 VGND VGND VPWR VPWR sky130_fd_sc_hd__diode_2
X_5773_ _6312_/CLK _5773_/D VGND VGND VPWR VPWR _5773_/Q sky130_fd_sc_hd__dfxtp_1
X_2985_ _2985_/A _2985_/B VGND VGND VPWR VPWR _2985_/X sky130_fd_sc_hd__or2_1
XFILLER_21_169 VGND VGND VPWR VPWR sky130_fd_sc_hd__fill_2
X_4724_ _5653_/Q _5671_/Q _4808_/S VGND VGND VPWR VPWR _4724_/X sky130_fd_sc_hd__mux2_1
XFILLER_135_517 VPWR VGND VPWR VGND sky130_ef_sc_hd__decap_40_12
X_4655_ _4794_/A _4655_/B VGND VGND VPWR VPWR _4655_/Y sky130_fd_sc_hd__nor2_1
Xhold811 _6228_/Q VGND VGND VPWR VPWR hold811/X sky130_fd_sc_hd__dlygate4sd3_1
X_3606_ _3606_/A _3606_/B VGND VGND VPWR VPWR _4955_/B sky130_fd_sc_hd__nand2_8
Xhold800 _4350_/X VGND VGND VPWR VPWR _5993_/D sky130_fd_sc_hd__dlygate4sd3_1
X_4586_ _4811_/A1 _4585_/X _2628_/A VGND VGND VPWR VPWR _4586_/Y sky130_fd_sc_hd__o21ai_1
XFILLER_116_753 VGND VGND VPWR VPWR sky130_fd_sc_hd__fill_2
Xhold822 _3299_/X VGND VGND VPWR VPWR _5417_/D sky130_fd_sc_hd__dlygate4sd3_1
X_3537_ hold637/X _5233_/A0 _3541_/S VGND VGND VPWR VPWR _3537_/X sky130_fd_sc_hd__mux2_1
X_6325_ _6342_/CLK _6325_/D VGND VGND VPWR VPWR _6325_/Q sky130_fd_sc_hd__dfxtp_1
Xhold855 _5676_/Q VGND VGND VPWR VPWR hold855/X sky130_fd_sc_hd__dlygate4sd3_1
Xhold844 _3388_/X VGND VGND VPWR VPWR _5447_/D sky130_fd_sc_hd__dlygate4sd3_1
Xhold833 _5892_/Q VGND VGND VPWR VPWR hold833/X sky130_fd_sc_hd__dlygate4sd3_1
Xhold888 _5527_/Q VGND VGND VPWR VPWR hold888/X sky130_fd_sc_hd__dlygate4sd3_1
XFILLER_103_425 VGND VGND VPWR VPWR sky130_fd_sc_hd__fill_1
Xhold866 _4315_/X VGND VGND VPWR VPWR _5963_/D sky130_fd_sc_hd__dlygate4sd3_1
Xhold877 _5387_/Q VGND VGND VPWR VPWR hold877/X sky130_fd_sc_hd__dlygate4sd3_1
X_3468_ _4445_/A _3468_/A1 _3477_/S VGND VGND VPWR VPWR _3468_/X sky130_fd_sc_hd__mux2_1
XANTENNA__3115__A1 _5238_/A1 VGND VGND VPWR VPWR sky130_fd_sc_hd__diode_2
Xhold899 _3184_/X VGND VGND VPWR VPWR _5347_/D sky130_fd_sc_hd__dlygate4sd3_1
X_6256_ _6261_/CLK _6256_/D VGND VGND VPWR VPWR _6256_/Q sky130_fd_sc_hd__dfxtp_1
Xhold2212 _5399_/Q VGND VGND VPWR VPWR hold2212/X sky130_fd_sc_hd__dlygate4sd3_1
Xhold2201 _5383_/Q VGND VGND VPWR VPWR _3226_/B sky130_fd_sc_hd__dlygate4sd3_1
XANTENNA_fanout198_X _3077_/S VGND VGND VPWR VPWR sky130_fd_sc_hd__diode_2
Xhold2245 _5252_/Q VGND VGND VPWR VPWR _3113_/C sky130_fd_sc_hd__dlygate4sd3_1
XFILLER_103_469 VGND VGND VPWR VPWR sky130_fd_sc_hd__fill_1
X_6187_ _6199_/CLK _6187_/D VGND VGND VPWR VPWR _6187_/Q sky130_fd_sc_hd__dfxtp_1
XFILLER_85_821 VPWR VGND VPWR VGND sky130_ef_sc_hd__decap_40_12
XFILLER_76_309 VGND VGND VPWR VPWR sky130_fd_sc_hd__fill_1
Xhold2234 _5815_/Q VGND VGND VPWR VPWR hold2234/X sky130_fd_sc_hd__dlygate4sd3_1
X_5207_ _3967_/B _3965_/A _5207_/S VGND VGND VPWR VPWR _5207_/X sky130_fd_sc_hd__mux2_1
Xhold1500 _6052_/Q VGND VGND VPWR VPWR _4415_/A1 sky130_fd_sc_hd__dlygate4sd3_1
X_3399_ _4190_/A2 _4982_/A1 _3401_/S VGND VGND VPWR VPWR _3399_/X sky130_fd_sc_hd__mux2_1
Xhold2223 _5340_/Q VGND VGND VPWR VPWR hold2223/X sky130_fd_sc_hd__dlygate4sd3_1
Xhold1544 _5228_/X VGND VGND VPWR VPWR _6425_/D sky130_fd_sc_hd__dlygate4sd3_1
Xhold1522 _5077_/X VGND VGND VPWR VPWR _6368_/D sky130_fd_sc_hd__dlygate4sd3_1
Xhold1533 _5421_/Q VGND VGND VPWR VPWR _3303_/A0 sky130_fd_sc_hd__dlygate4sd3_1
X_5138_ _5836_/Q _5835_/Q _5194_/S VGND VGND VPWR VPWR _5138_/X sky130_fd_sc_hd__mux2_1
Xhold2256 _5381_/Q VGND VGND VPWR VPWR _3553_/B sky130_fd_sc_hd__dlygate4sd3_1
XTAP_TAPCELL_ROW_4_357 VGND VPWR sky130_fd_sc_hd__tapvpwrvgnd_1
Xhold1511 _5786_/Q VGND VGND VPWR VPWR _3776_/A1 sky130_fd_sc_hd__dlygate4sd3_1
Xhold1577 _4824_/X VGND VGND VPWR VPWR _6178_/D sky130_fd_sc_hd__dlygate4sd3_1
Xhold1555 _6305_/Q VGND VGND VPWR VPWR _4972_/A1 sky130_fd_sc_hd__dlygate4sd3_1
XFILLER_29_269 VGND VGND VPWR VPWR sky130_fd_sc_hd__fill_1
Xhold1566 _5981_/Q VGND VGND VPWR VPWR _4335_/A1 sky130_fd_sc_hd__dlygate4sd3_1
X_5069_ _5225_/A _5069_/B VGND VGND VPWR VPWR _5081_/S sky130_fd_sc_hd__or2_4
XFILLER_72_515 VGND VGND VPWR VPWR sky130_fd_sc_hd__fill_1
Xhold1599 _5598_/Q VGND VGND VPWR VPWR _3559_/A1 sky130_fd_sc_hd__dlygate4sd3_1
XANTENNA__4615__B2 _4791_/B1 VGND VGND VPWR VPWR sky130_fd_sc_hd__diode_2
Xhold1588 _6283_/Q VGND VGND VPWR VPWR _4948_/A1 sky130_fd_sc_hd__dlygate4sd3_1
XANTENNA__2933__A _3020_/A VGND VGND VPWR VPWR sky130_fd_sc_hd__diode_2
XANTENNA__4624__S _4778_/S VGND VGND VPWR VPWR sky130_fd_sc_hd__diode_2
XFILLER_13_615 VGND VGND VPWR VPWR sky130_fd_sc_hd__fill_1
XFILLER_16_77 VGND VGND VPWR VPWR sky130_fd_sc_hd__fill_4
XANTENNA__5040__A1 _5040_/A1 VGND VGND VPWR VPWR sky130_fd_sc_hd__diode_2
XTAP_TAPCELL_ROW_23_643 VGND VPWR sky130_fd_sc_hd__tapvpwrvgnd_1
XFILLER_21_670 VGND VGND VPWR VPWR sky130_fd_sc_hd__fill_2
XFILLER_21_681 VPWR VGND VPWR VGND sky130_ef_sc_hd__decap_40_12
XFILLER_120_3 VPWR VGND VPWR VGND sky130_ef_sc_hd__decap_40_12
XTAP_TAPCELL_ROW_97_1748 VGND VPWR sky130_fd_sc_hd__tapvpwrvgnd_1
XTAP_TAPCELL_ROW_97_1759 VGND VPWR sky130_fd_sc_hd__tapvpwrvgnd_1
XFILLER_107_753 VPWR VGND VPWR VGND sky130_ef_sc_hd__decap_40_12
XFILLER_122_701 VPWR VGND VPWR VGND sky130_ef_sc_hd__decap_40_12
XFILLER_107_797 VPWR VGND VPWR VGND sky130_ef_sc_hd__decap_40_12
XANTENNA__3106__A1 _5075_/A0 VGND VGND VPWR VPWR sky130_fd_sc_hd__diode_2
XFILLER_106_285 VGND VGND VPWR VPWR sky130_fd_sc_hd__fill_4
XFILLER_79_147 VGND VGND VPWR VPWR sky130_fd_sc_hd__fill_2
XTAP_TAPCELL_ROW_128_2225 VGND VPWR sky130_fd_sc_hd__tapvpwrvgnd_1
XTAP_TAPCELL_ROW_128_2214 VGND VPWR sky130_fd_sc_hd__tapvpwrvgnd_1
XANTENNA__2667__X _4881_/A VGND VGND VPWR VPWR sky130_fd_sc_hd__diode_2
XFILLER_95_629 VPWR VGND VPWR VGND sky130_ef_sc_hd__decap_40_12
XFILLER_79_169 VPWR VGND VPWR VGND sky130_ef_sc_hd__decap_40_12
XANTENNA__3703__S _3707_/S VGND VGND VPWR VPWR sky130_fd_sc_hd__diode_2
XTAP_TAPCELL_ROW_50_1055 VGND VPWR sky130_fd_sc_hd__tapvpwrvgnd_1
XTAP_TAPCELL_ROW_50_1044 VGND VPWR sky130_fd_sc_hd__tapvpwrvgnd_1
XFILLER_0_585 VGND VGND VPWR VPWR sky130_fd_sc_hd__fill_2
XANTENNA__4067__C1 _4271_/S1 VGND VGND VPWR VPWR sky130_fd_sc_hd__diode_2
XFILLER_90_334 VGND VGND VPWR VPWR sky130_fd_sc_hd__fill_1
XANTENNA__4534__S _4535_/S VGND VGND VPWR VPWR sky130_fd_sc_hd__diode_2
XTAP_TAPCELL_ROW_106_1888 VGND VPWR sky130_fd_sc_hd__tapvpwrvgnd_1
XANTENNA__2843__A _3005_/A VGND VGND VPWR VPWR sky130_fd_sc_hd__diode_2
XFILLER_90_367 VGND VGND VPWR VPWR sky130_fd_sc_hd__fill_1
XFILLER_16_475 VGND VGND VPWR VPWR sky130_fd_sc_hd__fill_1
XFILLER_92_7 VPWR VGND VPWR VGND sky130_ef_sc_hd__decap_40_12
XTAP_TAPCELL_ROW_42_930 VGND VPWR sky130_fd_sc_hd__tapvpwrvgnd_1
X_2770_ _3029_/A _2770_/B VGND VGND VPWR VPWR _2770_/X sky130_fd_sc_hd__or2_1
XFILLER_12_681 VPWR VGND VPWR VGND sky130_ef_sc_hd__decap_40_12
XPHY_EDGE_ROW_130_Left_269 VGND VGND VPWR VPWR sky130_fd_sc_hd__decap_3
XFILLER_129_377 VGND VGND VPWR VPWR sky130_fd_sc_hd__fill_4
XFILLER_117_517 VPWR VGND VPWR VGND sky130_ef_sc_hd__decap_40_12
XANTENNA__2989__S _3077_/S VGND VGND VPWR VPWR sky130_fd_sc_hd__diode_2
XANTENNA__3593__A1 _3926_/A1 VGND VGND VPWR VPWR sky130_fd_sc_hd__diode_2
XFILLER_8_641 VGND VGND VPWR VPWR sky130_fd_sc_hd__fill_2
X_4440_ _6255_/Q _3366_/X _4445_/B _4899_/A0 _4439_/Y VGND VGND VPWR VPWR _4440_/X
+ sky130_fd_sc_hd__a221o_1
Xhold107 _5888_/Q VGND VGND VPWR VPWR hold107/X sky130_fd_sc_hd__dlygate4sd3_1
Xhold129 _5301_/Q VGND VGND VPWR VPWR hold129/X sky130_fd_sc_hd__dlygate4sd3_1
Xhold118 _5057_/X VGND VGND VPWR VPWR _6350_/D sky130_fd_sc_hd__dlygate4sd3_1
XFILLER_125_561 VPWR VGND VPWR VGND sky130_ef_sc_hd__decap_40_12
XFILLER_98_401 VGND VGND VPWR VPWR sky130_fd_sc_hd__fill_1
X_6110_ _6125_/CLK _6110_/D VGND VGND VPWR VPWR _6110_/Q sky130_fd_sc_hd__dfxtp_1
X_4371_ _4929_/A1 _4371_/A1 _4376_/S VGND VGND VPWR VPWR _6012_/D sky130_fd_sc_hd__mux2_1
X_3322_ _5335_/Q _3322_/B VGND VGND VPWR VPWR _3322_/X sky130_fd_sc_hd__xor2_1
X_3253_ _5389_/Q _4103_/A0 _3258_/S VGND VGND VPWR VPWR _3253_/X sky130_fd_sc_hd__mux2_1
X_6041_ clkload9/A _6041_/D VGND VGND VPWR VPWR _6041_/Q sky130_fd_sc_hd__dfxtp_1
X_3184_ hold898/X _5228_/A0 _3193_/S VGND VGND VPWR VPWR _3184_/X sky130_fd_sc_hd__mux2_1
XFILLER_67_821 VGND VGND VPWR VPWR sky130_fd_sc_hd__fill_2
XFILLER_82_813 VPWR VGND VPWR VGND sky130_ef_sc_hd__decap_40_12
XTAP_TAPCELL_ROW_1_316 VGND VPWR sky130_fd_sc_hd__tapvpwrvgnd_1
XTAP_TAPCELL_ROW_68_1327 VGND VPWR sky130_fd_sc_hd__tapvpwrvgnd_1
XTAP_TAPCELL_ROW_68_1316 VGND VPWR sky130_fd_sc_hd__tapvpwrvgnd_1
XFILLER_26_217 VGND VGND VPWR VPWR sky130_fd_sc_hd__fill_1
XFILLER_81_334 VGND VGND VPWR VPWR sky130_fd_sc_hd__fill_2
XANTENNA__4444__S _4457_/S VGND VGND VPWR VPWR sky130_fd_sc_hd__diode_2
XTAP_TAPCELL_ROW_81_1516 VGND VPWR sky130_fd_sc_hd__tapvpwrvgnd_1
XANTENNA__3281__B1 _3801_/A VGND VGND VPWR VPWR sky130_fd_sc_hd__diode_2
XFILLER_22_401 VPWR VGND VPWR VGND sky130_ef_sc_hd__decap_40_12
X_5825_ _6342_/CLK _5825_/D VGND VGND VPWR VPWR _5825_/Q sky130_fd_sc_hd__dfxtp_2
XANTENNA_fanout158_A _4205_/A VGND VGND VPWR VPWR sky130_fd_sc_hd__diode_2
XFILLER_22_445 VPWR VGND VPWR VGND sky130_ef_sc_hd__decap_40_12
X_2968_ _5303_/Q _5376_/Q _5364_/Q _6145_/Q _2984_/S _2985_/A VGND VGND VPWR VPWR
+ _2968_/X sky130_fd_sc_hd__mux4_1
X_5756_ _6398_/CLK _5756_/D VGND VGND VPWR VPWR _5756_/Q sky130_fd_sc_hd__dfxtp_1
XTAP_TAPCELL_ROW_20_602 VGND VPWR sky130_fd_sc_hd__tapvpwrvgnd_1
XFILLER_22_489 VPWR VGND VPWR VGND sky130_ef_sc_hd__decap_40_12
X_5687_ _5849_/CLK _5687_/D VGND VGND VPWR VPWR _5687_/Q sky130_fd_sc_hd__dfxtp_1
XANTENNA__2899__S _3062_/S VGND VGND VPWR VPWR sky130_fd_sc_hd__diode_2
XANTENNA__3584__A1 _4964_/A0 VGND VGND VPWR VPWR sky130_fd_sc_hd__diode_2
X_4707_ _4791_/A1 _4704_/X _4791_/B1 VGND VGND VPWR VPWR _4707_/X sky130_fd_sc_hd__o21a_1
XANTENNA__4781__B1 _2628_/A VGND VGND VPWR VPWR sky130_fd_sc_hd__diode_2
XFILLER_136_837 VGND VGND VPWR VPWR sky130_fd_sc_hd__fill_4
X_2899_ _6176_/Q _6200_/Q _3062_/S VGND VGND VPWR VPWR _2900_/B sky130_fd_sc_hd__mux2_1
XANTENNA_fanout113_X _5238_/A1 VGND VGND VPWR VPWR sky130_fd_sc_hd__diode_2
X_4638_ _4633_/X _4637_/X _4813_/S VGND VGND VPWR VPWR _4638_/Y sky130_fd_sc_hd__o21ai_1
XTAP_TAPCELL_ROW_79_1489 VGND VPWR sky130_fd_sc_hd__tapvpwrvgnd_1
XTAP_TAPCELL_ROW_79_1478 VGND VPWR sky130_fd_sc_hd__tapvpwrvgnd_1
Xhold630 _4287_/X VGND VGND VPWR VPWR _5938_/D sky130_fd_sc_hd__dlygate4sd3_1
Xhold641 _6070_/Q VGND VGND VPWR VPWR hold641/X sky130_fd_sc_hd__dlygate4sd3_1
XFILLER_104_701 VPWR VGND VPWR VGND sky130_ef_sc_hd__decap_40_12
X_4569_ _4794_/A _4569_/B VGND VGND VPWR VPWR _4569_/Y sky130_fd_sc_hd__nor2_1
Xhold663 _5964_/Q VGND VGND VPWR VPWR hold663/X sky130_fd_sc_hd__dlygate4sd3_1
XTAP_TAPCELL_ROW_9_438 VGND VPWR sky130_fd_sc_hd__tapvpwrvgnd_1
Xhold652 _4308_/X VGND VGND VPWR VPWR _5956_/D sky130_fd_sc_hd__dlygate4sd3_1
Xhold685 _6077_/Q VGND VGND VPWR VPWR hold685/X sky130_fd_sc_hd__dlygate4sd3_1
Xhold696 _6159_/Q VGND VGND VPWR VPWR hold696/X sky130_fd_sc_hd__dlygate4sd3_1
XTAP_TAPCELL_ROW_92_1678 VGND VPWR sky130_fd_sc_hd__tapvpwrvgnd_1
XFILLER_89_445 VGND VGND VPWR VPWR sky130_fd_sc_hd__fill_1
Xhold674 _4409_/X VGND VGND VPWR VPWR _6046_/D sky130_fd_sc_hd__dlygate4sd3_1
XFILLER_1_349 VGND VGND VPWR VPWR sky130_fd_sc_hd__fill_8
X_6308_ _6315_/CLK _6308_/D VGND VGND VPWR VPWR _6308_/Q sky130_fd_sc_hd__dfxtp_1
XFILLER_131_553 VGND VGND VPWR VPWR sky130_fd_sc_hd__fill_4
X_6239_ _6239_/CLK _6239_/D VGND VGND VPWR VPWR _6239_/Q sky130_fd_sc_hd__dfxtp_1
XANTENNA__4619__S _4773_/S VGND VGND VPWR VPWR sky130_fd_sc_hd__diode_2
XFILLER_49_309 VGND VGND VPWR VPWR sky130_fd_sc_hd__fill_2
Xhold2020 _5325_/Q VGND VGND VPWR VPWR _2703_/B sky130_fd_sc_hd__dlygate4sd3_1
XANTENNA__3523__S _3529_/S VGND VGND VPWR VPWR sky130_fd_sc_hd__diode_2
XFILLER_131_597 VPWR VGND VPWR VGND sky130_ef_sc_hd__decap_40_12
Xhold2031 _4441_/X VGND VGND VPWR VPWR _6061_/D sky130_fd_sc_hd__dlygate4sd3_1
XFILLER_103_299 VGND VGND VPWR VPWR sky130_fd_sc_hd__fill_4
XFILLER_94_27 VGND VGND VPWR VPWR sky130_fd_sc_hd__fill_1
Xhold2042 _6330_/Q VGND VGND VPWR VPWR _5006_/A sky130_fd_sc_hd__dlygate4sd3_1
Xhold2053 _5430_/Q VGND VGND VPWR VPWR _5215_/A0 sky130_fd_sc_hd__dlygate4sd3_1
Xhold1352 _5687_/Q VGND VGND VPWR VPWR _3662_/A1 sky130_fd_sc_hd__dlygate4sd3_1
Xhold1341 _3707_/X VGND VGND VPWR VPWR _5728_/D sky130_fd_sc_hd__dlygate4sd3_1
Xhold2064 _6398_/Q VGND VGND VPWR VPWR _3948_/B sky130_fd_sc_hd__dlygate4sd3_1
Xhold2097 _6395_/Q VGND VGND VPWR VPWR _5152_/A sky130_fd_sc_hd__dlygate4sd3_1
XFILLER_57_353 VPWR VGND VPWR VGND sky130_ef_sc_hd__decap_40_12
Xhold2086 _6411_/Q VGND VGND VPWR VPWR hold2086/X sky130_fd_sc_hd__dlygate4sd3_1
Xhold2075 _5214_/X VGND VGND VPWR VPWR _6416_/D sky130_fd_sc_hd__dlygate4sd3_1
Xhold1330 _6279_/Q VGND VGND VPWR VPWR _4943_/A1 sky130_fd_sc_hd__dlygate4sd3_1
Xhold1385 _5483_/Q VGND VGND VPWR VPWR _3432_/A0 sky130_fd_sc_hd__dlygate4sd3_1
Xhold1363 _6065_/Q VGND VGND VPWR VPWR _4453_/A1 sky130_fd_sc_hd__dlygate4sd3_1
Xhold1374 _5709_/Q VGND VGND VPWR VPWR _3687_/A1 sky130_fd_sc_hd__dlygate4sd3_1
XTAP_TAPCELL_ROW_28_713 VGND VPWR sky130_fd_sc_hd__tapvpwrvgnd_1
XTAP_TAPCELL_ROW_28_724 VGND VPWR sky130_fd_sc_hd__tapvpwrvgnd_1
Xhold1396 _5227_/X VGND VGND VPWR VPWR _6424_/D sky130_fd_sc_hd__dlygate4sd3_1
XTAP_TAPCELL_ROW_123_2144 VGND VPWR sky130_fd_sc_hd__tapvpwrvgnd_1
XANTENNA__4354__S _4356_/S VGND VGND VPWR VPWR sky130_fd_sc_hd__diode_2
XFILLER_26_751 VGND VGND VPWR VPWR sky130_fd_sc_hd__fill_4
XFILLER_9_405 VPWR VGND VPWR VGND sky130_ef_sc_hd__decap_40_12
XFILLER_13_445 VGND VGND VPWR VPWR sky130_fd_sc_hd__fill_2
XFILLER_40_253 VGND VGND VPWR VPWR sky130_fd_sc_hd__fill_2
XFILLER_9_449 VPWR VGND VPWR VGND sky130_ef_sc_hd__decap_40_12
XFILLER_127_837 VGND VGND VPWR VPWR sky130_fd_sc_hd__fill_2
XFILLER_114_509 VPWR VGND VPWR VGND sky130_ef_sc_hd__decap_40_12
XFILLER_107_561 VPWR VGND VPWR VGND sky130_ef_sc_hd__decap_40_12
XFILLER_4_143 VGND VGND VPWR VPWR sky130_fd_sc_hd__fill_4
XFILLER_122_531 VGND VGND VPWR VPWR sky130_fd_sc_hd__fill_1
XANTENNA__4529__S _4535_/S VGND VGND VPWR VPWR sky130_fd_sc_hd__diode_2
XFILLER_110_737 VPWR VGND VPWR VGND sky130_ef_sc_hd__decap_40_12
XANTENNA__3433__S _3437_/S VGND VGND VPWR VPWR sky130_fd_sc_hd__diode_2
XFILLER_68_83 VGND VGND VPWR VPWR sky130_fd_sc_hd__fill_1
XFILLER_49_821 VPWR VGND VPWR VGND sky130_ef_sc_hd__decap_40_12
XFILLER_0_371 VGND VGND VPWR VPWR sky130_fd_sc_hd__fill_1
XTAP_TAPCELL_ROW_108_1917 VGND VPWR sky130_fd_sc_hd__tapvpwrvgnd_1
XFILLER_76_695 VGND VGND VPWR VPWR sky130_fd_sc_hd__fill_4
XFILLER_64_835 VGND VGND VPWR VPWR sky130_fd_sc_hd__fill_1
XFILLER_64_813 VPWR VGND VPWR VGND sky130_ef_sc_hd__decap_40_12
XFILLER_63_334 VGND VGND VPWR VPWR sky130_fd_sc_hd__fill_2
XFILLER_91_665 VGND VGND VPWR VPWR sky130_fd_sc_hd__fill_4
XFILLER_84_93 VGND VGND VPWR VPWR sky130_fd_sc_hd__fill_1
X_3940_ _3941_/B _3940_/B VGND VGND VPWR VPWR _5137_/B sky130_fd_sc_hd__or2_1
XFILLER_16_261 VGND VGND VPWR VPWR sky130_fd_sc_hd__fill_1
XANTENNA_clkbuf_leaf_50_clk_A clkload3/A VGND VGND VPWR VPWR sky130_fd_sc_hd__diode_2
X_3871_ _4484_/A0 _3871_/A1 _3879_/S VGND VGND VPWR VPWR _5852_/D sky130_fd_sc_hd__mux2_1
XTAP_TAPCELL_ROW_63_1246 VGND VPWR sky130_fd_sc_hd__tapvpwrvgnd_1
XFILLER_32_754 VGND VGND VPWR VPWR sky130_fd_sc_hd__fill_2
X_2822_ _6437_/Q _6245_/Q _5405_/Q _5503_/Q _3077_/S _3020_/A VGND VGND VPWR VPWR
+ _2822_/X sky130_fd_sc_hd__mux4_1
X_5610_ _6097_/CLK _5610_/D VGND VGND VPWR VPWR _5610_/Q sky130_fd_sc_hd__dfxtp_1
X_5541_ _5565_/CLK _5541_/D VGND VGND VPWR VPWR _5541_/Q sky130_fd_sc_hd__dfxtp_1
X_2753_ _2753_/A0 _5237_/A0 _2753_/S VGND VGND VPWR VPWR _2753_/X sky130_fd_sc_hd__mux2_1
XANTENNA__3566__A1 _4484_/A0 VGND VGND VPWR VPWR sky130_fd_sc_hd__diode_2
XFILLER_118_837 VGND VGND VPWR VPWR sky130_fd_sc_hd__fill_4
XANTENNA_clkbuf_leaf_65_clk_A clkload5/A VGND VGND VPWR VPWR sky130_fd_sc_hd__diode_2
X_2684_ _4548_/C _4868_/A _5222_/A VGND VGND VPWR VPWR _2685_/B sky130_fd_sc_hd__a21o_1
X_5472_ _6382_/CLK _5472_/D VGND VGND VPWR VPWR _5472_/Q sky130_fd_sc_hd__dfxtp_1
XFILLER_99_721 VGND VGND VPWR VPWR sky130_fd_sc_hd__fill_4
X_4423_ input5/X input4/X VGND VGND VPWR VPWR _4451_/B sky130_fd_sc_hd__or2_2
XFILLER_125_391 VGND VGND VPWR VPWR sky130_fd_sc_hd__fill_1
XFILLER_125_380 VGND VGND VPWR VPWR sky130_fd_sc_hd__fill_1
X_4354_ hold817/X _5045_/A1 _4356_/S VGND VGND VPWR VPWR _4354_/X sky130_fd_sc_hd__mux2_1
XFILLER_113_553 VGND VGND VPWR VPWR sky130_fd_sc_hd__fill_4
XFILLER_99_765 VPWR VGND VPWR VGND sky130_ef_sc_hd__decap_40_12
XFILLER_98_264 VGND VGND VPWR VPWR sky130_fd_sc_hd__fill_1
XFILLER_98_253 VGND VGND VPWR VPWR sky130_fd_sc_hd__fill_1
X_3305_ _3305_/A0 _5234_/A0 _3308_/S VGND VGND VPWR VPWR _5423_/D sky130_fd_sc_hd__mux2_1
XFILLER_113_597 VPWR VGND VPWR VGND sky130_ef_sc_hd__decap_40_12
XFILLER_98_275 VGND VGND VPWR VPWR sky130_fd_sc_hd__fill_8
X_6024_ _6421_/CLK _6024_/D VGND VGND VPWR VPWR _6024_/Q sky130_fd_sc_hd__dfxtp_1
X_4285_ _4935_/A _4975_/B VGND VGND VPWR VPWR _4294_/S sky130_fd_sc_hd__nor2_4
XFILLER_104_15 VPWR VGND VPWR VGND sky130_ef_sc_hd__decap_40_12
X_3236_ _3236_/A _3606_/B VGND VGND VPWR VPWR _4503_/A sky130_fd_sc_hd__nand2_8
XFILLER_104_37 VGND VGND VPWR VPWR sky130_fd_sc_hd__fill_2
X_3167_ _4178_/A _4257_/S _3167_/C VGND VGND VPWR VPWR _3172_/C sky130_fd_sc_hd__and3_1
X_3098_ _5270_/Q _3083_/X _3097_/Y _2925_/S VGND VGND VPWR VPWR _3098_/X sky130_fd_sc_hd__o211a_1
XFILLER_82_643 VGND VGND VPWR VPWR sky130_fd_sc_hd__fill_1
XFILLER_54_323 VGND VGND VPWR VPWR sky130_fd_sc_hd__fill_1
XFILLER_39_397 VGND VGND VPWR VPWR sky130_fd_sc_hd__fill_1
XFILLER_81_142 VGND VGND VPWR VPWR sky130_fd_sc_hd__fill_1
XFILLER_80_29 VPWR VGND VPWR VGND sky130_ef_sc_hd__decap_40_12
XANTENNA_clkbuf_leaf_18_clk_A clkload3/A VGND VGND VPWR VPWR sky130_fd_sc_hd__diode_2
XANTENNA__4902__S _4906_/S VGND VGND VPWR VPWR sky130_fd_sc_hd__diode_2
Xfanout57 _5145_/A VGND VGND VPWR VPWR _5175_/S sky130_fd_sc_hd__buf_4
X_5808_ _6060_/CLK _5808_/D VGND VGND VPWR VPWR _5808_/Q sky130_fd_sc_hd__dfxtp_1
XFILLER_50_584 VGND VGND VPWR VPWR sky130_fd_sc_hd__fill_4
Xfanout79 hold2074/X VGND VGND VPWR VPWR _5214_/A1 sky130_fd_sc_hd__buf_4
Xfanout68 _2636_/Y VGND VGND VPWR VPWR _4252_/A1 sky130_fd_sc_hd__buf_4
XANTENNA__4203__C1 _5343_/Q VGND VGND VPWR VPWR sky130_fd_sc_hd__diode_2
XFILLER_136_601 VPWR VGND VPWR VGND sky130_ef_sc_hd__decap_40_12
X_5739_ _6307_/CLK _5739_/D VGND VGND VPWR VPWR _5739_/Q sky130_fd_sc_hd__dfxtp_1
XTAP_TAPCELL_ROW_33_793 VGND VPWR sky130_fd_sc_hd__tapvpwrvgnd_1
XFILLER_135_111 VGND VGND VPWR VPWR sky130_fd_sc_hd__fill_1
XANTENNA__3518__S _3529_/S VGND VGND VPWR VPWR sky130_fd_sc_hd__diode_2
XFILLER_109_837 VGND VGND VPWR VPWR sky130_fd_sc_hd__fill_2
XFILLER_6_419 VGND VGND VPWR VPWR sky130_fd_sc_hd__fill_1
XFILLER_136_645 VPWR VGND VPWR VGND sky130_ef_sc_hd__decap_40_12
XTAP_TAPCELL_ROW_94_1707 VGND VPWR sky130_fd_sc_hd__tapvpwrvgnd_1
XANTENNA__2951__A1_N _3096_/A1 VGND VGND VPWR VPWR sky130_fd_sc_hd__diode_2
XFILLER_104_531 VGND VGND VPWR VPWR sky130_fd_sc_hd__fill_1
Xhold471 _5617_/Q VGND VGND VPWR VPWR hold471/X sky130_fd_sc_hd__dlygate4sd3_1
XFILLER_2_625 VPWR VGND VPWR VGND sky130_ef_sc_hd__decap_40_12
Xhold460 _3694_/X VGND VGND VPWR VPWR _5715_/D sky130_fd_sc_hd__dlygate4sd3_1
XANTENNA_fanout90_A _5208_/A1 VGND VGND VPWR VPWR sky130_fd_sc_hd__diode_2
XANTENNA__2658__A _3085_/A VGND VGND VPWR VPWR sky130_fd_sc_hd__diode_2
Xhold493 _6150_/Q VGND VGND VPWR VPWR hold493/X sky130_fd_sc_hd__dlygate4sd3_1
XANTENNA__4349__S _4356_/S VGND VGND VPWR VPWR sky130_fd_sc_hd__diode_2
XFILLER_2_669 VPWR VGND VPWR VGND sky130_ef_sc_hd__decap_40_12
Xhold482 _4519_/X VGND VGND VPWR VPWR _6122_/D sky130_fd_sc_hd__dlygate4sd3_1
XFILLER_77_459 VGND VGND VPWR VPWR sky130_fd_sc_hd__fill_1
Xhold1160 _6426_/Q VGND VGND VPWR VPWR _5229_/A1 sky130_fd_sc_hd__dlygate4sd3_1
XANTENNA__3493__A0 _5239_/A1 VGND VGND VPWR VPWR sky130_fd_sc_hd__diode_2
XFILLER_100_781 VPWR VGND VPWR VGND sky130_ef_sc_hd__decap_40_12
XFILLER_46_813 VPWR VGND VPWR VGND sky130_ef_sc_hd__decap_40_12
Xhold1193 _3519_/X VGND VGND VPWR VPWR _5562_/D sky130_fd_sc_hd__dlygate4sd3_1
Xhold1182 _3534_/X VGND VGND VPWR VPWR _5577_/D sky130_fd_sc_hd__dlygate4sd3_1
XFILLER_45_334 VGND VGND VPWR VPWR sky130_fd_sc_hd__fill_2
Xhold1171 _6276_/Q VGND VGND VPWR VPWR _4940_/A1 sky130_fd_sc_hd__dlygate4sd3_1
XTAP_TAPCELL_ROW_103_1847 VGND VPWR sky130_fd_sc_hd__tapvpwrvgnd_1
XFILLER_54_85 VGND VGND VPWR VPWR sky130_fd_sc_hd__fill_4
XANTENNA__3796__A1 _5215_/A1 VGND VGND VPWR VPWR sky130_fd_sc_hd__diode_2
XTAP_TAPCELL_ROW_136_2346 VGND VPWR sky130_fd_sc_hd__tapvpwrvgnd_1
XTAP_TAPCELL_ROW_136_2335 VGND VPWR sky130_fd_sc_hd__tapvpwrvgnd_1
XANTENNA__3548__A1 _4488_/A0 VGND VGND VPWR VPWR sky130_fd_sc_hd__diode_2
XANTENNA__3428__S _3437_/S VGND VGND VPWR VPWR sky130_fd_sc_hd__diode_2
XTAP_TAPCELL_ROW_11_465 VGND VPWR sky130_fd_sc_hd__tapvpwrvgnd_1
Xclkload16 _6316_/CLK VGND VGND VPWR VPWR clkload16/Y sky130_fd_sc_hd__inv_6
Xclkload27 _6339_/CLK VGND VGND VPWR VPWR clkload27/Y sky130_fd_sc_hd__inv_6
Xclkload38 _6422_/CLK VGND VGND VPWR VPWR clkload38/Y sky130_fd_sc_hd__clkinv_8
Xclkload49 _6125_/CLK VGND VGND VPWR VPWR clkload49/Y sky130_fd_sc_hd__clkinv_2
XFILLER_107_391 VGND VGND VPWR VPWR sky130_fd_sc_hd__fill_1
XFILLER_5_485 VPWR VGND VPWR VGND sky130_ef_sc_hd__decap_40_12
XFILLER_96_713 VPWR VGND VPWR VGND sky130_ef_sc_hd__decap_40_12
XANTENNA__3720__A1 _4976_/A1 VGND VGND VPWR VPWR sky130_fd_sc_hd__diode_2
XFILLER_122_361 VGND VGND VPWR VPWR sky130_fd_sc_hd__fill_1
XFILLER_110_501 VPWR VGND VPWR VGND sky130_ef_sc_hd__decap_40_12
XFILLER_110_545 VPWR VGND VPWR VGND sky130_ef_sc_hd__decap_40_12
XFILLER_96_757 VPWR VGND VPWR VGND sky130_ef_sc_hd__decap_40_12
XFILLER_68_448 VGND VGND VPWR VPWR sky130_fd_sc_hd__fill_1
X_4070_ _4212_/A _4070_/B VGND VGND VPWR VPWR _4070_/Y sky130_fd_sc_hd__nor2_1
X_3021_ _5522_/Q _5534_/Q _3077_/S VGND VGND VPWR VPWR _3021_/X sky130_fd_sc_hd__mux2_1
XFILLER_110_589 VPWR VGND VPWR VGND sky130_ef_sc_hd__decap_40_12
XFILLER_49_673 VGND VGND VPWR VPWR sky130_fd_sc_hd__fill_1
XFILLER_64_643 VGND VGND VPWR VPWR sky130_fd_sc_hd__fill_1
XFILLER_52_805 VGND VGND VPWR VPWR sky130_fd_sc_hd__fill_4
XFILLER_51_337 VGND VGND VPWR VPWR sky130_fd_sc_hd__fill_8
XTAP_TAPCELL_ROW_19_587 VGND VPWR sky130_fd_sc_hd__tapvpwrvgnd_1
X_4972_ _4982_/A1 _4972_/A1 _4974_/S VGND VGND VPWR VPWR _6305_/D sky130_fd_sc_hd__mux2_1
X_3923_ hold321/X _4517_/A1 _3928_/S VGND VGND VPWR VPWR _3923_/X sky130_fd_sc_hd__mux2_1
XFILLER_32_551 VGND VGND VPWR VPWR sky130_fd_sc_hd__fill_1
XANTENNA__3787__A1 _4964_/A0 VGND VGND VPWR VPWR sky130_fd_sc_hd__diode_2
X_3854_ _2665_/Y _3821_/X _3854_/B1 VGND VGND VPWR VPWR _3854_/Y sky130_fd_sc_hd__a21oi_1
XFILLER_20_713 VPWR VGND VPWR VGND sky130_ef_sc_hd__decap_40_12
XANTENNA__3539__A1 _5235_/A0 VGND VGND VPWR VPWR sky130_fd_sc_hd__diode_2
X_2805_ _6151_/Q _6220_/Q _3091_/S VGND VGND VPWR VPWR _2805_/X sky130_fd_sc_hd__mux2_1
XFILLER_20_757 VPWR VGND VPWR VGND sky130_ef_sc_hd__decap_40_12
XFILLER_118_601 VPWR VGND VPWR VGND sky130_ef_sc_hd__decap_40_12
X_3785_ hold960/X _5214_/A1 _3787_/S VGND VGND VPWR VPWR _3785_/X sky130_fd_sc_hd__mux2_1
XTAP_TAPCELL_ROW_30_752 VGND VPWR sky130_fd_sc_hd__tapvpwrvgnd_1
XFILLER_118_645 VPWR VGND VPWR VGND sky130_ef_sc_hd__decap_40_12
X_5524_ _6242_/CLK _5524_/D VGND VGND VPWR VPWR _5524_/Q sky130_fd_sc_hd__dfxtp_1
X_2736_ _5222_/A _2736_/B VGND VGND VPWR VPWR _2736_/Y sky130_fd_sc_hd__nor2_1
XFILLER_133_615 VGND VGND VPWR VPWR sky130_fd_sc_hd__fill_1
X_2667_ _3207_/A _2667_/B _3207_/C VGND VGND VPWR VPWR _4881_/A sky130_fd_sc_hd__or3_4
XTAP_TAPCELL_ROW_76_1437 VGND VPWR sky130_fd_sc_hd__tapvpwrvgnd_1
X_5455_ clkload7/A _5455_/D VGND VGND VPWR VPWR _5455_/Q sky130_fd_sc_hd__dfxtp_1
X_4406_ _5047_/A1 _4406_/A1 _4406_/S VGND VGND VPWR VPWR _4406_/X sky130_fd_sc_hd__mux2_1
XFILLER_99_573 VPWR VGND VPWR VGND sky130_ef_sc_hd__decap_40_12
Xfanout203 _2682_/A VGND VGND VPWR VPWR _5176_/A sky130_fd_sc_hd__buf_4
X_5386_ _6418_/CLK _5386_/D VGND VGND VPWR VPWR _5386_/Q sky130_fd_sc_hd__dfxtp_1
XANTENNA__3711__A1 _4978_/A1 VGND VGND VPWR VPWR sky130_fd_sc_hd__diode_2
X_4337_ hold542/X _5051_/A1 _4345_/S VGND VGND VPWR VPWR _4337_/X sky130_fd_sc_hd__mux2_1
XFILLER_115_47 VGND VGND VPWR VPWR sky130_fd_sc_hd__fill_1
XANTENNA__3066__A1_N _3094_/C1 VGND VGND VPWR VPWR sky130_fd_sc_hd__diode_2
X_4268_ _6008_/Q _5999_/Q _4270_/S VGND VGND VPWR VPWR _4268_/X sky130_fd_sc_hd__mux2_1
XANTENNA__3475__A0 _5814_/Q VGND VGND VPWR VPWR sky130_fd_sc_hd__diode_2
X_3219_ _5080_/A0 hold755/X _3220_/S VGND VGND VPWR VPWR _3219_/X sky130_fd_sc_hd__mux2_1
XANTENNA_fanout180_X _3027_/A VGND VGND VPWR VPWR sky130_fd_sc_hd__diode_2
X_6007_ _6347_/CLK _6007_/D VGND VGND VPWR VPWR _6007_/Q sky130_fd_sc_hd__dfxtp_1
XFILLER_28_813 VPWR VGND VPWR VGND sky130_ef_sc_hd__decap_40_12
X_4199_ _4252_/A1 _4198_/X _3172_/B VGND VGND VPWR VPWR _4199_/Y sky130_fd_sc_hd__o21ai_1
XFILLER_131_57 VGND VGND VPWR VPWR sky130_fd_sc_hd__fill_2
XTAP_TAPCELL_ROW_120_2103 VGND VPWR sky130_fd_sc_hd__tapvpwrvgnd_1
XFILLER_82_462 VGND VGND VPWR VPWR sky130_fd_sc_hd__fill_2
XTAP_TAPCELL_ROW_38_863 VGND VPWR sky130_fd_sc_hd__tapvpwrvgnd_1
XTAP_TAPCELL_ROW_38_874 VGND VPWR sky130_fd_sc_hd__tapvpwrvgnd_1
XFILLER_91_28 VGND VGND VPWR VPWR sky130_fd_sc_hd__fill_2
XTAP_TAPCELL_ROW_87_1599 VGND VPWR sky130_fd_sc_hd__tapvpwrvgnd_1
XFILLER_54_197 VGND VGND VPWR VPWR sky130_fd_sc_hd__fill_2
XFILLER_54_186 VGND VGND VPWR VPWR sky130_fd_sc_hd__fill_1
XFILLER_15_529 VPWR VGND VPWR VGND sky130_ef_sc_hd__decap_40_12
XFILLER_24_33 VGND VGND VPWR VPWR sky130_fd_sc_hd__fill_1
XFILLER_24_99 VGND VGND VPWR VPWR sky130_fd_sc_hd__fill_2
XTAP_TAPCELL_ROW_118_2076 VGND VPWR sky130_fd_sc_hd__tapvpwrvgnd_1
XTAP_TAPCELL_ROW_118_2065 VGND VPWR sky130_fd_sc_hd__tapvpwrvgnd_1
XFILLER_40_87 VGND VGND VPWR VPWR sky130_fd_sc_hd__fill_1
XTAP_TAPCELL_ROW_131_2265 VGND VPWR sky130_fd_sc_hd__tapvpwrvgnd_1
XFILLER_124_637 VGND VGND VPWR VPWR sky130_fd_sc_hd__fill_4
XFILLER_104_350 VGND VGND VPWR VPWR sky130_fd_sc_hd__fill_1
XANTENNA_fanout93_X _4964_/A0 VGND VGND VPWR VPWR sky130_fd_sc_hd__diode_2
XFILLER_2_433 VPWR VGND VPWR VGND sky130_ef_sc_hd__decap_40_12
XFILLER_132_681 VPWR VGND VPWR VGND sky130_ef_sc_hd__decap_40_12
Xhold290 _3614_/X VGND VGND VPWR VPWR _5645_/D sky130_fd_sc_hd__dlygate4sd3_1
XFILLER_77_212 VGND VGND VPWR VPWR sky130_fd_sc_hd__fill_2
XANTENNA__4079__S _4237_/S VGND VGND VPWR VPWR sky130_fd_sc_hd__diode_2
XFILLER_2_477 VPWR VGND VPWR VGND sky130_ef_sc_hd__decap_40_12
XANTENNA__3466__A0 _5238_/A1 VGND VGND VPWR VPWR sky130_fd_sc_hd__diode_2
XFILLER_93_727 VGND VGND VPWR VPWR sky130_fd_sc_hd__fill_1
XFILLER_92_248 VGND VGND VPWR VPWR sky130_fd_sc_hd__fill_4
XFILLER_46_643 VGND VGND VPWR VPWR sky130_fd_sc_hd__fill_1
XTAP_TAPCELL_ROW_47_1005 VGND VPWR sky130_fd_sc_hd__tapvpwrvgnd_1
XFILLER_34_805 VGND VGND VPWR VPWR sky130_fd_sc_hd__fill_4
XANTENNA__3218__A0 _5235_/A0 VGND VGND VPWR VPWR sky130_fd_sc_hd__diode_2
XFILLER_18_389 VPWR VGND VPWR VGND sky130_ef_sc_hd__decap_40_12
XANTENNA__4966__A0 _4976_/A1 VGND VGND VPWR VPWR sky130_fd_sc_hd__diode_2
XTAP_TAPCELL_ROW_16_535 VGND VPWR sky130_fd_sc_hd__tapvpwrvgnd_1
XTAP_TAPCELL_ROW_16_546 VGND VPWR sky130_fd_sc_hd__tapvpwrvgnd_1
XFILLER_121_90 VGND VGND VPWR VPWR sky130_fd_sc_hd__fill_1
XANTENNA__4542__S _4547_/S VGND VGND VPWR VPWR sky130_fd_sc_hd__diode_2
XFILLER_81_61 VGND VGND VPWR VPWR sky130_fd_sc_hd__fill_2
XTAP_TAPCELL_ROW_60_1205 VGND VPWR sky130_fd_sc_hd__tapvpwrvgnd_1
XANTENNA__4430__A2 _4427_/B VGND VGND VPWR VPWR sky130_fd_sc_hd__diode_2
Xclkload105 _5571_/CLK VGND VGND VPWR VPWR clkload105/X sky130_fd_sc_hd__clkbuf_4
X_3570_ hold590/X _4488_/A0 _3574_/S VGND VGND VPWR VPWR _3570_/X sky130_fd_sc_hd__mux2_1
XANTENNA__4194__A1 _4252_/A1 VGND VGND VPWR VPWR sky130_fd_sc_hd__diode_2
XFILLER_127_475 VPWR VGND VPWR VGND sky130_ef_sc_hd__decap_40_12
XFILLER_115_615 VGND VGND VPWR VPWR sky130_fd_sc_hd__fill_1
X_5240_ hold276/X _4445_/A _5241_/S VGND VGND VPWR VPWR _5240_/X sky130_fd_sc_hd__mux2_1
XTAP_TAPCELL_ROW_58_1167 VGND VPWR sky130_fd_sc_hd__tapvpwrvgnd_1
XFILLER_102_309 VGND VGND VPWR VPWR sky130_fd_sc_hd__fill_2
XFILLER_46_3 VGND VGND VPWR VPWR sky130_fd_sc_hd__fill_2
XFILLER_111_821 VPWR VGND VPWR VGND sky130_ef_sc_hd__decap_40_12
X_5171_ _3948_/B _5175_/S _5170_/Y _5176_/A VGND VGND VPWR VPWR _5171_/X sky130_fd_sc_hd__o211a_1
XFILLER_69_724 VGND VGND VPWR VPWR sky130_fd_sc_hd__fill_4
XPHY_EDGE_ROW_18_Right_18 VGND VGND VPWR VPWR sky130_fd_sc_hd__decap_3
XTAP_TAPCELL_ROW_71_1367 VGND VPWR sky130_fd_sc_hd__tapvpwrvgnd_1
Xhold1918 _5087_/X VGND VGND VPWR VPWR _6375_/D sky130_fd_sc_hd__dlygate4sd3_1
Xhold1907 _2711_/X VGND VGND VPWR VPWR _5259_/D sky130_fd_sc_hd__dlygate4sd3_1
X_4122_ hold739/X _4310_/A0 _4262_/S VGND VGND VPWR VPWR _4122_/X sky130_fd_sc_hd__mux2_1
XFILLER_96_587 VGND VGND VPWR VPWR sky130_fd_sc_hd__fill_1
Xhold1929 _5720_/Q VGND VGND VPWR VPWR _4562_/A3 sky130_fd_sc_hd__dlygate4sd3_1
X_4053_ _4149_/A _4048_/X _4050_/X _4052_/X VGND VGND VPWR VPWR _4053_/X sky130_fd_sc_hd__a22o_1
XANTENNA__4717__S _4803_/S VGND VGND VPWR VPWR sky130_fd_sc_hd__diode_2
Xinput3 rst VGND VGND VPWR VPWR input3/X sky130_fd_sc_hd__buf_1
X_3004_ _6239_/Q _6215_/Q _3062_/S VGND VGND VPWR VPWR _3005_/B sky130_fd_sc_hd__mux2_1
XANTENNA__3209__A0 _5821_/Q VGND VGND VPWR VPWR sky130_fd_sc_hd__diode_2
XFILLER_92_793 VPWR VGND VPWR VGND sky130_ef_sc_hd__decap_40_12
XFILLER_91_270 VGND VGND VPWR VPWR sky130_fd_sc_hd__fill_4
XTAP_TAPCELL_ROW_35_822 VGND VPWR sky130_fd_sc_hd__tapvpwrvgnd_1
XFILLER_101_49 VGND VGND VPWR VPWR sky130_fd_sc_hd__fill_4
X_4955_ _4955_/A _4955_/B VGND VGND VPWR VPWR _4964_/S sky130_fd_sc_hd__or2_4
XANTENNA__4957__A0 _5209_/A1 VGND VGND VPWR VPWR sky130_fd_sc_hd__diode_2
XPHY_EDGE_ROW_27_Right_27 VGND VGND VPWR VPWR sky130_fd_sc_hd__decap_3
XFILLER_36_197 VGND VGND VPWR VPWR sky130_fd_sc_hd__fill_1
XANTENNA__2761__A _3050_/A VGND VGND VPWR VPWR sky130_fd_sc_hd__diode_2
X_3906_ hold580/X _5214_/A1 _3908_/S VGND VGND VPWR VPWR _3906_/X sky130_fd_sc_hd__mux2_1
X_4886_ hold716/X _4886_/A1 _4893_/S VGND VGND VPWR VPWR _4886_/X sky130_fd_sc_hd__mux2_1
XFILLER_138_729 VGND VGND VPWR VPWR sky130_fd_sc_hd__fill_8
X_3837_ _3837_/A _4922_/C VGND VGND VPWR VPWR _3852_/B sky130_fd_sc_hd__nor2_2
X_3768_ _4976_/A1 _3768_/A1 _3776_/S VGND VGND VPWR VPWR _3768_/X sky130_fd_sc_hd__mux2_1
XFILLER_20_587 VGND VGND VPWR VPWR sky130_fd_sc_hd__fill_1
XANTENNA__4185__A1 _4252_/A1 VGND VGND VPWR VPWR sky130_fd_sc_hd__diode_2
X_5507_ _6252_/CLK _5507_/D VGND VGND VPWR VPWR _5507_/Q sky130_fd_sc_hd__dfxtp_1
XFILLER_118_475 VGND VGND VPWR VPWR sky130_fd_sc_hd__fill_1
XFILLER_118_464 VGND VGND VPWR VPWR sky130_fd_sc_hd__fill_1
X_2719_ _2721_/A _2719_/A2 _2682_/A VGND VGND VPWR VPWR _5265_/D sky130_fd_sc_hd__o21a_1
XFILLER_106_637 VGND VGND VPWR VPWR sky130_fd_sc_hd__fill_4
X_3699_ _5208_/A1 _4562_/A3 _3707_/S VGND VGND VPWR VPWR _3699_/X sky130_fd_sc_hd__mux2_1
XFILLER_133_445 VGND VGND VPWR VPWR sky130_fd_sc_hd__fill_2
X_5438_ _6380_/CLK _5438_/D VGND VGND VPWR VPWR _5438_/Q sky130_fd_sc_hd__dfxtp_1
XPHY_EDGE_ROW_36_Right_36 VGND VGND VPWR VPWR sky130_fd_sc_hd__decap_3
X_5369_ _6148_/CLK _5369_/D VGND VGND VPWR VPWR _5369_/Q sky130_fd_sc_hd__dfxtp_1
XFILLER_121_629 VPWR VGND VPWR VGND sky130_ef_sc_hd__decap_40_12
XFILLER_114_681 VPWR VGND VPWR VGND sky130_ef_sc_hd__decap_40_12
XFILLER_120_139 VGND VGND VPWR VPWR sky130_fd_sc_hd__fill_1
XFILLER_101_331 VGND VGND VPWR VPWR sky130_fd_sc_hd__fill_2
XTAP_TAPCELL_ROW_89_1639 VGND VPWR sky130_fd_sc_hd__tapvpwrvgnd_1
XTAP_TAPCELL_ROW_89_1628 VGND VPWR sky130_fd_sc_hd__tapvpwrvgnd_1
XFILLER_47_407 VGND VGND VPWR VPWR sky130_fd_sc_hd__fill_8
XANTENNA__3531__S _3541_/S VGND VGND VPWR VPWR sky130_fd_sc_hd__diode_2
XFILLER_28_643 VGND VGND VPWR VPWR sky130_fd_sc_hd__fill_1
XANTENNA__4645__C1 _3278_/A VGND VGND VPWR VPWR sky130_fd_sc_hd__diode_2
XFILLER_90_708 VGND VGND VPWR VPWR sky130_fd_sc_hd__fill_1
XFILLER_16_805 VGND VGND VPWR VPWR sky130_fd_sc_hd__fill_4
XANTENNA__2671__A1 _4901_/A0 VGND VGND VPWR VPWR sky130_fd_sc_hd__diode_2
XPHY_EDGE_ROW_45_Right_45 VGND VGND VPWR VPWR sky130_fd_sc_hd__decap_3
XANTENNA__4099__S1 _4212_/A VGND VGND VPWR VPWR sky130_fd_sc_hd__diode_2
XANTENNA__4948__A0 _4978_/A1 VGND VGND VPWR VPWR sky130_fd_sc_hd__diode_2
XFILLER_15_337 VGND VGND VPWR VPWR sky130_fd_sc_hd__fill_4
XTAP_TAPCELL_ROW_100_1806 VGND VPWR sky130_fd_sc_hd__tapvpwrvgnd_1
XFILLER_30_307 VGND VGND VPWR VPWR sky130_fd_sc_hd__fill_1
XFILLER_129_729 VPWR VGND VPWR VGND sky130_ef_sc_hd__decap_40_12
XFILLER_7_503 VGND VGND VPWR VPWR sky130_fd_sc_hd__fill_1
XFILLER_109_442 VGND VGND VPWR VPWR sky130_fd_sc_hd__fill_4
XANTENNA__4271__S1 _4271_/S1 VGND VGND VPWR VPWR sky130_fd_sc_hd__diode_2
XANTENNA__3923__A1 _4517_/A1 VGND VGND VPWR VPWR sky130_fd_sc_hd__diode_2
XFILLER_136_294 VGND VGND VPWR VPWR sky130_fd_sc_hd__fill_1
XANTENNA__3706__S _3707_/S VGND VGND VPWR VPWR sky130_fd_sc_hd__diode_2
XPHY_EDGE_ROW_54_Right_54 VGND VGND VPWR VPWR sky130_fd_sc_hd__decap_3
XFILLER_124_456 VGND VGND VPWR VPWR sky130_fd_sc_hd__fill_2
XFILLER_3_753 VPWR VGND VPWR VGND sky130_ef_sc_hd__decap_40_12
XFILLER_111_117 VGND VGND VPWR VPWR sky130_fd_sc_hd__fill_1
XFILLER_3_797 VPWR VGND VPWR VGND sky130_ef_sc_hd__decap_40_12
XANTENNA__3687__A0 _4521_/A1 VGND VGND VPWR VPWR sky130_fd_sc_hd__diode_2
XTAP_TAPCELL_ROW_111_1968 VGND VPWR sky130_fd_sc_hd__tapvpwrvgnd_1
XFILLER_111_139 VGND VGND VPWR VPWR sky130_fd_sc_hd__fill_1
XFILLER_78_554 VGND VGND VPWR VPWR sky130_fd_sc_hd__fill_2
XTAP_TAPCELL_ROW_53_1097 VGND VPWR sky130_fd_sc_hd__tapvpwrvgnd_1
XFILLER_38_407 VGND VGND VPWR VPWR sky130_fd_sc_hd__fill_1
XANTENNA__4537__S _4547_/S VGND VGND VPWR VPWR sky130_fd_sc_hd__diode_2
XANTENNA__3441__S _3450_/S VGND VGND VPWR VPWR sky130_fd_sc_hd__diode_2
XANTENNA__5222__A _5222_/A VGND VGND VPWR VPWR sky130_fd_sc_hd__diode_2
XFILLER_81_708 VGND VGND VPWR VPWR sky130_fd_sc_hd__fill_1
XPHY_EDGE_ROW_63_Right_63 VGND VGND VPWR VPWR sky130_fd_sc_hd__decap_3
XANTENNA__4100__B2 _4149_/A VGND VGND VPWR VPWR sky130_fd_sc_hd__diode_2
XFILLER_19_665 VGND VGND VPWR VPWR sky130_fd_sc_hd__fill_4
XFILLER_73_281 VGND VGND VPWR VPWR sky130_fd_sc_hd__fill_2
XANTENNA__4939__A0 _5042_/A1 VGND VGND VPWR VPWR sky130_fd_sc_hd__diode_2
XFILLER_18_197 VGND VGND VPWR VPWR sky130_fd_sc_hd__fill_1
XFILLER_92_82 VGND VGND VPWR VPWR sky130_fd_sc_hd__fill_2
XANTENNA__4272__S _4272_/S VGND VGND VPWR VPWR sky130_fd_sc_hd__diode_2
XFILLER_33_167 VGND VGND VPWR VPWR sky130_fd_sc_hd__fill_1
X_4740_ _5609_/Q _5690_/Q _6096_/Q _5876_/Q _4795_/S _4794_/A VGND VGND VPWR VPWR
+ _4740_/X sky130_fd_sc_hd__mux4_1
Xclkbuf_leaf_107_clk clkload0/A VGND VGND VPWR VPWR _6307_/CLK sky130_fd_sc_hd__clkbuf_8
XFILLER_30_841 VGND VGND VPWR VPWR sky130_fd_sc_hd__fill_1
X_4671_ _5651_/Q _5669_/Q _4810_/S VGND VGND VPWR VPWR _4671_/X sky130_fd_sc_hd__mux2_1
X_6410_ _6418_/CLK _6410_/D VGND VGND VPWR VPWR _6410_/Q sky130_fd_sc_hd__dfxtp_1
X_3622_ hold345/X _4517_/A1 _3627_/S VGND VGND VPWR VPWR _3622_/X sky130_fd_sc_hd__mux2_1
XANTENNA__4167__A1 _4264_/A1 VGND VGND VPWR VPWR sky130_fd_sc_hd__diode_2
XPHY_EDGE_ROW_72_Right_72 VGND VGND VPWR VPWR sky130_fd_sc_hd__decap_3
X_6341_ _6341_/CLK _6341_/D VGND VGND VPWR VPWR _6341_/Q sky130_fd_sc_hd__dfxtp_1
XANTENNA__3914__A1 _5212_/A1 VGND VGND VPWR VPWR sky130_fd_sc_hd__diode_2
X_3553_ _3606_/A _3553_/B _3553_/C VGND VGND VPWR VPWR _4513_/A sky130_fd_sc_hd__or3_4
X_3484_ _3484_/A0 _4887_/A1 _3490_/S VGND VGND VPWR VPWR _3484_/X sky130_fd_sc_hd__mux2_1
X_6272_ _6302_/CLK _6272_/D VGND VGND VPWR VPWR _6272_/Q sky130_fd_sc_hd__dfxtp_1
XFILLER_103_629 VPWR VGND VPWR VGND sky130_ef_sc_hd__decap_40_12
X_5223_ _3958_/Y _3987_/B _5117_/B _5223_/B1 VGND VGND VPWR VPWR _5223_/X sky130_fd_sc_hd__a31o_1
XANTENNA__3678__A0 _5202_/A1 VGND VGND VPWR VPWR sky130_fd_sc_hd__diode_2
XFILLER_97_841 VGND VGND VPWR VPWR sky130_fd_sc_hd__fill_1
X_5154_ _3959_/A _5153_/X _5152_/Y VGND VGND VPWR VPWR _5155_/B sky130_fd_sc_hd__o21ai_1
XFILLER_111_673 VPWR VGND VPWR VGND sky130_ef_sc_hd__decap_40_12
Xhold1704 _6211_/Q VGND VGND VPWR VPWR _4860_/A1 sky130_fd_sc_hd__dlygate4sd3_1
Xhold1726 _3671_/X VGND VGND VPWR VPWR _5694_/D sky130_fd_sc_hd__dlygate4sd3_1
Xhold1715 _6275_/Q VGND VGND VPWR VPWR _4939_/A1 sky130_fd_sc_hd__dlygate4sd3_1
X_4105_ _4105_/A0 _4105_/A1 _4237_/S VGND VGND VPWR VPWR _4106_/B sky130_fd_sc_hd__mux2_1
Xhold1737 _6364_/Q VGND VGND VPWR VPWR _5073_/A1 sky130_fd_sc_hd__dlygate4sd3_1
Xhold1759 _3501_/X VGND VGND VPWR VPWR _5546_/D sky130_fd_sc_hd__dlygate4sd3_1
Xhold1748 _5574_/Q VGND VGND VPWR VPWR _3531_/A0 sky130_fd_sc_hd__dlygate4sd3_1
XANTENNA_fanout188_A _5267_/Q VGND VGND VPWR VPWR sky130_fd_sc_hd__diode_2
XPHY_EDGE_ROW_81_Right_81 VGND VGND VPWR VPWR sky130_fd_sc_hd__decap_3
X_5085_ _5085_/A _5085_/B VGND VGND VPWR VPWR _6373_/D sky130_fd_sc_hd__nor2_1
XPHY_EDGE_ROW_16_Left_155 VGND VGND VPWR VPWR sky130_fd_sc_hd__decap_3
XFILLER_112_15 VPWR VGND VPWR VGND sky130_ef_sc_hd__decap_40_12
XFILLER_56_259 VGND VGND VPWR VPWR sky130_fd_sc_hd__fill_1
X_4036_ _5760_/Q _5738_/Q _4237_/S VGND VGND VPWR VPWR _4036_/X sky130_fd_sc_hd__mux2_1
XFILLER_71_229 VGND VGND VPWR VPWR sky130_fd_sc_hd__fill_2
XFILLER_52_410 VGND VGND VPWR VPWR sky130_fd_sc_hd__fill_1
XFILLER_25_613 VGND VGND VPWR VPWR sky130_fd_sc_hd__fill_2
XTAP_TAPCELL_ROW_84_1558 VGND VPWR sky130_fd_sc_hd__tapvpwrvgnd_1
XFILLER_80_774 VPWR VGND VPWR VGND sky130_ef_sc_hd__decap_40_12
X_5987_ clkload7/A _5987_/D VGND VGND VPWR VPWR _5987_/Q sky130_fd_sc_hd__dfxtp_1
XANTENNA_fanout143_X _4789_/A VGND VGND VPWR VPWR sky130_fd_sc_hd__diode_2
X_4938_ _4978_/A1 _4938_/A1 _4944_/S VGND VGND VPWR VPWR _4938_/X sky130_fd_sc_hd__mux2_1
XFILLER_21_841 VGND VGND VPWR VPWR sky130_fd_sc_hd__fill_1
XANTENNA__4182__S _4257_/S VGND VGND VPWR VPWR sky130_fd_sc_hd__diode_2
X_4869_ hold639/X _4882_/A1 _4880_/S VGND VGND VPWR VPWR _4869_/X sky130_fd_sc_hd__mux2_1
XPHY_EDGE_ROW_25_Left_164 VGND VGND VPWR VPWR sky130_fd_sc_hd__decap_3
XFILLER_138_559 VGND VGND VPWR VPWR sky130_fd_sc_hd__fill_1
XPHY_EDGE_ROW_90_Right_90 VGND VGND VPWR VPWR sky130_fd_sc_hd__decap_3
XANTENNA__4158__A1 _4264_/A1 VGND VGND VPWR VPWR sky130_fd_sc_hd__diode_2
XTAP_TAPCELL_ROW_115_2024 VGND VPWR sky130_fd_sc_hd__tapvpwrvgnd_1
XTAP_TAPCELL_ROW_99_1790 VGND VPWR sky130_fd_sc_hd__tapvpwrvgnd_1
XANTENNA__4253__S1 _4251_/A VGND VGND VPWR VPWR sky130_fd_sc_hd__diode_2
XANTENNA__3905__A1 _5213_/A1 VGND VGND VPWR VPWR sky130_fd_sc_hd__diode_2
XANTENNA__3526__S _3529_/S VGND VGND VPWR VPWR sky130_fd_sc_hd__diode_2
XFILLER_106_412 VGND VGND VPWR VPWR sky130_fd_sc_hd__fill_1
XFILLER_97_27 VGND VGND VPWR VPWR sky130_fd_sc_hd__fill_4
XANTENNA__3381__A2 _4457_/S VGND VGND VPWR VPWR sky130_fd_sc_hd__diode_2
XFILLER_0_701 VPWR VGND VPWR VGND sky130_ef_sc_hd__decap_40_12
XFILLER_88_841 VGND VGND VPWR VPWR sky130_fd_sc_hd__fill_1
XTAP_TAPCELL_ROW_7_399 VGND VPWR sky130_fd_sc_hd__tapvpwrvgnd_1
XPHY_EDGE_ROW_34_Left_173 VGND VGND VPWR VPWR sky130_fd_sc_hd__decap_3
XANTENNA__2892__A1 _3036_/A1 VGND VGND VPWR VPWR sky130_fd_sc_hd__diode_2
XANTENNA__2666__A _2666_/A VGND VGND VPWR VPWR sky130_fd_sc_hd__diode_2
XFILLER_75_557 VGND VGND VPWR VPWR sky130_fd_sc_hd__fill_2
XTAP_TAPCELL_ROW_126_2197 VGND VPWR sky130_fd_sc_hd__tapvpwrvgnd_1
XTAP_TAPCELL_ROW_126_2186 VGND VPWR sky130_fd_sc_hd__tapvpwrvgnd_1
XANTENNA__4881__A _4881_/A VGND VGND VPWR VPWR sky130_fd_sc_hd__diode_2
XFILLER_16_613 VPWR VGND VPWR VGND sky130_ef_sc_hd__decap_40_12
XFILLER_28_473 VGND VGND VPWR VPWR sky130_fd_sc_hd__fill_2
XFILLER_55_281 VGND VGND VPWR VPWR sky130_fd_sc_hd__fill_4
XFILLER_16_657 VPWR VGND VPWR VGND sky130_ef_sc_hd__decap_40_12
XFILLER_71_785 VGND VGND VPWR VPWR sky130_fd_sc_hd__fill_2
XANTENNA__4092__S _4228_/S VGND VGND VPWR VPWR sky130_fd_sc_hd__diode_2
XPHY_EDGE_ROW_43_Left_182 VGND VGND VPWR VPWR sky130_fd_sc_hd__decap_3
XTAP_TAPCELL_ROW_26_685 VGND VPWR sky130_fd_sc_hd__tapvpwrvgnd_1
XTAP_TAPCELL_ROW_26_696 VGND VPWR sky130_fd_sc_hd__tapvpwrvgnd_1
XFILLER_30_104 VGND VGND VPWR VPWR sky130_fd_sc_hd__fill_2
XFILLER_62_74 VGND VGND VPWR VPWR sky130_fd_sc_hd__fill_2
XFILLER_129_559 VGND VGND VPWR VPWR sky130_fd_sc_hd__fill_1
XANTENNA__4820__S _4828_/S VGND VGND VPWR VPWR sky130_fd_sc_hd__diode_2
XANTENNA__4244__S1 _4241_/A VGND VGND VPWR VPWR sky130_fd_sc_hd__diode_2
XFILLER_125_721 VGND VGND VPWR VPWR sky130_fd_sc_hd__fill_4
XANTENNA__3436__S _3437_/S VGND VGND VPWR VPWR sky130_fd_sc_hd__diode_2
XFILLER_125_765 VPWR VGND VPWR VGND sky130_ef_sc_hd__decap_40_12
XANTENNA__4121__A _4263_/A VGND VGND VPWR VPWR sky130_fd_sc_hd__diode_2
XFILLER_124_253 VGND VGND VPWR VPWR sky130_fd_sc_hd__fill_1
XTAP_TAPCELL_ROW_55_1126 VGND VPWR sky130_fd_sc_hd__tapvpwrvgnd_1
XFILLER_3_561 VPWR VGND VPWR VGND sky130_ef_sc_hd__decap_40_12
XFILLER_112_437 VGND VGND VPWR VPWR sky130_fd_sc_hd__fill_2
XFILLER_79_841 VGND VGND VPWR VPWR sky130_fd_sc_hd__fill_1
XPHY_EDGE_ROW_52_Left_191 VGND VGND VPWR VPWR sky130_fd_sc_hd__decap_3
XANTENNA__4321__A1 _4980_/A1 VGND VGND VPWR VPWR sky130_fd_sc_hd__diode_2
XFILLER_94_811 VGND VGND VPWR VPWR sky130_fd_sc_hd__fill_1
XFILLER_78_362 VGND VGND VPWR VPWR sky130_fd_sc_hd__fill_2
XFILLER_39_705 VGND VGND VPWR VPWR sky130_fd_sc_hd__fill_1
XFILLER_47_782 VGND VGND VPWR VPWR sky130_fd_sc_hd__fill_2
XFILLER_19_473 VPWR VGND VPWR VGND sky130_ef_sc_hd__decap_40_12
X_5910_ clkload8/A _5910_/D VGND VGND VPWR VPWR _5910_/Q sky130_fd_sc_hd__dfxtp_1
XFILLER_34_421 VGND VGND VPWR VPWR sky130_fd_sc_hd__fill_1
X_5841_ _5841_/CLK _5841_/D VGND VGND VPWR VPWR _5841_/Q sky130_fd_sc_hd__dfxtp_1
XTAP_TAPCELL_ROW_66_1288 VGND VPWR sky130_fd_sc_hd__tapvpwrvgnd_1
XFILLER_62_774 VPWR VGND VPWR VGND sky130_ef_sc_hd__decap_40_12
XTAP_TAPCELL_ROW_45_972 VGND VPWR sky130_fd_sc_hd__tapvpwrvgnd_1
XFILLER_22_605 VGND VGND VPWR VPWR sky130_fd_sc_hd__fill_2
X_2984_ hold685/X _5078_/A1 _2984_/S VGND VGND VPWR VPWR _2985_/B sky130_fd_sc_hd__mux2_1
X_5772_ _6302_/CLK _5772_/D VGND VGND VPWR VPWR _5772_/Q sky130_fd_sc_hd__dfxtp_1
XFILLER_21_104 VGND VGND VPWR VPWR sky130_fd_sc_hd__fill_1
XANTENNA__3060__A1 _3085_/A VGND VGND VPWR VPWR sky130_fd_sc_hd__diode_2
X_4723_ _5716_/Q _5707_/Q _4808_/S VGND VGND VPWR VPWR _4723_/X sky130_fd_sc_hd__mux2_1
XFILLER_30_671 VGND VGND VPWR VPWR sky130_fd_sc_hd__fill_8
X_4654_ _5864_/Q _5855_/Q _4795_/S VGND VGND VPWR VPWR _4655_/B sky130_fd_sc_hd__mux2_1
XFILLER_135_529 VPWR VGND VPWR VGND sky130_ef_sc_hd__decap_40_12
XFILLER_128_581 VGND VGND VPWR VPWR sky130_fd_sc_hd__fill_4
Xhold812 _4878_/X VGND VGND VPWR VPWR _6228_/D sky130_fd_sc_hd__dlygate4sd3_1
X_3605_ hold720/X _4964_/A0 _3605_/S VGND VGND VPWR VPWR _3605_/X sky130_fd_sc_hd__mux2_1
Xhold801 _5944_/Q VGND VGND VPWR VPWR hold801/X sky130_fd_sc_hd__dlygate4sd3_1
X_4585_ hold29/A _5666_/Q _4808_/S VGND VGND VPWR VPWR _4585_/X sky130_fd_sc_hd__mux2_1
Xhold845 _5311_/Q VGND VGND VPWR VPWR hold845/X sky130_fd_sc_hd__dlygate4sd3_1
XANTENNA__4560__A1 _4905_/A0 VGND VGND VPWR VPWR sky130_fd_sc_hd__diode_2
Xhold823 _5354_/Q VGND VGND VPWR VPWR hold823/X sky130_fd_sc_hd__dlygate4sd3_1
X_3536_ _3536_/A0 _5232_/A0 _3541_/S VGND VGND VPWR VPWR _3536_/X sky130_fd_sc_hd__mux2_1
X_6324_ _6339_/CLK _6324_/D VGND VGND VPWR VPWR _6324_/Q sky130_fd_sc_hd__dfxtp_1
XANTENNA__4031__A _4272_/S VGND VGND VPWR VPWR sky130_fd_sc_hd__diode_2
Xhold834 _3914_/X VGND VGND VPWR VPWR _5892_/D sky130_fd_sc_hd__dlygate4sd3_1
Xhold889 _3481_/X VGND VGND VPWR VPWR _5527_/D sky130_fd_sc_hd__dlygate4sd3_1
XFILLER_107_15 VPWR VGND VPWR VGND sky130_ef_sc_hd__decap_40_12
Xhold867 _5289_/Q VGND VGND VPWR VPWR hold867/X sky130_fd_sc_hd__dlygate4sd3_1
X_6255_ _6261_/CLK _6255_/D VGND VGND VPWR VPWR _6255_/Q sky130_fd_sc_hd__dfxtp_1
Xhold856 _3650_/X VGND VGND VPWR VPWR _5676_/D sky130_fd_sc_hd__dlygate4sd3_1
Xhold878 _3251_/X VGND VGND VPWR VPWR _5387_/D sky130_fd_sc_hd__dlygate4sd3_1
X_3467_ _5239_/A1 hold722/X _3477_/S VGND VGND VPWR VPWR _3467_/X sky130_fd_sc_hd__mux2_1
XFILLER_103_459 VGND VGND VPWR VPWR sky130_fd_sc_hd__fill_8
Xhold2202 _3239_/X VGND VGND VPWR VPWR _3240_/B sky130_fd_sc_hd__dlygate4sd3_1
X_5206_ _5206_/A1 _5205_/Y _5204_/X _5034_/B VGND VGND VPWR VPWR _5206_/X sky130_fd_sc_hd__o211a_1
XANTENNA__4312__A1 _5044_/A1 VGND VGND VPWR VPWR sky130_fd_sc_hd__diode_2
Xhold2246 _4535_/S VGND VGND VPWR VPWR _4532_/S sky130_fd_sc_hd__dlygate4sd3_1
X_6186_ _6238_/CLK _6186_/D VGND VGND VPWR VPWR _6186_/Q sky130_fd_sc_hd__dfxtp_1
XFILLER_97_671 VGND VGND VPWR VPWR sky130_fd_sc_hd__fill_1
Xhold2235 _5829_/Q VGND VGND VPWR VPWR hold2235/X sky130_fd_sc_hd__dlygate4sd3_1
Xhold1501 _4415_/X VGND VGND VPWR VPWR _6052_/D sky130_fd_sc_hd__dlygate4sd3_1
Xhold2213 _5397_/Q VGND VGND VPWR VPWR hold2213/X sky130_fd_sc_hd__dlygate4sd3_1
X_3398_ _3398_/A0 _5044_/A1 _3401_/S VGND VGND VPWR VPWR _3398_/X sky130_fd_sc_hd__mux2_1
Xhold2224 _3168_/Y VGND VGND VPWR VPWR _5340_/D sky130_fd_sc_hd__dlygate4sd3_1
XANTENNA__2874__A1 _3076_/A1 VGND VGND VPWR VPWR sky130_fd_sc_hd__diode_2
Xhold1523 _6253_/Q VGND VGND VPWR VPWR _4905_/A1 sky130_fd_sc_hd__dlygate4sd3_1
Xhold1534 _3303_/X VGND VGND VPWR VPWR _5421_/D sky130_fd_sc_hd__dlygate4sd3_1
XFILLER_85_833 VGND VGND VPWR VPWR sky130_fd_sc_hd__fill_4
X_5137_ _5137_/A _5137_/B VGND VGND VPWR VPWR _5137_/Y sky130_fd_sc_hd__nand2_1
XFILLER_57_535 VGND VGND VPWR VPWR sky130_fd_sc_hd__fill_1
XTAP_TAPCELL_ROW_4_358 VGND VPWR sky130_fd_sc_hd__tapvpwrvgnd_1
Xhold1512 _3776_/X VGND VGND VPWR VPWR _5786_/D sky130_fd_sc_hd__dlygate4sd3_1
Xhold2257 _5322_/Q VGND VGND VPWR VPWR _4305_/B sky130_fd_sc_hd__dlygate4sd3_1
X_5068_ _5329_/Q _2649_/A _5207_/S VGND VGND VPWR VPWR _5068_/X sky130_fd_sc_hd__mux2_1
Xhold1556 _5977_/Q VGND VGND VPWR VPWR _4331_/A1 sky130_fd_sc_hd__dlygate4sd3_1
Xhold1545 _6281_/Q VGND VGND VPWR VPWR _4946_/A1 sky130_fd_sc_hd__dlygate4sd3_1
Xhold1567 _4335_/X VGND VGND VPWR VPWR _5981_/D sky130_fd_sc_hd__dlygate4sd3_1
Xhold1578 _6053_/Q VGND VGND VPWR VPWR _4416_/A1 sky130_fd_sc_hd__dlygate4sd3_1
X_4019_ hold602/X _4368_/A1 hold771/X hold165/X _4213_/S _4212_/A VGND VGND VPWR VPWR
+ _4019_/X sky130_fd_sc_hd__mux4_1
Xhold1589 _4948_/X VGND VGND VPWR VPWR _6283_/D sky130_fd_sc_hd__dlygate4sd3_1
XANTENNA__4905__S _4906_/S VGND VGND VPWR VPWR sky130_fd_sc_hd__diode_2
XFILLER_53_785 VPWR VGND VPWR VGND sky130_ef_sc_hd__decap_40_12
XPHY_EDGE_ROW_0_Right_0 VGND VGND VPWR VPWR sky130_fd_sc_hd__decap_3
XFILLER_25_476 VGND VGND VPWR VPWR sky130_fd_sc_hd__fill_4
XANTENNA__4379__A1 _5052_/A1 VGND VGND VPWR VPWR sky130_fd_sc_hd__diode_2
XFILLER_9_609 VGND VGND VPWR VPWR sky130_fd_sc_hd__fill_4
XTAP_TAPCELL_ROW_23_644 VGND VPWR sky130_fd_sc_hd__tapvpwrvgnd_1
XTAP_TAPCELL_ROW_97_1749 VGND VPWR sky130_fd_sc_hd__tapvpwrvgnd_1
XFILLER_21_693 VPWR VGND VPWR VGND sky130_ef_sc_hd__decap_40_12
XANTENNA_clkbuf_3_2__f_clk_X clkload1/A VGND VGND VPWR VPWR sky130_fd_sc_hd__diode_2
XFILLER_126_529 VGND VGND VPWR VPWR sky130_fd_sc_hd__fill_2
XFILLER_113_3 VPWR VGND VPWR VGND sky130_ef_sc_hd__decap_40_12
XFILLER_107_721 VGND VGND VPWR VPWR sky130_fd_sc_hd__fill_4
XFILLER_5_837 VGND VGND VPWR VPWR sky130_fd_sc_hd__fill_2
XFILLER_107_765 VPWR VGND VPWR VGND sky130_ef_sc_hd__decap_40_12
XANTENNA__4551__A1 _4883_/A1 VGND VGND VPWR VPWR sky130_fd_sc_hd__diode_2
XANTENNA__3354__A2 _5035_/C VGND VGND VPWR VPWR sky130_fd_sc_hd__diode_2
XFILLER_122_713 VPWR VGND VPWR VGND sky130_ef_sc_hd__decap_40_12
XFILLER_121_201 VGND VGND VPWR VPWR sky130_fd_sc_hd__fill_1
XFILLER_79_115 VGND VGND VPWR VPWR sky130_fd_sc_hd__fill_1
XFILLER_122_757 VPWR VGND VPWR VGND sky130_ef_sc_hd__decap_40_12
XANTENNA__4303__A1 _5046_/A1 VGND VGND VPWR VPWR sky130_fd_sc_hd__diode_2
XFILLER_0_531 VGND VGND VPWR VPWR sky130_fd_sc_hd__fill_1
XTAP_TAPCELL_ROW_128_2226 VGND VPWR sky130_fd_sc_hd__tapvpwrvgnd_1
XTAP_TAPCELL_ROW_128_2215 VGND VPWR sky130_fd_sc_hd__tapvpwrvgnd_1
XFILLER_79_159 VGND VGND VPWR VPWR sky130_fd_sc_hd__fill_2
XFILLER_76_811 VGND VGND VPWR VPWR sky130_fd_sc_hd__fill_1
XTAP_TAPCELL_ROW_50_1045 VGND VPWR sky130_fd_sc_hd__tapvpwrvgnd_1
XFILLER_48_535 VGND VGND VPWR VPWR sky130_fd_sc_hd__fill_1
XANTENNA__2865__B2 _3075_/C1 VGND VGND VPWR VPWR sky130_fd_sc_hd__diode_2
XFILLER_57_96 VGND VGND VPWR VPWR sky130_fd_sc_hd__fill_2
XTAP_TAPCELL_ROW_50_1056 VGND VPWR sky130_fd_sc_hd__tapvpwrvgnd_1
XFILLER_75_376 VGND VGND VPWR VPWR sky130_fd_sc_hd__fill_4
XPHY_EDGE_ROW_121_Right_121 VGND VGND VPWR VPWR sky130_fd_sc_hd__decap_3
XFILLER_113_91 VGND VGND VPWR VPWR sky130_fd_sc_hd__fill_2
XFILLER_16_421 VPWR VGND VPWR VGND sky130_ef_sc_hd__decap_40_12
XANTENNA__3290__A1 _4901_/A0 VGND VGND VPWR VPWR sky130_fd_sc_hd__diode_2
XTAP_TAPCELL_ROW_106_1889 VGND VPWR sky130_fd_sc_hd__tapvpwrvgnd_1
XFILLER_44_752 VGND VGND VPWR VPWR sky130_fd_sc_hd__fill_4
XTAP_TAPCELL_ROW_42_931 VGND VPWR sky130_fd_sc_hd__tapvpwrvgnd_1
XANTENNA__4116__A _4260_/S VGND VGND VPWR VPWR sky130_fd_sc_hd__diode_2
XANTENNA__3020__A _3020_/A VGND VGND VPWR VPWR sky130_fd_sc_hd__diode_2
XANTENNA__4550__S _4561_/S VGND VGND VPWR VPWR sky130_fd_sc_hd__diode_2
XFILLER_12_693 VGND VGND VPWR VPWR sky130_fd_sc_hd__fill_4
XFILLER_117_529 VPWR VGND VPWR VGND sky130_ef_sc_hd__decap_40_12
XFILLER_8_697 VGND VGND VPWR VPWR sky130_fd_sc_hd__fill_2
Xhold108 _3910_/X VGND VGND VPWR VPWR _5888_/D sky130_fd_sc_hd__dlygate4sd3_1
XANTENNA__4542__A1 _5232_/A0 VGND VGND VPWR VPWR sky130_fd_sc_hd__diode_2
Xhold119 _5861_/Q VGND VGND VPWR VPWR hold119/X sky130_fd_sc_hd__dlygate4sd3_1
X_4370_ _5053_/A1 _4370_/A1 _4376_/S VGND VGND VPWR VPWR _4370_/X sky130_fd_sc_hd__mux2_1
XFILLER_7_196 VGND VGND VPWR VPWR sky130_fd_sc_hd__fill_4
XFILLER_125_573 VPWR VGND VPWR VGND sky130_ef_sc_hd__decap_40_12
X_3321_ _5066_/A0 _2651_/Y _3321_/B1 _3319_/X _3320_/X VGND VGND VPWR VPWR _3336_/A
+ sky130_fd_sc_hd__a2111o_1
XANTENNA_hold2235_A _5829_/Q VGND VGND VPWR VPWR sky130_fd_sc_hd__diode_2
X_6040_ _6405_/CLK _6040_/D VGND VGND VPWR VPWR _6040_/Q sky130_fd_sc_hd__dfxtp_1
XFILLER_3_391 VGND VGND VPWR VPWR sky130_fd_sc_hd__fill_1
X_3252_ _3362_/A1 _5920_/Q _3258_/S VGND VGND VPWR VPWR _3252_/X sky130_fd_sc_hd__mux2_1
X_3183_ hold511/X _4883_/A1 _3193_/S VGND VGND VPWR VPWR _5346_/D sky130_fd_sc_hd__mux2_1
XFILLER_94_641 VGND VGND VPWR VPWR sky130_fd_sc_hd__fill_2
XFILLER_66_354 VGND VGND VPWR VPWR sky130_fd_sc_hd__fill_1
XFILLER_82_825 VPWR VGND VPWR VGND sky130_ef_sc_hd__decap_40_12
XTAP_TAPCELL_ROW_68_1317 VGND VPWR sky130_fd_sc_hd__tapvpwrvgnd_1
XFILLER_66_365 VGND VGND VPWR VPWR sky130_fd_sc_hd__fill_4
XTAP_TAPCELL_ROW_1_317 VGND VPWR sky130_fd_sc_hd__tapvpwrvgnd_1
XFILLER_93_184 VGND VGND VPWR VPWR sky130_fd_sc_hd__fill_1
XTAP_TAPCELL_ROW_81_1517 VGND VPWR sky130_fd_sc_hd__tapvpwrvgnd_1
X_5824_ _6342_/CLK _5824_/D VGND VGND VPWR VPWR _5824_/Q sky130_fd_sc_hd__dfxtp_2
XANTENNA__4026__A _4212_/A VGND VGND VPWR VPWR sky130_fd_sc_hd__diode_2
XFILLER_22_413 VGND VGND VPWR VPWR sky130_fd_sc_hd__fill_4
XFILLER_35_785 VPWR VGND VPWR VGND sky130_ef_sc_hd__decap_40_12
XFILLER_22_457 VPWR VGND VPWR VGND sky130_ef_sc_hd__decap_40_12
X_2967_ _2960_/X _2966_/X _2967_/S VGND VGND VPWR VPWR _2967_/X sky130_fd_sc_hd__mux2_1
X_5755_ _6399_/CLK _5755_/D VGND VGND VPWR VPWR _5755_/Q sky130_fd_sc_hd__dfxtp_1
XTAP_TAPCELL_ROW_20_603 VGND VPWR sky130_fd_sc_hd__tapvpwrvgnd_1
XFILLER_136_805 VGND VGND VPWR VPWR sky130_fd_sc_hd__fill_4
X_2898_ hold33/A _6212_/Q _6155_/Q _6224_/Q _3062_/S _3005_/A VGND VGND VPWR VPWR
+ _2898_/X sky130_fd_sc_hd__mux4_1
X_4706_ _4789_/A _4706_/B VGND VGND VPWR VPWR _4706_/X sky130_fd_sc_hd__or2_1
X_5686_ _6095_/CLK _5686_/D VGND VGND VPWR VPWR _5686_/Q sky130_fd_sc_hd__dfxtp_1
XANTENNA__4781__A1 _4811_/A1 VGND VGND VPWR VPWR sky130_fd_sc_hd__diode_2
XANTENNA__2792__B1 _3076_/A1 VGND VGND VPWR VPWR sky130_fd_sc_hd__diode_2
XFILLER_108_529 VGND VGND VPWR VPWR sky130_fd_sc_hd__fill_2
X_4637_ _4811_/A1 _4636_/X _4635_/X _4811_/C1 VGND VGND VPWR VPWR _4637_/X sky130_fd_sc_hd__o211a_1
XANTENNA__4533__A1 _5235_/A0 VGND VGND VPWR VPWR sky130_fd_sc_hd__diode_2
Xhold620 _6127_/Q VGND VGND VPWR VPWR hold620/X sky130_fd_sc_hd__dlygate4sd3_1
XTAP_TAPCELL_ROW_79_1479 VGND VPWR sky130_fd_sc_hd__tapvpwrvgnd_1
Xhold642 _4462_/X VGND VGND VPWR VPWR _6070_/D sky130_fd_sc_hd__dlygate4sd3_1
XFILLER_104_713 VPWR VGND VPWR VGND sky130_ef_sc_hd__decap_40_12
Xhold653 _6241_/Q VGND VGND VPWR VPWR hold653/X sky130_fd_sc_hd__dlygate4sd3_1
Xhold631 _5611_/Q VGND VGND VPWR VPWR hold631/X sky130_fd_sc_hd__dlygate4sd3_1
XFILLER_78_29 VPWR VGND VPWR VGND sky130_ef_sc_hd__decap_40_12
X_4568_ _5861_/Q _5852_/Q _4713_/S VGND VGND VPWR VPWR _4569_/B sky130_fd_sc_hd__mux2_1
XANTENNA_fanout106_X _5053_/A1 VGND VGND VPWR VPWR sky130_fd_sc_hd__diode_2
XTAP_TAPCELL_ROW_9_439 VGND VPWR sky130_fd_sc_hd__tapvpwrvgnd_1
XTAP_TAPCELL_ROW_9_428 VGND VPWR sky130_fd_sc_hd__tapvpwrvgnd_1
XFILLER_1_306 VPWR VGND VPWR VGND sky130_ef_sc_hd__decap_40_12
X_3519_ _5239_/A1 _3519_/A1 _3529_/S VGND VGND VPWR VPWR _3519_/X sky130_fd_sc_hd__mux2_1
XFILLER_104_757 VPWR VGND VPWR VGND sky130_ef_sc_hd__decap_40_12
Xhold697 _4559_/X VGND VGND VPWR VPWR _6159_/D sky130_fd_sc_hd__dlygate4sd3_1
XTAP_TAPCELL_ROW_92_1679 VGND VPWR sky130_fd_sc_hd__tapvpwrvgnd_1
Xhold664 _4317_/X VGND VGND VPWR VPWR _5964_/D sky130_fd_sc_hd__dlygate4sd3_1
Xhold675 _5457_/Q VGND VGND VPWR VPWR hold675/X sky130_fd_sc_hd__dlygate4sd3_1
X_6307_ _6307_/CLK _6307_/D VGND VGND VPWR VPWR _6307_/Q sky130_fd_sc_hd__dfxtp_1
X_4499_ hold293/X _5213_/A1 _4502_/S VGND VGND VPWR VPWR _4499_/X sky130_fd_sc_hd__mux2_1
Xhold686 _5971_/Q VGND VGND VPWR VPWR hold686/X sky130_fd_sc_hd__dlygate4sd3_1
X_6238_ _6238_/CLK _6238_/D VGND VGND VPWR VPWR _6238_/Q sky130_fd_sc_hd__dfxtp_1
Xhold2010 _6056_/Q VGND VGND VPWR VPWR _3265_/A sky130_fd_sc_hd__dlygate4sd3_1
Xhold2021 _3144_/X VGND VGND VPWR VPWR _5325_/D sky130_fd_sc_hd__dlygate4sd3_1
XFILLER_134_57 VGND VGND VPWR VPWR sky130_fd_sc_hd__fill_2
Xhold2032 _6353_/Q VGND VGND VPWR VPWR _3317_/B sky130_fd_sc_hd__dlygate4sd3_1
X_6169_ _6382_/CLK _6169_/D VGND VGND VPWR VPWR _6169_/Q sky130_fd_sc_hd__dfxtp_1
XFILLER_57_310 VGND VGND VPWR VPWR sky130_fd_sc_hd__fill_8
Xhold2043 _5007_/Y VGND VGND VPWR VPWR _6330_/D sky130_fd_sc_hd__dlygate4sd3_1
Xhold2054 _3353_/X VGND VGND VPWR VPWR _5430_/D sky130_fd_sc_hd__dlygate4sd3_1
Xhold2065 _5171_/X VGND VGND VPWR VPWR _6398_/D sky130_fd_sc_hd__dlygate4sd3_1
Xhold2076 _5428_/Q VGND VGND VPWR VPWR _3328_/B sky130_fd_sc_hd__dlygate4sd3_1
XFILLER_69_181 VGND VGND VPWR VPWR sky130_fd_sc_hd__fill_2
Xhold2087 _6260_/Q VGND VGND VPWR VPWR _5190_/A1 sky130_fd_sc_hd__dlygate4sd3_1
Xhold1320 _5592_/Q VGND VGND VPWR VPWR _3551_/A0 sky130_fd_sc_hd__dlygate4sd3_1
Xclkbuf_leaf_96_clk clkbuf_leaf_9_clk/A VGND VGND VPWR VPWR _6421_/CLK sky130_fd_sc_hd__clkbuf_8
Xhold1331 _4943_/X VGND VGND VPWR VPWR _6279_/D sky130_fd_sc_hd__dlygate4sd3_1
Xhold1342 _5776_/Q VGND VGND VPWR VPWR _3765_/A0 sky130_fd_sc_hd__dlygate4sd3_1
Xhold1353 _6212_/Q VGND VGND VPWR VPWR _4861_/A1 sky130_fd_sc_hd__dlygate4sd3_1
Xhold1386 _3432_/X VGND VGND VPWR VPWR _5483_/D sky130_fd_sc_hd__dlygate4sd3_1
XFILLER_84_151 VGND VGND VPWR VPWR sky130_fd_sc_hd__fill_1
Xhold2098 _5156_/X VGND VGND VPWR VPWR _6395_/D sky130_fd_sc_hd__dlygate4sd3_1
XFILLER_73_825 VGND VGND VPWR VPWR sky130_fd_sc_hd__fill_2
Xhold1364 _4453_/X VGND VGND VPWR VPWR _6065_/D sky130_fd_sc_hd__dlygate4sd3_1
XFILLER_57_365 VGND VGND VPWR VPWR sky130_fd_sc_hd__fill_4
Xhold1375 _6336_/Q VGND VGND VPWR VPWR _5041_/A0 sky130_fd_sc_hd__dlygate4sd3_1
XFILLER_45_505 VGND VGND VPWR VPWR sky130_fd_sc_hd__fill_1
XTAP_TAPCELL_ROW_28_714 VGND VPWR sky130_fd_sc_hd__tapvpwrvgnd_1
XTAP_TAPCELL_ROW_123_2145 VGND VPWR sky130_fd_sc_hd__tapvpwrvgnd_1
Xhold1397 _5472_/Q VGND VGND VPWR VPWR _3419_/A0 sky130_fd_sc_hd__dlygate4sd3_1
XANTENNA__4144__S0 _4257_/S VGND VGND VPWR VPWR sky130_fd_sc_hd__diode_2
XFILLER_27_66 VGND VGND VPWR VPWR sky130_fd_sc_hd__fill_1
XFILLER_26_730 VGND VGND VPWR VPWR sky130_fd_sc_hd__fill_2
XTAP_TAPCELL_ROW_28_725 VGND VPWR sky130_fd_sc_hd__tapvpwrvgnd_1
XFILLER_9_417 VPWR VGND VPWR VGND sky130_ef_sc_hd__decap_40_12
XANTENNA__3024__B2 _2641_/Y VGND VGND VPWR VPWR sky130_fd_sc_hd__diode_2
Xclkbuf_leaf_20_clk clkload3/A VGND VGND VPWR VPWR _6398_/CLK sky130_fd_sc_hd__clkbuf_8
XFILLER_138_197 VGND VGND VPWR VPWR sky130_fd_sc_hd__fill_1
XANTENNA__4524__A1 _4882_/A1 VGND VGND VPWR VPWR sky130_fd_sc_hd__diode_2
XFILLER_107_573 VPWR VGND VPWR VGND sky130_ef_sc_hd__decap_40_12
XFILLER_4_15 VPWR VGND VPWR VGND sky130_ef_sc_hd__decap_40_12
XFILLER_122_521 VGND VGND VPWR VPWR sky130_fd_sc_hd__fill_8
XFILLER_122_587 VGND VGND VPWR VPWR sky130_fd_sc_hd__fill_1
XFILLER_110_749 VGND VGND VPWR VPWR sky130_fd_sc_hd__fill_4
XFILLER_95_449 VGND VGND VPWR VPWR sky130_fd_sc_hd__fill_2
XFILLER_67_107 VGND VGND VPWR VPWR sky130_fd_sc_hd__fill_4
XFILLER_49_833 VGND VGND VPWR VPWR sky130_fd_sc_hd__fill_4
XANTENNA__3015__A _3044_/A VGND VGND VPWR VPWR sky130_fd_sc_hd__diode_2
Xclkbuf_leaf_87_clk clkload1/A VGND VGND VPWR VPWR _6414_/CLK sky130_fd_sc_hd__clkbuf_8
XTAP_TAPCELL_ROW_108_1918 VGND VPWR sky130_fd_sc_hd__tapvpwrvgnd_1
XFILLER_64_825 VGND VGND VPWR VPWR sky130_fd_sc_hd__fill_8
XANTENNA__4545__S _4547_/S VGND VGND VPWR VPWR sky130_fd_sc_hd__diode_2
XFILLER_84_83 VGND VGND VPWR VPWR sky130_fd_sc_hd__fill_1
XFILLER_84_72 VGND VGND VPWR VPWR sky130_fd_sc_hd__fill_1
XFILLER_17_741 VPWR VGND VPWR VGND sky130_ef_sc_hd__decap_40_12
XFILLER_90_143 VGND VGND VPWR VPWR sky130_fd_sc_hd__fill_1
XFILLER_16_251 VGND VGND VPWR VPWR sky130_fd_sc_hd__fill_1
XFILLER_44_593 VGND VGND VPWR VPWR sky130_fd_sc_hd__fill_2
XFILLER_17_785 VPWR VGND VPWR VGND sky130_ef_sc_hd__decap_40_12
XFILLER_32_733 VGND VGND VPWR VPWR sky130_fd_sc_hd__fill_2
XTAP_TAPCELL_ROW_63_1247 VGND VPWR sky130_fd_sc_hd__tapvpwrvgnd_1
X_3870_ _3870_/A _4955_/B VGND VGND VPWR VPWR _3879_/S sky130_fd_sc_hd__or2_4
XFILLER_31_221 VGND VGND VPWR VPWR sky130_fd_sc_hd__fill_1
X_2821_ _3036_/A1 _2820_/X _3094_/C1 VGND VGND VPWR VPWR _2821_/X sky130_fd_sc_hd__o21a_1
X_5540_ _6438_/CLK _5540_/D VGND VGND VPWR VPWR _5540_/Q sky130_fd_sc_hd__dfxtp_1
XFILLER_118_805 VGND VGND VPWR VPWR sky130_fd_sc_hd__fill_4
X_2752_ _2752_/A0 _5080_/A0 _2753_/S VGND VGND VPWR VPWR _2752_/X sky130_fd_sc_hd__mux2_1
Xclkbuf_leaf_11_clk clkbuf_leaf_9_clk/A VGND VGND VPWR VPWR _6351_/CLK sky130_fd_sc_hd__clkbuf_8
X_5471_ _6236_/CLK _5471_/D VGND VGND VPWR VPWR _5471_/Q sky130_fd_sc_hd__dfxtp_1
X_2683_ _4548_/C _4868_/A VGND VGND VPWR VPWR _2685_/A sky130_fd_sc_hd__nor2_1
X_4422_ input5/X input4/X VGND VGND VPWR VPWR _4427_/B sky130_fd_sc_hd__nor2_4
X_4353_ _4353_/A0 _4981_/A1 _4356_/S VGND VGND VPWR VPWR _4353_/X sky130_fd_sc_hd__mux2_1
XFILLER_99_777 VGND VGND VPWR VPWR sky130_fd_sc_hd__fill_4
X_3304_ hold499/X _5233_/A0 _3308_/S VGND VGND VPWR VPWR _3304_/X sky130_fd_sc_hd__mux2_1
X_4284_ hold457/X _5047_/A1 _4284_/S VGND VGND VPWR VPWR _4284_/X sky130_fd_sc_hd__mux2_1
XFILLER_101_727 VGND VGND VPWR VPWR sky130_fd_sc_hd__fill_1
X_3235_ _3236_/A _3606_/B VGND VGND VPWR VPWR _3237_/B sky130_fd_sc_hd__or2_1
X_6023_ clkload9/A _6023_/D VGND VGND VPWR VPWR _6023_/Q sky130_fd_sc_hd__dfxtp_1
XFILLER_104_27 VGND VGND VPWR VPWR sky130_fd_sc_hd__fill_1
XFILLER_100_237 VGND VGND VPWR VPWR sky130_fd_sc_hd__fill_2
Xclkbuf_leaf_78_clk clkload2/A VGND VGND VPWR VPWR _6060_/CLK sky130_fd_sc_hd__clkbuf_8
XFILLER_67_685 VGND VGND VPWR VPWR sky130_fd_sc_hd__fill_1
XFILLER_66_151 VGND VGND VPWR VPWR sky130_fd_sc_hd__fill_2
X_3166_ _4257_/S _3167_/C _4241_/A VGND VGND VPWR VPWR _3168_/B sky130_fd_sc_hd__a21oi_1
XFILLER_39_376 VGND VGND VPWR VPWR sky130_fd_sc_hd__fill_2
X_3097_ _2967_/S _3096_/Y _3090_/Y _5270_/Q VGND VGND VPWR VPWR _3097_/Y sky130_fd_sc_hd__o211ai_1
XFILLER_94_493 VGND VGND VPWR VPWR sky130_fd_sc_hd__fill_1
XFILLER_66_195 VGND VGND VPWR VPWR sky130_fd_sc_hd__fill_1
XFILLER_66_184 VGND VGND VPWR VPWR sky130_fd_sc_hd__fill_1
XFILLER_54_313 VGND VGND VPWR VPWR sky130_fd_sc_hd__fill_2
XANTENNA_fanout170_A _4221_/S VGND VGND VPWR VPWR sky130_fd_sc_hd__diode_2
XFILLER_82_688 VGND VGND VPWR VPWR sky130_fd_sc_hd__fill_1
XFILLER_70_817 VGND VGND VPWR VPWR sky130_fd_sc_hd__fill_2
XFILLER_120_15 VPWR VGND VPWR VGND sky130_ef_sc_hd__decap_40_12
XFILLER_23_733 VGND VGND VPWR VPWR sky130_fd_sc_hd__fill_2
X_5807_ _5820_/CLK _5807_/D VGND VGND VPWR VPWR _5807_/Q sky130_fd_sc_hd__dfxtp_1
Xfanout58 _3959_/A VGND VGND VPWR VPWR _3958_/A sky130_fd_sc_hd__buf_4
X_3999_ _6409_/Q _3998_/Y _3964_/B VGND VGND VPWR VPWR _3999_/X sky130_fd_sc_hd__a21o_1
Xfanout69 _2636_/Y VGND VGND VPWR VPWR _4264_/A1 sky130_fd_sc_hd__clkbuf_8
XANTENNA__4754__A1 _2629_/Y VGND VGND VPWR VPWR sky130_fd_sc_hd__diode_2
X_5738_ _5908_/CLK _5738_/D VGND VGND VPWR VPWR _5738_/Q sky130_fd_sc_hd__dfxtp_1
XTAP_TAPCELL_ROW_33_794 VGND VPWR sky130_fd_sc_hd__tapvpwrvgnd_1
XFILLER_136_613 VPWR VGND VPWR VGND sky130_ef_sc_hd__decap_40_12
XFILLER_136_657 VPWR VGND VPWR VGND sky130_ef_sc_hd__decap_40_12
XTAP_TAPCELL_ROW_94_1708 VGND VPWR sky130_fd_sc_hd__tapvpwrvgnd_1
X_5669_ _5850_/CLK _5669_/D VGND VGND VPWR VPWR _5669_/Q sky130_fd_sc_hd__dfxtp_1
XANTENNA__4506__A1 _5210_/A1 VGND VGND VPWR VPWR sky130_fd_sc_hd__diode_2
XFILLER_132_841 VGND VGND VPWR VPWR sky130_fd_sc_hd__fill_1
Xhold450 _3204_/X VGND VGND VPWR VPWR _5366_/D sky130_fd_sc_hd__dlygate4sd3_1
XFILLER_116_392 VGND VGND VPWR VPWR sky130_fd_sc_hd__fill_1
XANTENNA__3534__S _3541_/S VGND VGND VPWR VPWR sky130_fd_sc_hd__diode_2
Xhold472 _3581_/X VGND VGND VPWR VPWR _5617_/D sky130_fd_sc_hd__dlygate4sd3_1
Xhold461 _5643_/Q VGND VGND VPWR VPWR hold461/X sky130_fd_sc_hd__dlygate4sd3_1
XFILLER_2_637 VGND VGND VPWR VPWR sky130_fd_sc_hd__fill_4
Xhold494 _4550_/X VGND VGND VPWR VPWR _6150_/D sky130_fd_sc_hd__dlygate4sd3_1
Xhold483 _5959_/Q VGND VGND VPWR VPWR hold483/X sky130_fd_sc_hd__dlygate4sd3_1
XPHY_EDGE_ROW_8_Left_147 VGND VGND VPWR VPWR sky130_fd_sc_hd__decap_3
XFILLER_104_587 VGND VGND VPWR VPWR sky130_fd_sc_hd__fill_1
XANTENNA__5034__B _5034_/B VGND VGND VPWR VPWR sky130_fd_sc_hd__diode_2
XFILLER_1_169 VGND VGND VPWR VPWR sky130_fd_sc_hd__fill_1
Xclkbuf_leaf_69_clk clkload5/A VGND VGND VPWR VPWR _6290_/CLK sky130_fd_sc_hd__clkbuf_8
Xhold1150 _6427_/Q VGND VGND VPWR VPWR _5230_/A1 sky130_fd_sc_hd__dlygate4sd3_1
XFILLER_46_825 VPWR VGND VPWR VGND sky130_ef_sc_hd__decap_40_12
XFILLER_38_87 VGND VGND VPWR VPWR sky130_fd_sc_hd__fill_2
XFILLER_100_793 VPWR VGND VPWR VGND sky130_ef_sc_hd__decap_40_12
Xhold1161 _6220_/Q VGND VGND VPWR VPWR _4870_/A0 sky130_fd_sc_hd__dlygate4sd3_1
Xhold1183 _6240_/Q VGND VGND VPWR VPWR _4891_/A0 sky130_fd_sc_hd__dlygate4sd3_1
XFILLER_85_482 VGND VGND VPWR VPWR sky130_fd_sc_hd__fill_1
XFILLER_72_121 VGND VGND VPWR VPWR sky130_fd_sc_hd__fill_1
Xhold1194 _5262_/Q VGND VGND VPWR VPWR _2714_/A1 sky130_fd_sc_hd__dlygate4sd3_1
Xhold1172 _4940_/X VGND VGND VPWR VPWR _6276_/D sky130_fd_sc_hd__dlygate4sd3_1
XFILLER_73_677 VGND VGND VPWR VPWR sky130_fd_sc_hd__fill_2
XFILLER_72_143 VGND VGND VPWR VPWR sky130_fd_sc_hd__fill_8
XANTENNA__4442__B1 _4445_/B VGND VGND VPWR VPWR sky130_fd_sc_hd__diode_2
XFILLER_72_165 VGND VGND VPWR VPWR sky130_fd_sc_hd__fill_4
XFILLER_61_839 VGND VGND VPWR VPWR sky130_fd_sc_hd__fill_1
XTAP_TAPCELL_ROW_103_1848 VGND VPWR sky130_fd_sc_hd__tapvpwrvgnd_1
XANTENNA__4993__A1 _5047_/A1 VGND VGND VPWR VPWR sky130_fd_sc_hd__diode_2
XFILLER_14_755 VGND VGND VPWR VPWR sky130_fd_sc_hd__fill_1
XFILLER_41_530 VGND VGND VPWR VPWR sky130_fd_sc_hd__fill_1
XTAP_TAPCELL_ROW_136_2336 VGND VPWR sky130_fd_sc_hd__tapvpwrvgnd_1
XTAP_TAPCELL_ROW_136_2347 VGND VPWR sky130_fd_sc_hd__tapvpwrvgnd_1
XFILLER_127_613 VGND VGND VPWR VPWR sky130_fd_sc_hd__fill_2
Xclkload17 _6314_/CLK VGND VGND VPWR VPWR clkload17/Y sky130_fd_sc_hd__inv_6
XANTENNA__2851__S0 _2963_/S VGND VGND VPWR VPWR sky130_fd_sc_hd__diode_2
Xclkload28 _6342_/CLK VGND VGND VPWR VPWR clkload28/X sky130_fd_sc_hd__clkbuf_8
Xclkload39 _6408_/CLK VGND VGND VPWR VPWR clkload39/Y sky130_fd_sc_hd__clkinv_2
XTAP_TAPCELL_ROW_11_466 VGND VPWR sky130_fd_sc_hd__tapvpwrvgnd_1
XFILLER_126_156 VGND VGND VPWR VPWR sky130_fd_sc_hd__fill_2
XFILLER_123_841 VGND VGND VPWR VPWR sky130_fd_sc_hd__fill_1
XFILLER_79_61 VGND VGND VPWR VPWR sky130_fd_sc_hd__fill_1
XFILLER_5_497 VGND VGND VPWR VPWR sky130_fd_sc_hd__fill_4
XANTENNA__3444__S _3450_/S VGND VGND VPWR VPWR sky130_fd_sc_hd__diode_2
XFILLER_110_513 VPWR VGND VPWR VGND sky130_ef_sc_hd__decap_40_12
XFILLER_96_725 VPWR VGND VPWR VGND sky130_ef_sc_hd__decap_40_12
XFILLER_110_557 VPWR VGND VPWR VGND sky130_ef_sc_hd__decap_40_12
XFILLER_96_769 VPWR VGND VPWR VGND sky130_ef_sc_hd__decap_40_12
XANTENNA__3484__A1 _4887_/A1 VGND VGND VPWR VPWR sky130_fd_sc_hd__diode_2
X_3020_ _3020_/A _3020_/B VGND VGND VPWR VPWR _3020_/X sky130_fd_sc_hd__or2_1
XFILLER_95_279 VGND VGND VPWR VPWR sky130_fd_sc_hd__fill_1
Xclkbuf_leaf_0_clk clkload0/A VGND VGND VPWR VPWR clkload7/A sky130_fd_sc_hd__clkbuf_8
XFILLER_36_302 VGND VGND VPWR VPWR sky130_fd_sc_hd__fill_4
XFILLER_91_430 VGND VGND VPWR VPWR sky130_fd_sc_hd__fill_4
XFILLER_76_493 VGND VGND VPWR VPWR sky130_fd_sc_hd__fill_2
XANTENNA__4681__B1 _4791_/B1 VGND VGND VPWR VPWR sky130_fd_sc_hd__diode_2
XFILLER_64_633 VGND VGND VPWR VPWR sky130_fd_sc_hd__fill_8
XANTENNA__4433__B1 _4430_/X VGND VGND VPWR VPWR sky130_fd_sc_hd__diode_2
XTAP_TAPCELL_ROW_19_588 VGND VPWR sky130_fd_sc_hd__tapvpwrvgnd_1
X_4971_ _4981_/A1 _4971_/A1 _4974_/S VGND VGND VPWR VPWR _4971_/X sky130_fd_sc_hd__mux2_1
XANTENNA__4984__A1 _4984_/A1 VGND VGND VPWR VPWR sky130_fd_sc_hd__diode_2
X_3922_ hold655/X _4958_/A0 _3928_/S VGND VGND VPWR VPWR _3922_/X sky130_fd_sc_hd__mux2_1
X_3853_ input25/X _3837_/A _4922_/C _3852_/X _5200_/A VGND VGND VPWR VPWR _5840_/D
+ sky130_fd_sc_hd__o311a_1
XFILLER_20_725 VPWR VGND VPWR VGND sky130_ef_sc_hd__decap_40_12
XFILLER_32_585 VGND VGND VPWR VPWR sky130_fd_sc_hd__fill_1
X_2804_ _3005_/A _2804_/B VGND VGND VPWR VPWR _2804_/Y sky130_fd_sc_hd__nor2_1
XFILLER_118_613 VPWR VGND VPWR VGND sky130_ef_sc_hd__decap_40_12
XFILLER_117_101 VGND VGND VPWR VPWR sky130_fd_sc_hd__fill_2
XANTENNA__3095__S0 _3062_/S VGND VGND VPWR VPWR sky130_fd_sc_hd__diode_2
XFILLER_9_781 VGND VGND VPWR VPWR sky130_fd_sc_hd__fill_2
XFILLER_20_769 VPWR VGND VPWR VGND sky130_ef_sc_hd__decap_40_12
X_3784_ _3784_/A0 _5213_/A1 _3787_/S VGND VGND VPWR VPWR _3784_/X sky130_fd_sc_hd__mux2_1
XTAP_TAPCELL_ROW_30_753 VGND VPWR sky130_fd_sc_hd__tapvpwrvgnd_1
XFILLER_118_657 VPWR VGND VPWR VGND sky130_ef_sc_hd__decap_40_12
X_5523_ _5571_/CLK _5523_/D VGND VGND VPWR VPWR _5523_/Q sky130_fd_sc_hd__dfxtp_1
XFILLER_117_134 VGND VGND VPWR VPWR sky130_fd_sc_hd__fill_1
X_2735_ _2735_/A _2735_/B VGND VGND VPWR VPWR _2736_/B sky130_fd_sc_hd__and2_1
X_2666_ _2666_/A _2666_/B VGND VGND VPWR VPWR _3207_/C sky130_fd_sc_hd__nand2_2
XTAP_TAPCELL_ROW_76_1438 VGND VPWR sky130_fd_sc_hd__tapvpwrvgnd_1
X_5454_ clkload7/A _5454_/D VGND VGND VPWR VPWR _5454_/Q sky130_fd_sc_hd__dfxtp_1
X_5385_ _6123_/CLK _5385_/D VGND VGND VPWR VPWR _5385_/Q sky130_fd_sc_hd__dfxtp_2
X_4405_ _5046_/A1 _4405_/A1 _4406_/S VGND VGND VPWR VPWR _4405_/X sky130_fd_sc_hd__mux2_1
XFILLER_114_841 VGND VGND VPWR VPWR sky130_fd_sc_hd__fill_1
Xfanout204 _3237_/A VGND VGND VPWR VPWR _2682_/A sky130_fd_sc_hd__clkbuf_4
XANTENNA__3207__X _5069_/B VGND VGND VPWR VPWR sky130_fd_sc_hd__diode_2
XFILLER_87_703 VGND VGND VPWR VPWR sky130_fd_sc_hd__fill_1
X_4336_ _4965_/A _4336_/B VGND VGND VPWR VPWR _4345_/S sky130_fd_sc_hd__nor2_4
XFILLER_115_15 VPWR VGND VPWR VGND sky130_ef_sc_hd__decap_40_12
XFILLER_99_585 VPWR VGND VPWR VGND sky130_ef_sc_hd__decap_40_12
XFILLER_101_557 VGND VGND VPWR VPWR sky130_fd_sc_hd__fill_2
XFILLER_59_449 VGND VGND VPWR VPWR sky130_fd_sc_hd__fill_8
X_4267_ hold53/A _6017_/Q _4270_/S VGND VGND VPWR VPWR _4267_/X sky130_fd_sc_hd__mux2_1
X_3218_ _5235_/A0 hold994/X _3220_/S VGND VGND VPWR VPWR _3218_/X sky130_fd_sc_hd__mux2_1
XFILLER_74_419 VGND VGND VPWR VPWR sky130_fd_sc_hd__fill_1
X_6006_ _6421_/CLK _6006_/D VGND VGND VPWR VPWR _6006_/Q sky130_fd_sc_hd__dfxtp_1
X_4198_ _6278_/Q _6269_/Q _4257_/S VGND VGND VPWR VPWR _4198_/X sky130_fd_sc_hd__mux2_1
XFILLER_27_302 VGND VGND VPWR VPWR sky130_fd_sc_hd__fill_1
XFILLER_28_825 VPWR VGND VPWR VGND sky130_ef_sc_hd__decap_40_12
X_3149_ _3321_/B1 hold807/X _3156_/S VGND VGND VPWR VPWR _3149_/X sky130_fd_sc_hd__mux2_1
XFILLER_67_493 VGND VGND VPWR VPWR sky130_fd_sc_hd__fill_1
XANTENNA__4672__B1 _2628_/A VGND VGND VPWR VPWR sky130_fd_sc_hd__diode_2
XFILLER_131_47 VGND VGND VPWR VPWR sky130_fd_sc_hd__fill_1
XTAP_TAPCELL_ROW_120_2104 VGND VPWR sky130_fd_sc_hd__tapvpwrvgnd_1
XFILLER_27_357 VGND VGND VPWR VPWR sky130_fd_sc_hd__fill_1
XANTENNA_fanout173_X _4221_/S VGND VGND VPWR VPWR sky130_fd_sc_hd__diode_2
XTAP_TAPCELL_ROW_38_864 VGND VPWR sky130_fd_sc_hd__tapvpwrvgnd_1
XANTENNA__4424__B1 _4427_/B VGND VGND VPWR VPWR sky130_fd_sc_hd__diode_2
XFILLER_70_614 VGND VGND VPWR VPWR sky130_fd_sc_hd__fill_4
XANTENNA__3227__A1 _4811_/A1 VGND VGND VPWR VPWR sky130_fd_sc_hd__diode_2
XFILLER_43_839 VGND VGND VPWR VPWR sky130_fd_sc_hd__fill_1
XTAP_TAPCELL_ROW_38_875 VGND VPWR sky130_fd_sc_hd__tapvpwrvgnd_1
XFILLER_11_725 VGND VGND VPWR VPWR sky130_fd_sc_hd__fill_2
XANTENNA__3529__S _3529_/S VGND VGND VPWR VPWR sky130_fd_sc_hd__diode_2
XFILLER_109_613 VGND VGND VPWR VPWR sky130_fd_sc_hd__fill_2
XANTENNA__2738__B1 _5222_/A VGND VGND VPWR VPWR sky130_fd_sc_hd__diode_2
XFILLER_7_729 VPWR VGND VPWR VGND sky130_ef_sc_hd__decap_40_12
XTAP_TAPCELL_ROW_118_2077 VGND VPWR sky130_fd_sc_hd__tapvpwrvgnd_1
XTAP_TAPCELL_ROW_118_2066 VGND VPWR sky130_fd_sc_hd__tapvpwrvgnd_1
XFILLER_109_635 VPWR VGND VPWR VGND sky130_ef_sc_hd__decap_40_12
XTAP_TAPCELL_ROW_131_2266 VGND VPWR sky130_fd_sc_hd__tapvpwrvgnd_1
XFILLER_105_841 VGND VGND VPWR VPWR sky130_fd_sc_hd__fill_1
Xhold280 _5443_/Q VGND VGND VPWR VPWR hold280/X sky130_fd_sc_hd__dlygate4sd3_1
XFILLER_6_3 VPWR VGND VPWR VGND sky130_ef_sc_hd__decap_40_12
XFILLER_2_445 VPWR VGND VPWR VGND sky130_ef_sc_hd__decap_40_12
XFILLER_120_811 VGND VGND VPWR VPWR sky130_fd_sc_hd__fill_1
Xhold291 _5279_/Q VGND VGND VPWR VPWR hold291/X sky130_fd_sc_hd__dlygate4sd3_1
XFILLER_2_489 VPWR VGND VPWR VGND sky130_ef_sc_hd__decap_40_12
XANTENNA_fanout86_X _4958_/A0 VGND VGND VPWR VPWR sky130_fd_sc_hd__diode_2
XFILLER_132_693 VGND VGND VPWR VPWR sky130_fd_sc_hd__fill_4
XFILLER_77_279 VGND VGND VPWR VPWR sky130_fd_sc_hd__fill_1
XFILLER_105_92 VGND VGND VPWR VPWR sky130_fd_sc_hd__fill_2
XFILLER_105_70 VGND VGND VPWR VPWR sky130_fd_sc_hd__fill_2
XANTENNA__4095__S _4228_/S VGND VGND VPWR VPWR sky130_fd_sc_hd__diode_2
XANTENNA_clkbuf_leaf_64_clk_A clkload5/A VGND VGND VPWR VPWR sky130_fd_sc_hd__diode_2
XTAP_TAPCELL_ROW_47_1006 VGND VPWR sky130_fd_sc_hd__tapvpwrvgnd_1
XANTENNA__4415__A0 _5046_/A1 VGND VGND VPWR VPWR sky130_fd_sc_hd__diode_2
XFILLER_33_327 VGND VGND VPWR VPWR sky130_fd_sc_hd__fill_1
XANTENNA__4823__S _4828_/S VGND VGND VPWR VPWR sky130_fd_sc_hd__diode_2
XTAP_TAPCELL_ROW_16_536 VGND VPWR sky130_fd_sc_hd__tapvpwrvgnd_1
XTAP_TAPCELL_ROW_16_547 VGND VPWR sky130_fd_sc_hd__tapvpwrvgnd_1
XANTENNA__2977__B1 _3076_/A1 VGND VGND VPWR VPWR sky130_fd_sc_hd__diode_2
XTAP_TAPCELL_ROW_60_1206 VGND VPWR sky130_fd_sc_hd__tapvpwrvgnd_1
XANTENNA__3439__S _3450_/S VGND VGND VPWR VPWR sky130_fd_sc_hd__diode_2
XANTENNA_clkbuf_leaf_79_clk_A clkload2/A VGND VGND VPWR VPWR sky130_fd_sc_hd__diode_2
XFILLER_14_585 VGND VGND VPWR VPWR sky130_fd_sc_hd__fill_2
Xclkload106 _6437_/CLK VGND VGND VPWR VPWR clkload106/Y sky130_fd_sc_hd__inv_6
XFILLER_127_410 VGND VGND VPWR VPWR sky130_fd_sc_hd__fill_2
XFILLER_127_487 VPWR VGND VPWR VGND sky130_ef_sc_hd__decap_40_12
XTAP_TAPCELL_ROW_58_1168 VGND VPWR sky130_fd_sc_hd__tapvpwrvgnd_1
XFILLER_123_671 VGND VGND VPWR VPWR sky130_fd_sc_hd__fill_1
XFILLER_96_511 VPWR VGND VPWR VGND sky130_ef_sc_hd__decap_40_12
X_5170_ _5175_/S _5170_/B VGND VGND VPWR VPWR _5170_/Y sky130_fd_sc_hd__nand2_1
XANTENNA_clkbuf_leaf_17_clk_A clkload6/A VGND VGND VPWR VPWR sky130_fd_sc_hd__diode_2
XFILLER_111_833 VGND VGND VPWR VPWR sky130_fd_sc_hd__fill_4
XFILLER_96_533 VPWR VGND VPWR VGND sky130_ef_sc_hd__decap_40_12
Xhold1908 _5292_/Q VGND VGND VPWR VPWR _3153_/A1 sky130_fd_sc_hd__dlygate4sd3_1
XANTENNA__4794__A _4794_/A VGND VGND VPWR VPWR sky130_fd_sc_hd__diode_2
XTAP_TAPCELL_ROW_71_1368 VGND VPWR sky130_fd_sc_hd__tapvpwrvgnd_1
XFILLER_69_758 VPWR VGND VPWR VGND sky130_ef_sc_hd__decap_40_12
X_4121_ _4263_/A _4121_/B VGND VGND VPWR VPWR _4121_/X sky130_fd_sc_hd__or2_1
XANTENNA__3457__A1 _4887_/A1 VGND VGND VPWR VPWR sky130_fd_sc_hd__diode_2
XFILLER_84_717 VGND VGND VPWR VPWR sky130_fd_sc_hd__fill_1
XFILLER_56_419 VGND VGND VPWR VPWR sky130_fd_sc_hd__fill_1
Xhold1919 _5914_/Q VGND VGND VPWR VPWR _3938_/A1 sky130_fd_sc_hd__dlygate4sd3_1
X_4052_ _4252_/A1 _4051_/X _4252_/B1 VGND VGND VPWR VPWR _4052_/X sky130_fd_sc_hd__o21a_1
XFILLER_110_398 VGND VGND VPWR VPWR sky130_fd_sc_hd__fill_4
X_3003_ _2998_/X _3002_/X _2995_/A VGND VGND VPWR VPWR _3003_/Y sky130_fd_sc_hd__o21ai_1
XFILLER_77_780 VGND VGND VPWR VPWR sky130_fd_sc_hd__fill_4
Xinput4 s_axil_araddr[2] VGND VGND VPWR VPWR input4/X sky130_fd_sc_hd__clkbuf_4
XANTENNA__4406__A0 _5047_/A1 VGND VGND VPWR VPWR sky130_fd_sc_hd__diode_2
XFILLER_25_839 VGND VGND VPWR VPWR sky130_fd_sc_hd__fill_1
XTAP_TAPCELL_ROW_35_823 VGND VPWR sky130_fd_sc_hd__tapvpwrvgnd_1
X_4954_ _4984_/A1 _4954_/A1 _4954_/S VGND VGND VPWR VPWR _4954_/X sky130_fd_sc_hd__mux2_1
XFILLER_24_338 VGND VGND VPWR VPWR sky130_fd_sc_hd__fill_2
XFILLER_40_809 VGND VGND VPWR VPWR sky130_fd_sc_hd__fill_2
X_3905_ hold307/X _5213_/A1 _3908_/S VGND VGND VPWR VPWR _3905_/X sky130_fd_sc_hd__mux2_1
X_4885_ _4885_/A0 _5818_/Q _4893_/S VGND VGND VPWR VPWR _4885_/X sky130_fd_sc_hd__mux2_1
XFILLER_20_533 VPWR VGND VPWR VGND sky130_ef_sc_hd__decap_40_12
XANTENNA__4709__B2 _4792_/A1 VGND VGND VPWR VPWR sky130_fd_sc_hd__diode_2
X_3836_ input7/X input8/X VGND VGND VPWR VPWR _3836_/Y sky130_fd_sc_hd__nand2_1
XANTENNA_fanout133_A _5811_/Q VGND VGND VPWR VPWR sky130_fd_sc_hd__diode_2
XFILLER_118_421 VGND VGND VPWR VPWR sky130_fd_sc_hd__fill_1
X_3767_ _4965_/A _3767_/B VGND VGND VPWR VPWR _3776_/S sky130_fd_sc_hd__or2_4
X_5506_ _6248_/CLK _5506_/D VGND VGND VPWR VPWR _5506_/Q sky130_fd_sc_hd__dfxtp_1
XPHY_EDGE_ROW_89_Left_228 VGND VGND VPWR VPWR sky130_fd_sc_hd__decap_3
X_2718_ _5428_/Q _5265_/Q VGND VGND VPWR VPWR _3156_/S sky130_fd_sc_hd__nand2b_4
X_3698_ hold238/X _5202_/A1 _3698_/S VGND VGND VPWR VPWR _3698_/X sky130_fd_sc_hd__mux2_1
X_2649_ _2649_/A VGND VGND VPWR VPWR _2649_/Y sky130_fd_sc_hd__inv_2
X_5437_ _6068_/CLK _5437_/D VGND VGND VPWR VPWR _5437_/Q sky130_fd_sc_hd__dfxtp_1
X_5368_ _6369_/CLK _5368_/D VGND VGND VPWR VPWR _5368_/Q sky130_fd_sc_hd__dfxtp_1
XFILLER_102_811 VGND VGND VPWR VPWR sky130_fd_sc_hd__fill_1
XFILLER_86_29 VGND VGND VPWR VPWR sky130_fd_sc_hd__fill_4
XANTENNA__3696__A1 _3926_/A1 VGND VGND VPWR VPWR sky130_fd_sc_hd__diode_2
XANTENNA__4975__Y _4984_/S VGND VGND VPWR VPWR sky130_fd_sc_hd__diode_2
X_5299_ _6366_/CLK _5299_/D VGND VGND VPWR VPWR _5299_/Q sky130_fd_sc_hd__dfxtp_1
XFILLER_114_693 VGND VGND VPWR VPWR sky130_fd_sc_hd__fill_4
X_4319_ hold87/X _5053_/A1 _4325_/S VGND VGND VPWR VPWR hold88/A sky130_fd_sc_hd__mux2_1
XFILLER_101_343 VGND VGND VPWR VPWR sky130_fd_sc_hd__fill_1
XTAP_TAPCELL_ROW_89_1629 VGND VPWR sky130_fd_sc_hd__tapvpwrvgnd_1
XFILLER_59_257 VGND VGND VPWR VPWR sky130_fd_sc_hd__fill_2
XANTENNA__3448__A1 _5235_/A0 VGND VGND VPWR VPWR sky130_fd_sc_hd__diode_2
XPHY_EDGE_ROW_98_Left_237 VGND VGND VPWR VPWR sky130_fd_sc_hd__decap_3
XFILLER_83_783 VGND VGND VPWR VPWR sky130_fd_sc_hd__fill_1
XFILLER_28_699 VGND VGND VPWR VPWR sky130_fd_sc_hd__fill_1
XANTENNA__5070__A0 _5238_/A1 VGND VGND VPWR VPWR sky130_fd_sc_hd__diode_2
XFILLER_43_669 VGND VGND VPWR VPWR sky130_fd_sc_hd__fill_2
XFILLER_31_809 VPWR VGND VPWR VGND sky130_ef_sc_hd__decap_40_12
XTAP_TAPCELL_ROW_100_1807 VGND VPWR sky130_fd_sc_hd__tapvpwrvgnd_1
XANTENNA__2959__B1 _3096_/A1 VGND VGND VPWR VPWR sky130_fd_sc_hd__diode_2
XFILLER_42_179 VGND VGND VPWR VPWR sky130_fd_sc_hd__fill_1
XFILLER_51_691 VGND VGND VPWR VPWR sky130_fd_sc_hd__fill_4
XFILLER_23_393 VPWR VGND VPWR VGND sky130_ef_sc_hd__decap_40_12
XFILLER_51_54 VGND VGND VPWR VPWR sky130_fd_sc_hd__fill_2
XFILLER_137_741 VPWR VGND VPWR VGND sky130_ef_sc_hd__decap_40_12
XFILLER_51_65 VGND VGND VPWR VPWR sky130_fd_sc_hd__fill_2
XFILLER_7_559 VGND VGND VPWR VPWR sky130_fd_sc_hd__fill_1
XANTENNA__4581__C1 _4811_/C1 VGND VGND VPWR VPWR sky130_fd_sc_hd__diode_2
XFILLER_137_785 VPWR VGND VPWR VGND sky130_ef_sc_hd__decap_40_12
XFILLER_3_721 VGND VGND VPWR VPWR sky130_fd_sc_hd__fill_4
XFILLER_98_809 VGND VGND VPWR VPWR sky130_fd_sc_hd__fill_2
XANTENNA__3136__B1 _5085_/A VGND VGND VPWR VPWR sky130_fd_sc_hd__diode_2
XFILLER_105_671 VGND VGND VPWR VPWR sky130_fd_sc_hd__fill_1
XFILLER_3_765 VPWR VGND VPWR VGND sky130_ef_sc_hd__decap_40_12
XFILLER_2_264 VGND VGND VPWR VPWR sky130_fd_sc_hd__fill_1
XFILLER_120_641 VGND VGND VPWR VPWR sky130_fd_sc_hd__fill_2
XTAP_TAPCELL_ROW_111_1969 VGND VPWR sky130_fd_sc_hd__tapvpwrvgnd_1
XTAP_TAPCELL_ROW_111_1958 VGND VPWR sky130_fd_sc_hd__tapvpwrvgnd_1
XANTENNA__4818__S _4828_/S VGND VGND VPWR VPWR sky130_fd_sc_hd__diode_2
XTAP_TAPCELL_ROW_53_1098 VGND VPWR sky130_fd_sc_hd__tapvpwrvgnd_1
XFILLER_38_419 VGND VGND VPWR VPWR sky130_fd_sc_hd__fill_1
XANTENNA__3439__A1 _4882_/A1 VGND VGND VPWR VPWR sky130_fd_sc_hd__diode_2
XFILLER_65_238 VGND VGND VPWR VPWR sky130_fd_sc_hd__fill_1
XANTENNA__4119__A _4149_/A VGND VGND VPWR VPWR sky130_fd_sc_hd__diode_2
XFILLER_46_463 VGND VGND VPWR VPWR sky130_fd_sc_hd__fill_1
XANTENNA__4553__S _4561_/S VGND VGND VPWR VPWR sky130_fd_sc_hd__diode_2
XANTENNA__3958__A _3958_/A VGND VGND VPWR VPWR sky130_fd_sc_hd__diode_2
XFILLER_22_809 VGND VGND VPWR VPWR sky130_fd_sc_hd__fill_2
XFILLER_34_658 VGND VGND VPWR VPWR sky130_fd_sc_hd__fill_1
XANTENNA__3611__A1 _5211_/A1 VGND VGND VPWR VPWR sky130_fd_sc_hd__diode_2
X_4670_ _4809_/A _4670_/B VGND VGND VPWR VPWR _4670_/Y sky130_fd_sc_hd__nor2_1
XANTENNA__4789__A _4789_/A VGND VGND VPWR VPWR sky130_fd_sc_hd__diode_2
X_3621_ hold25/X _4958_/A0 _3627_/S VGND VGND VPWR VPWR hold26/A sky130_fd_sc_hd__mux2_1
X_3552_ hold775/X _4964_/A0 _3552_/S VGND VGND VPWR VPWR _3552_/X sky130_fd_sc_hd__mux2_1
X_6340_ _6404_/CLK _6340_/D VGND VGND VPWR VPWR _6340_/Q sky130_fd_sc_hd__dfxtp_1
XFILLER_6_581 VGND VGND VPWR VPWR sky130_fd_sc_hd__fill_4
X_3483_ hold391/X _4899_/A0 _3490_/S VGND VGND VPWR VPWR _3483_/X sky130_fd_sc_hd__mux2_1
XFILLER_89_809 VPWR VGND VPWR VGND sky130_ef_sc_hd__decap_40_12
X_6271_ _6313_/CLK _6271_/D VGND VGND VPWR VPWR _6271_/Q sky130_fd_sc_hd__dfxtp_1
X_5222_ _5222_/A _5222_/B VGND VGND VPWR VPWR _6421_/D sky130_fd_sc_hd__or2_1
XPHY_EDGE_ROW_135_Right_135 VGND VGND VPWR VPWR sky130_fd_sc_hd__decap_3
X_5153_ _5839_/Q _5838_/Q _5194_/S VGND VGND VPWR VPWR _5153_/X sky130_fd_sc_hd__mux2_1
XANTENNA__4728__S _5401_/Q VGND VGND VPWR VPWR sky130_fd_sc_hd__diode_2
XFILLER_111_641 VPWR VGND VPWR VGND sky130_ef_sc_hd__decap_40_12
XFILLER_69_588 VGND VGND VPWR VPWR sky130_fd_sc_hd__fill_2
Xhold1705 _6333_/Q VGND VGND VPWR VPWR _5037_/A0 sky130_fd_sc_hd__dlygate4sd3_1
Xhold1716 _4939_/X VGND VGND VPWR VPWR _6275_/D sky130_fd_sc_hd__dlygate4sd3_1
X_4104_ _4104_/A0 _4104_/A1 hold375/X hold212/X _4237_/S _4251_/A VGND VGND VPWR VPWR
+ _4104_/X sky130_fd_sc_hd__mux4_1
XFILLER_111_685 VPWR VGND VPWR VGND sky130_ef_sc_hd__decap_40_12
Xhold1727 _5487_/Q VGND VGND VPWR VPWR _3436_/A0 sky130_fd_sc_hd__dlygate4sd3_1
Xhold1749 _3531_/X VGND VGND VPWR VPWR _5574_/D sky130_fd_sc_hd__dlygate4sd3_1
Xhold1738 _6202_/Q VGND VGND VPWR VPWR _4850_/A1 sky130_fd_sc_hd__dlygate4sd3_1
XANTENNA__4627__B1 _4792_/A1 VGND VGND VPWR VPWR sky130_fd_sc_hd__diode_2
X_5084_ _5048_/A _5219_/A _5083_/Y _5084_/B2 VGND VGND VPWR VPWR _5084_/X sky130_fd_sc_hd__o22a_1
X_4035_ _4251_/A _4035_/B VGND VGND VPWR VPWR _4035_/Y sky130_fd_sc_hd__nor2_1
XFILLER_2_81 VGND VGND VPWR VPWR sky130_fd_sc_hd__fill_2
XFILLER_112_27 VGND VGND VPWR VPWR sky130_fd_sc_hd__fill_1
XFILLER_71_219 VGND VGND VPWR VPWR sky130_fd_sc_hd__fill_4
XFILLER_65_783 VGND VGND VPWR VPWR sky130_fd_sc_hd__fill_1
XANTENNA__4463__S _4472_/S VGND VGND VPWR VPWR sky130_fd_sc_hd__diode_2
XTAP_TAPCELL_ROW_84_1559 VGND VPWR sky130_fd_sc_hd__tapvpwrvgnd_1
XFILLER_80_753 VGND VGND VPWR VPWR sky130_fd_sc_hd__fill_2
XFILLER_80_731 VGND VGND VPWR VPWR sky130_fd_sc_hd__fill_1
XFILLER_25_636 VGND VGND VPWR VPWR sky130_fd_sc_hd__fill_2
XFILLER_80_786 VPWR VGND VPWR VGND sky130_ef_sc_hd__decap_40_12
XFILLER_52_455 VGND VGND VPWR VPWR sky130_fd_sc_hd__fill_4
XFILLER_13_809 VPWR VGND VPWR VGND sky130_ef_sc_hd__decap_40_12
X_5986_ _6334_/CLK _5986_/D VGND VGND VPWR VPWR _5986_/Q sky130_fd_sc_hd__dfxtp_1
XANTENNA__3602__A1 _4961_/A0 VGND VGND VPWR VPWR sky130_fd_sc_hd__diode_2
XFILLER_12_319 VGND VGND VPWR VPWR sky130_fd_sc_hd__fill_2
X_4937_ _5052_/A1 _4937_/A1 _4944_/S VGND VGND VPWR VPWR _4937_/X sky130_fd_sc_hd__mux2_1
XFILLER_138_505 VPWR VGND VPWR VGND sky130_ef_sc_hd__decap_40_12
X_4868_ _4868_/A _4881_/B VGND VGND VPWR VPWR _4880_/S sky130_fd_sc_hd__nor2_8
XFILLER_119_741 VPWR VGND VPWR VGND sky130_ef_sc_hd__decap_40_12
X_3819_ _2666_/A _2665_/Y _3818_/S VGND VGND VPWR VPWR _3819_/X sky130_fd_sc_hd__a21bo_1
XFILLER_20_363 VGND VGND VPWR VPWR sky130_fd_sc_hd__fill_1
XTAP_TAPCELL_ROW_115_2025 VGND VPWR sky130_fd_sc_hd__tapvpwrvgnd_1
XTAP_TAPCELL_ROW_99_1791 VGND VPWR sky130_fd_sc_hd__tapvpwrvgnd_1
XTAP_TAPCELL_ROW_99_1780 VGND VPWR sky130_fd_sc_hd__tapvpwrvgnd_1
X_4799_ _4799_/A _4799_/B VGND VGND VPWR VPWR _4799_/Y sky130_fd_sc_hd__nor2_1
XANTENNA__2711__S _2716_/S VGND VGND VPWR VPWR sky130_fd_sc_hd__diode_2
XFILLER_119_785 VPWR VGND VPWR VGND sky130_ef_sc_hd__decap_40_12
XFILLER_4_529 VGND VGND VPWR VPWR sky130_fd_sc_hd__fill_2
XFILLER_21_57 VGND VGND VPWR VPWR sky130_fd_sc_hd__fill_2
XFILLER_137_57 VPWR VGND VPWR VGND sky130_ef_sc_hd__decap_40_12
XFILLER_134_755 VGND VGND VPWR VPWR sky130_fd_sc_hd__fill_1
XFILLER_106_435 VGND VGND VPWR VPWR sky130_fd_sc_hd__fill_1
XANTENNA__4866__A0 _4905_/A0 VGND VGND VPWR VPWR sky130_fd_sc_hd__diode_2
XFILLER_0_713 VPWR VGND VPWR VGND sky130_ef_sc_hd__decap_40_12
XANTENNA__2947__A _3005_/A VGND VGND VPWR VPWR sky130_fd_sc_hd__diode_2
XPHY_EDGE_ROW_102_Right_102 VGND VGND VPWR VPWR sky130_fd_sc_hd__decap_3
XFILLER_102_641 VGND VGND VPWR VPWR sky130_fd_sc_hd__fill_2
XFILLER_0_757 VPWR VGND VPWR VGND sky130_ef_sc_hd__decap_40_12
XFILLER_75_536 VGND VGND VPWR VPWR sky130_fd_sc_hd__fill_4
XFILLER_47_227 VGND VGND VPWR VPWR sky130_fd_sc_hd__fill_2
XTAP_TAPCELL_ROW_126_2187 VGND VPWR sky130_fd_sc_hd__tapvpwrvgnd_1
XFILLER_16_625 VPWR VGND VPWR VGND sky130_ef_sc_hd__decap_40_12
XFILLER_28_485 VGND VGND VPWR VPWR sky130_fd_sc_hd__fill_2
XANTENNA__2682__A _2682_/A VGND VGND VPWR VPWR sky130_fd_sc_hd__diode_2
XFILLER_15_113 VGND VGND VPWR VPWR sky130_fd_sc_hd__fill_1
XFILLER_102_82 VGND VGND VPWR VPWR sky130_fd_sc_hd__fill_2
XFILLER_16_669 VPWR VGND VPWR VGND sky130_ef_sc_hd__decap_40_12
XFILLER_102_93 VGND VGND VPWR VPWR sky130_fd_sc_hd__fill_1
XTAP_TAPCELL_ROW_26_686 VGND VPWR sky130_fd_sc_hd__tapvpwrvgnd_1
XTAP_TAPCELL_ROW_26_697 VGND VPWR sky130_fd_sc_hd__tapvpwrvgnd_1
XFILLER_129_505 VPWR VGND VPWR VGND sky130_ef_sc_hd__decap_40_12
XANTENNA__2801__C1 _3089_/C1 VGND VGND VPWR VPWR sky130_fd_sc_hd__diode_2
XANTENNA__5169__A1_N _3958_/A VGND VGND VPWR VPWR sky130_fd_sc_hd__diode_2
XFILLER_8_813 VPWR VGND VPWR VGND sky130_ef_sc_hd__decap_40_12
XFILLER_11_330 VGND VGND VPWR VPWR sky130_fd_sc_hd__fill_4
XFILLER_7_15 VPWR VGND VPWR VGND sky130_ef_sc_hd__decap_40_12
XFILLER_7_59 VGND VGND VPWR VPWR sky130_fd_sc_hd__fill_1
XFILLER_7_389 VGND VGND VPWR VPWR sky130_fd_sc_hd__fill_2
XFILLER_125_777 VGND VGND VPWR VPWR sky130_fd_sc_hd__fill_4
XANTENNA__4857__A0 _4883_/A1 VGND VGND VPWR VPWR sky130_fd_sc_hd__diode_2
XTAP_TAPCELL_ROW_55_1127 VGND VPWR sky130_fd_sc_hd__tapvpwrvgnd_1
XFILLER_3_573 VPWR VGND VPWR VGND sky130_ef_sc_hd__decap_40_12
XANTENNA__3452__S _3463_/S VGND VGND VPWR VPWR sky130_fd_sc_hd__diode_2
XFILLER_19_441 VGND VGND VPWR VPWR sky130_fd_sc_hd__fill_4
XFILLER_19_485 VPWR VGND VPWR VGND sky130_ef_sc_hd__decap_40_12
X_5840_ _6065_/CLK _5840_/D VGND VGND VPWR VPWR _5840_/Q sky130_fd_sc_hd__dfxtp_2
XFILLER_62_786 VPWR VGND VPWR VGND sky130_ef_sc_hd__decap_40_12
XTAP_TAPCELL_ROW_45_973 VGND VPWR sky130_fd_sc_hd__tapvpwrvgnd_1
X_2983_ hold518/X _3217_/A1 hold284/X hold353/X _2984_/S _2985_/A VGND VGND VPWR VPWR
+ _2983_/X sky130_fd_sc_hd__mux4_1
XTAP_TAPCELL_ROW_66_1289 VGND VPWR sky130_fd_sc_hd__tapvpwrvgnd_1
X_5771_ _6310_/CLK _5771_/D VGND VGND VPWR VPWR _5771_/Q sky130_fd_sc_hd__dfxtp_1
X_4722_ _5698_/Q _5902_/Q _4808_/S VGND VGND VPWR VPWR _4722_/X sky130_fd_sc_hd__mux2_1
X_4653_ _4792_/A1 _4648_/X _4650_/X _4652_/X VGND VGND VPWR VPWR _4653_/X sky130_fd_sc_hd__a22o_1
XANTENNA__3899__A1 _6406_/Q VGND VGND VPWR VPWR sky130_fd_sc_hd__diode_2
X_3604_ _3604_/A0 _5215_/A1 _3605_/S VGND VGND VPWR VPWR _3604_/X sky130_fd_sc_hd__mux2_1
Xhold802 _4293_/X VGND VGND VPWR VPWR _5944_/D sky130_fd_sc_hd__dlygate4sd3_1
X_4584_ _4809_/A _4584_/B VGND VGND VPWR VPWR _4584_/Y sky130_fd_sc_hd__nor2_1
Xhold835 _5406_/Q VGND VGND VPWR VPWR hold835/X sky130_fd_sc_hd__dlygate4sd3_1
Xhold846 _3118_/X VGND VGND VPWR VPWR _5311_/D sky130_fd_sc_hd__dlygate4sd3_1
XFILLER_116_755 VGND VGND VPWR VPWR sky130_fd_sc_hd__fill_1
X_3535_ _3535_/A0 _5075_/A0 _3541_/S VGND VGND VPWR VPWR _3535_/X sky130_fd_sc_hd__mux2_1
Xhold824 _3191_/X VGND VGND VPWR VPWR _5354_/D sky130_fd_sc_hd__dlygate4sd3_1
Xhold813 _5620_/Q VGND VGND VPWR VPWR hold813/X sky130_fd_sc_hd__dlygate4sd3_1
X_6323_ _6404_/CLK _6323_/D VGND VGND VPWR VPWR _6323_/Q sky130_fd_sc_hd__dfxtp_1
Xhold857 _5504_/Q VGND VGND VPWR VPWR hold857/X sky130_fd_sc_hd__dlygate4sd3_1
XFILLER_131_725 VGND VGND VPWR VPWR sky130_fd_sc_hd__fill_2
X_3466_ _5238_/A1 _3466_/A1 _3477_/S VGND VGND VPWR VPWR _3466_/X sky130_fd_sc_hd__mux2_1
X_6254_ _6254_/CLK _6254_/D VGND VGND VPWR VPWR _6254_/Q sky130_fd_sc_hd__dfxtp_1
XFILLER_107_27 VPWR VGND VPWR VGND sky130_ef_sc_hd__decap_40_12
Xhold879 _5846_/Q VGND VGND VPWR VPWR hold879/X sky130_fd_sc_hd__dlygate4sd3_1
Xhold868 _2925_/X VGND VGND VPWR VPWR _5289_/D sky130_fd_sc_hd__dlygate4sd3_1
XFILLER_103_449 VGND VGND VPWR VPWR sky130_fd_sc_hd__fill_1
XFILLER_88_149 VGND VGND VPWR VPWR sky130_fd_sc_hd__fill_1
XANTENNA__4848__A0 _4887_/A1 VGND VGND VPWR VPWR sky130_fd_sc_hd__diode_2
Xhold2203 _3240_/Y VGND VGND VPWR VPWR _5383_/D sky130_fd_sc_hd__dlygate4sd3_1
X_5205_ hold1/X _6419_/Q _6408_/Q VGND VGND VPWR VPWR _5205_/Y sky130_fd_sc_hd__a21boi_1
XANTENNA__3520__A0 _4445_/A VGND VGND VPWR VPWR sky130_fd_sc_hd__diode_2
X_6185_ _6233_/CLK _6185_/D VGND VGND VPWR VPWR _6185_/Q sky130_fd_sc_hd__dfxtp_1
Xhold2236 _5812_/Q VGND VGND VPWR VPWR hold2236/X sky130_fd_sc_hd__dlygate4sd3_1
Xhold2225 _5825_/Q VGND VGND VPWR VPWR hold2225/X sky130_fd_sc_hd__dlygate4sd3_1
Xhold2214 _3266_/Y VGND VGND VPWR VPWR _3268_/B sky130_fd_sc_hd__dlygate4sd3_1
X_3397_ hold547/X _5043_/A1 _3401_/S VGND VGND VPWR VPWR _3397_/X sky130_fd_sc_hd__mux2_1
XFILLER_123_15 VPWR VGND VPWR VGND sky130_ef_sc_hd__decap_40_12
Xhold1524 _4905_/X VGND VGND VPWR VPWR _6253_/D sky130_fd_sc_hd__dlygate4sd3_1
Xhold1535 _5536_/Q VGND VGND VPWR VPWR _3490_/A0 sky130_fd_sc_hd__dlygate4sd3_1
Xhold1513 _5532_/Q VGND VGND VPWR VPWR _3486_/A0 sky130_fd_sc_hd__dlygate4sd3_1
XFILLER_111_460 VGND VGND VPWR VPWR sky130_fd_sc_hd__fill_1
Xhold2258 _5251_/Q VGND VGND VPWR VPWR _3207_/A sky130_fd_sc_hd__dlygate4sd3_1
X_5136_ _3941_/B _5160_/A _5135_/Y _5034_/B VGND VGND VPWR VPWR _5136_/X sky130_fd_sc_hd__o211a_1
Xhold2247 _5384_/Q VGND VGND VPWR VPWR _3668_/B sky130_fd_sc_hd__dlygate4sd3_1
Xhold1502 _6043_/Q VGND VGND VPWR VPWR _4405_/A1 sky130_fd_sc_hd__dlygate4sd3_1
Xhold1568 _6098_/Q VGND VGND VPWR VPWR _4492_/A1 sky130_fd_sc_hd__dlygate4sd3_1
X_5067_ _5067_/A0 _5067_/A1 _5207_/S VGND VGND VPWR VPWR _5067_/X sky130_fd_sc_hd__mux2_1
Xhold1557 _6010_/Q VGND VGND VPWR VPWR _4369_/A1 sky130_fd_sc_hd__dlygate4sd3_1
Xhold1546 _4946_/X VGND VGND VPWR VPWR _6281_/D sky130_fd_sc_hd__dlygate4sd3_1
XTAP_TAPCELL_ROW_4_359 VGND VPWR sky130_fd_sc_hd__tapvpwrvgnd_1
Xhold1579 _4416_/X VGND VGND VPWR VPWR _6053_/D sky130_fd_sc_hd__dlygate4sd3_1
X_4018_ _4013_/B _3958_/Y _4017_/X _5200_/A VGND VGND VPWR VPWR _4018_/X sky130_fd_sc_hd__o211a_1
XFILLER_52_230 VGND VGND VPWR VPWR sky130_fd_sc_hd__fill_1
XFILLER_13_617 VPWR VGND VPWR VGND sky130_ef_sc_hd__decap_40_12
XFILLER_53_797 VPWR VGND VPWR VGND sky130_ef_sc_hd__decap_40_12
XFILLER_25_499 VGND VGND VPWR VPWR sky130_fd_sc_hd__fill_4
X_5969_ clkload7/A _5969_/D VGND VGND VPWR VPWR _5969_/Q sky130_fd_sc_hd__dfxtp_1
XTAP_TAPCELL_ROW_23_645 VGND VPWR sky130_fd_sc_hd__tapvpwrvgnd_1
XANTENNA__3537__S _3541_/S VGND VGND VPWR VPWR sky130_fd_sc_hd__diode_2
XANTENNA__4222__A _4263_/A VGND VGND VPWR VPWR sky130_fd_sc_hd__diode_2
XFILLER_4_315 VGND VGND VPWR VPWR sky130_fd_sc_hd__fill_2
XFILLER_4_304 VGND VGND VPWR VPWR sky130_fd_sc_hd__fill_4
XFILLER_106_3 VPWR VGND VPWR VGND sky130_ef_sc_hd__decap_40_12
XFILLER_122_725 VPWR VGND VPWR VGND sky130_ef_sc_hd__decap_40_12
XFILLER_107_777 VGND VGND VPWR VPWR sky130_fd_sc_hd__fill_4
XFILLER_134_585 VGND VGND VPWR VPWR sky130_fd_sc_hd__fill_2
XANTENNA__4839__A0 _4904_/A0 VGND VGND VPWR VPWR sky130_fd_sc_hd__diode_2
XTAP_TAPCELL_ROW_128_2216 VGND VPWR sky130_fd_sc_hd__tapvpwrvgnd_1
XFILLER_122_769 VPWR VGND VPWR VGND sky130_ef_sc_hd__decap_40_12
XFILLER_95_609 VGND VGND VPWR VPWR sky130_fd_sc_hd__fill_4
XANTENNA__3511__A0 _5232_/A0 VGND VGND VPWR VPWR sky130_fd_sc_hd__diode_2
XTAP_TAPCELL_ROW_128_2227 VGND VPWR sky130_fd_sc_hd__tapvpwrvgnd_1
XTAP_TAPCELL_ROW_50_1046 VGND VPWR sky130_fd_sc_hd__tapvpwrvgnd_1
XFILLER_0_587 VGND VGND VPWR VPWR sky130_fd_sc_hd__fill_1
XANTENNA_input26_A s_axil_wdata[8] VGND VGND VPWR VPWR sky130_fd_sc_hd__diode_2
XTAP_TAPCELL_ROW_50_1057 VGND VPWR sky130_fd_sc_hd__tapvpwrvgnd_1
XFILLER_91_837 VGND VGND VPWR VPWR sky130_fd_sc_hd__fill_2
XFILLER_75_388 VGND VGND VPWR VPWR sky130_fd_sc_hd__fill_4
XFILLER_75_366 VGND VGND VPWR VPWR sky130_fd_sc_hd__fill_2
XFILLER_29_783 VGND VGND VPWR VPWR sky130_fd_sc_hd__fill_1
XANTENNA__4067__A1 _4264_/A1 VGND VGND VPWR VPWR sky130_fd_sc_hd__diode_2
XANTENNA__3814__A1 _4886_/A1 VGND VGND VPWR VPWR sky130_fd_sc_hd__diode_2
XFILLER_16_433 VPWR VGND VPWR VGND sky130_ef_sc_hd__decap_40_12
XFILLER_71_561 VGND VGND VPWR VPWR sky130_fd_sc_hd__fill_4
XTAP_TAPCELL_ROW_42_932 VGND VPWR sky130_fd_sc_hd__tapvpwrvgnd_1
XFILLER_16_477 VPWR VGND VPWR VGND sky130_ef_sc_hd__decap_40_12
XFILLER_31_403 VPWR VGND VPWR VGND sky130_ef_sc_hd__decap_40_12
XANTENNA__4831__S _4841_/S VGND VGND VPWR VPWR sky130_fd_sc_hd__diode_2
XFILLER_43_296 VGND VGND VPWR VPWR sky130_fd_sc_hd__fill_1
XANTENNA__3447__S _3450_/S VGND VGND VPWR VPWR sky130_fd_sc_hd__diode_2
XFILLER_8_643 VGND VGND VPWR VPWR sky130_fd_sc_hd__fill_1
XFILLER_125_541 VPWR VGND VPWR VGND sky130_ef_sc_hd__decap_40_12
Xhold109 _5931_/Q VGND VGND VPWR VPWR hold109/X sky130_fd_sc_hd__dlygate4sd3_1
X_3320_ _5333_/Q _3320_/B VGND VGND VPWR VPWR _3320_/X sky130_fd_sc_hd__xor2_1
XANTENNA__3750__A0 _4929_/A1 VGND VGND VPWR VPWR sky130_fd_sc_hd__diode_2
XFILLER_125_585 VPWR VGND VPWR VGND sky130_ef_sc_hd__decap_40_12
XFILLER_113_725 VGND VGND VPWR VPWR sky130_fd_sc_hd__fill_2
XANTENNA__3502__A0 _4905_/A0 VGND VGND VPWR VPWR sky130_fd_sc_hd__diode_2
X_3251_ hold877/X _5919_/Q _3258_/S VGND VGND VPWR VPWR _3251_/X sky130_fd_sc_hd__mux2_1
X_3182_ hold544/X _4882_/A1 _3193_/S VGND VGND VPWR VPWR _5345_/D sky130_fd_sc_hd__mux2_1
XANTENNA_hold2228_A _5826_/Q VGND VGND VPWR VPWR sky130_fd_sc_hd__diode_2
XFILLER_21_3 VPWR VGND VPWR VGND sky130_ef_sc_hd__decap_40_12
XFILLER_66_344 VGND VGND VPWR VPWR sky130_fd_sc_hd__fill_8
XFILLER_94_697 VGND VGND VPWR VPWR sky130_fd_sc_hd__fill_2
XFILLER_82_837 VGND VGND VPWR VPWR sky130_fd_sc_hd__fill_4
XTAP_TAPCELL_ROW_68_1318 VGND VPWR sky130_fd_sc_hd__tapvpwrvgnd_1
XANTENNA__3689__Y _3698_/S VGND VGND VPWR VPWR sky130_fd_sc_hd__diode_2
XTAP_TAPCELL_ROW_1_318 VGND VPWR sky130_fd_sc_hd__tapvpwrvgnd_1
XANTENNA__3805__A1 _5232_/A0 VGND VGND VPWR VPWR sky130_fd_sc_hd__diode_2
XTAP_TAPCELL_ROW_81_1518 VGND VPWR sky130_fd_sc_hd__tapvpwrvgnd_1
X_5823_ _6338_/CLK _5823_/D VGND VGND VPWR VPWR _5823_/Q sky130_fd_sc_hd__dfxtp_2
XFILLER_35_797 VPWR VGND VPWR VGND sky130_ef_sc_hd__decap_40_12
X_2966_ _2962_/X _2964_/X _2965_/X _3089_/C1 VGND VGND VPWR VPWR _2966_/X sky130_fd_sc_hd__a22o_1
X_5754_ _6399_/CLK _5754_/D VGND VGND VPWR VPWR _5754_/Q sky130_fd_sc_hd__dfxtp_1
XTAP_TAPCELL_ROW_20_604 VGND VPWR sky130_fd_sc_hd__tapvpwrvgnd_1
XFILLER_22_469 VGND VGND VPWR VPWR sky130_fd_sc_hd__fill_4
X_2897_ hold807/X _3011_/A _2896_/X VGND VGND VPWR VPWR _2897_/X sky130_fd_sc_hd__a21o_1
X_4705_ hold471/X _6295_/Q _4790_/S VGND VGND VPWR VPWR _4706_/B sky130_fd_sc_hd__mux2_1
X_5685_ _6094_/CLK _5685_/D VGND VGND VPWR VPWR _5685_/Q sky130_fd_sc_hd__dfxtp_1
XANTENNA__2792__A1 _3036_/A1 VGND VGND VPWR VPWR sky130_fd_sc_hd__diode_2
XFILLER_118_15 VPWR VGND VPWR VGND sky130_ef_sc_hd__decap_40_12
X_4636_ hold139/X _4636_/A1 _4801_/S VGND VGND VPWR VPWR _4636_/X sky130_fd_sc_hd__mux2_1
Xhold610 _5945_/Q VGND VGND VPWR VPWR hold610/X sky130_fd_sc_hd__dlygate4sd3_1
Xhold621 _5965_/Q VGND VGND VPWR VPWR hold621/X sky130_fd_sc_hd__dlygate4sd3_1
Xhold654 _4892_/X VGND VGND VPWR VPWR _6241_/D sky130_fd_sc_hd__dlygate4sd3_1
Xhold632 _3574_/X VGND VGND VPWR VPWR _5611_/D sky130_fd_sc_hd__dlygate4sd3_1
X_4567_ _4792_/A1 _4562_/X _4564_/X _4566_/X VGND VGND VPWR VPWR _4567_/X sky130_fd_sc_hd__a22o_1
XTAP_TAPCELL_ROW_9_429 VGND VPWR sky130_fd_sc_hd__tapvpwrvgnd_1
X_6306_ _6315_/CLK _6306_/D VGND VGND VPWR VPWR _6306_/Q sky130_fd_sc_hd__dfxtp_1
Xhold643 _6117_/Q VGND VGND VPWR VPWR hold643/X sky130_fd_sc_hd__dlygate4sd3_1
X_3518_ _5238_/A1 _3518_/A1 _3529_/S VGND VGND VPWR VPWR _3518_/X sky130_fd_sc_hd__mux2_1
XFILLER_116_585 VGND VGND VPWR VPWR sky130_fd_sc_hd__fill_2
XFILLER_104_725 VPWR VGND VPWR VGND sky130_ef_sc_hd__decap_40_12
Xhold665 _5276_/Q VGND VGND VPWR VPWR hold665/X sky130_fd_sc_hd__dlygate4sd3_1
Xhold676 _3400_/X VGND VGND VPWR VPWR _5457_/D sky130_fd_sc_hd__dlygate4sd3_1
XFILLER_1_318 VPWR VGND VPWR VGND sky130_ef_sc_hd__decap_40_12
X_4498_ hold49/X _5212_/A1 _4502_/S VGND VGND VPWR VPWR hold50/A sky130_fd_sc_hd__mux2_1
Xhold687 _4324_/X VGND VGND VPWR VPWR _5971_/D sky130_fd_sc_hd__dlygate4sd3_1
XFILLER_104_769 VPWR VGND VPWR VGND sky130_ef_sc_hd__decap_40_12
X_3449_ hold175/X _5080_/A0 _3450_/S VGND VGND VPWR VPWR _3449_/X sky130_fd_sc_hd__mux2_1
X_6237_ _6237_/CLK _6237_/D VGND VGND VPWR VPWR _6237_/Q sky130_fd_sc_hd__dfxtp_1
Xhold2000 _6396_/Q VGND VGND VPWR VPWR _3944_/A sky130_fd_sc_hd__dlygate4sd3_1
Xhold2011 _3262_/X VGND VGND VPWR VPWR _5396_/D sky130_fd_sc_hd__dlygate4sd3_1
XANTENNA__4297__A1 _5040_/A1 VGND VGND VPWR VPWR sky130_fd_sc_hd__diode_2
Xhold698 _5445_/Q VGND VGND VPWR VPWR hold698/X sky130_fd_sc_hd__dlygate4sd3_1
XFILLER_103_279 VGND VGND VPWR VPWR sky130_fd_sc_hd__fill_1
Xhold2033 _5061_/X VGND VGND VPWR VPWR _6353_/D sky130_fd_sc_hd__dlygate4sd3_1
X_6168_ _6292_/CLK _6168_/D VGND VGND VPWR VPWR _6168_/Q sky130_fd_sc_hd__dfxtp_1
Xhold2022 _5402_/Q VGND VGND VPWR VPWR _3228_/A sky130_fd_sc_hd__dlygate4sd3_1
Xhold2044 _5926_/Q VGND VGND VPWR VPWR _4248_/B1 sky130_fd_sc_hd__dlygate4sd3_1
XFILLER_94_29 VGND VGND VPWR VPWR sky130_fd_sc_hd__fill_8
Xhold2088 _6259_/Q VGND VGND VPWR VPWR _5185_/A1 sky130_fd_sc_hd__dlygate4sd3_1
Xhold2077 _2721_/B VGND VGND VPWR VPWR _2719_/A2 sky130_fd_sc_hd__dlygate4sd3_1
Xhold1321 _3551_/X VGND VGND VPWR VPWR _5592_/D sky130_fd_sc_hd__dlygate4sd3_1
Xhold2055 _6418_/Q VGND VGND VPWR VPWR _5216_/A sky130_fd_sc_hd__dlygate4sd3_1
X_5119_ _5918_/Q _5917_/Q _5916_/Q _5915_/Q VGND VGND VPWR VPWR _5119_/Y sky130_fd_sc_hd__nand4_1
Xhold1310 _6334_/Q VGND VGND VPWR VPWR _5039_/A0 sky130_fd_sc_hd__dlygate4sd3_1
Xhold1343 _3765_/X VGND VGND VPWR VPWR _5776_/D sky130_fd_sc_hd__dlygate4sd3_1
Xhold1332 _5713_/Q VGND VGND VPWR VPWR _3692_/A0 sky130_fd_sc_hd__dlygate4sd3_1
Xhold2066 _5436_/Q VGND VGND VPWR VPWR _5209_/A0 sky130_fd_sc_hd__dlygate4sd3_1
Xhold1365 _5561_/Q VGND VGND VPWR VPWR _3518_/A1 sky130_fd_sc_hd__dlygate4sd3_1
Xhold1354 _4861_/X VGND VGND VPWR VPWR _6212_/D sky130_fd_sc_hd__dlygate4sd3_1
Xhold2099 _6390_/Q VGND VGND VPWR VPWR _5127_/A sky130_fd_sc_hd__dlygate4sd3_1
Xhold1376 _5041_/X VGND VGND VPWR VPWR _6336_/D sky130_fd_sc_hd__dlygate4sd3_1
XTAP_TAPCELL_ROW_28_715 VGND VPWR sky130_fd_sc_hd__tapvpwrvgnd_1
X_6099_ _6114_/CLK _6099_/D VGND VGND VPWR VPWR _6099_/Q sky130_fd_sc_hd__dfxtp_1
XTAP_TAPCELL_ROW_123_2146 VGND VPWR sky130_fd_sc_hd__tapvpwrvgnd_1
Xhold1398 _3419_/X VGND VGND VPWR VPWR _5472_/D sky130_fd_sc_hd__dlygate4sd3_1
Xhold1387 _6301_/Q VGND VGND VPWR VPWR _4968_/A1 sky130_fd_sc_hd__dlygate4sd3_1
XANTENNA__4144__S1 _4241_/A VGND VGND VPWR VPWR sky130_fd_sc_hd__diode_2
XTAP_TAPCELL_ROW_28_726 VGND VPWR sky130_fd_sc_hd__tapvpwrvgnd_1
XFILLER_43_55 VGND VGND VPWR VPWR sky130_fd_sc_hd__fill_1
XFILLER_13_447 VGND VGND VPWR VPWR sky130_fd_sc_hd__fill_1
XFILLER_40_222 VGND VGND VPWR VPWR sky130_fd_sc_hd__fill_1
XFILLER_9_429 VPWR VGND VPWR VGND sky130_ef_sc_hd__decap_40_12
XFILLER_40_255 VGND VGND VPWR VPWR sky130_fd_sc_hd__fill_1
XFILLER_127_839 VGND VGND VPWR VPWR sky130_fd_sc_hd__fill_1
XFILLER_5_613 VGND VGND VPWR VPWR sky130_fd_sc_hd__fill_2
XFILLER_138_187 VGND VGND VPWR VPWR sky130_fd_sc_hd__fill_2
XANTENNA__3732__B1 _5200_/A VGND VGND VPWR VPWR sky130_fd_sc_hd__diode_2
XFILLER_122_533 VPWR VGND VPWR VGND sky130_ef_sc_hd__decap_40_12
XFILLER_108_70 VGND VGND VPWR VPWR sky130_fd_sc_hd__fill_1
XFILLER_107_585 VPWR VGND VPWR VGND sky130_ef_sc_hd__decap_40_12
XFILLER_4_27 VGND VGND VPWR VPWR sky130_fd_sc_hd__fill_1
XFILLER_1_841 VGND VGND VPWR VPWR sky130_fd_sc_hd__fill_1
XANTENNA__4288__A1 _4978_/A1 VGND VGND VPWR VPWR sky130_fd_sc_hd__diode_2
XANTENNA__4826__S _4828_/S VGND VGND VPWR VPWR sky130_fd_sc_hd__diode_2
XANTENNA__5237__A0 _5237_/A0 VGND VGND VPWR VPWR sky130_fd_sc_hd__diode_2
XTAP_TAPCELL_ROW_108_1919 VGND VPWR sky130_fd_sc_hd__tapvpwrvgnd_1
XFILLER_17_753 VPWR VGND VPWR VGND sky130_ef_sc_hd__decap_40_12
XFILLER_17_797 VPWR VGND VPWR VGND sky130_ef_sc_hd__decap_40_12
XANTENNA__4561__S _4561_/S VGND VGND VPWR VPWR sky130_fd_sc_hd__diode_2
XFILLER_71_391 VGND VGND VPWR VPWR sky130_fd_sc_hd__fill_1
XTAP_TAPCELL_ROW_63_1248 VGND VPWR sky130_fd_sc_hd__tapvpwrvgnd_1
X_2820_ _5515_/Q _5527_/Q _3077_/S VGND VGND VPWR VPWR _2820_/X sky130_fd_sc_hd__mux2_1
X_2751_ hold688/X _5235_/A0 _2753_/S VGND VGND VPWR VPWR _2751_/X sky130_fd_sc_hd__mux2_1
X_2682_ _2682_/A _2682_/B _4868_/A VGND VGND VPWR VPWR _5251_/D sky130_fd_sc_hd__and3_1
X_5470_ _6294_/CLK _5470_/D VGND VGND VPWR VPWR _5470_/Q sky130_fd_sc_hd__dfxtp_1
XFILLER_8_473 VGND VGND VPWR VPWR sky130_fd_sc_hd__fill_2
XFILLER_133_809 VPWR VGND VPWR VGND sky130_ef_sc_hd__decap_40_12
XFILLER_129_187 VGND VGND VPWR VPWR sky130_fd_sc_hd__fill_1
X_4421_ _5833_/Q input5/X input4/X VGND VGND VPWR VPWR _4421_/X sky130_fd_sc_hd__and3_1
X_4352_ hold805/X _4980_/A1 _4356_/S VGND VGND VPWR VPWR _4352_/X sky130_fd_sc_hd__mux2_1
X_3303_ _3303_/A0 _5232_/A0 _3308_/S VGND VGND VPWR VPWR _3303_/X sky130_fd_sc_hd__mux2_1
XANTENNA__4279__A1 _5042_/A1 VGND VGND VPWR VPWR sky130_fd_sc_hd__diode_2
X_4283_ hold169/X _5046_/A1 _4284_/S VGND VGND VPWR VPWR _4283_/X sky130_fd_sc_hd__mux2_1
X_3234_ _3606_/B _3234_/B VGND VGND VPWR VPWR _5381_/D sky130_fd_sc_hd__nor2_1
X_6022_ _6349_/CLK _6022_/D VGND VGND VPWR VPWR _6022_/Q sky130_fd_sc_hd__dfxtp_1
XANTENNA__5228__A0 _5228_/A0 VGND VGND VPWR VPWR sky130_fd_sc_hd__diode_2
XFILLER_66_163 VGND VGND VPWR VPWR sky130_fd_sc_hd__fill_2
X_3165_ _4213_/S _3167_/C _3164_/Y VGND VGND VPWR VPWR _5339_/D sky130_fd_sc_hd__o21a_1
X_3096_ _3096_/A1 _3095_/X _3094_/X VGND VGND VPWR VPWR _3096_/Y sky130_fd_sc_hd__a21oi_1
XFILLER_82_645 VGND VGND VPWR VPWR sky130_fd_sc_hd__fill_1
XFILLER_55_837 VGND VGND VPWR VPWR sky130_fd_sc_hd__fill_2
XFILLER_54_369 VGND VGND VPWR VPWR sky130_fd_sc_hd__fill_8
XFILLER_42_509 VGND VGND VPWR VPWR sky130_fd_sc_hd__fill_1
XANTENNA_fanout163_A _4178_/A VGND VGND VPWR VPWR sky130_fd_sc_hd__diode_2
XFILLER_120_27 VGND VGND VPWR VPWR sky130_fd_sc_hd__fill_1
XFILLER_35_561 VGND VGND VPWR VPWR sky130_fd_sc_hd__fill_2
XANTENNA__4471__S _4472_/S VGND VGND VPWR VPWR sky130_fd_sc_hd__diode_2
X_5806_ _5820_/CLK _5806_/D VGND VGND VPWR VPWR _6461_/A sky130_fd_sc_hd__dfxtp_1
Xfanout59 _5123_/X VGND VGND VPWR VPWR _5194_/S sky130_fd_sc_hd__clkbuf_8
X_3998_ _5037_/A0 _3998_/B VGND VGND VPWR VPWR _3998_/Y sky130_fd_sc_hd__nand2b_1
XFILLER_10_417 VGND VGND VPWR VPWR sky130_fd_sc_hd__fill_2
XANTENNA__4203__A1 _4260_/S VGND VGND VPWR VPWR sky130_fd_sc_hd__diode_2
X_2949_ _3036_/A1 _2948_/X _3094_/C1 VGND VGND VPWR VPWR _2949_/Y sky130_fd_sc_hd__o21ai_1
X_5737_ _5784_/CLK _5737_/D VGND VGND VPWR VPWR _5737_/Q sky130_fd_sc_hd__dfxtp_1
XFILLER_22_299 VGND VGND VPWR VPWR sky130_fd_sc_hd__fill_2
XTAP_TAPCELL_ROW_33_795 VGND VPWR sky130_fd_sc_hd__tapvpwrvgnd_1
XFILLER_136_625 VPWR VGND VPWR VGND sky130_ef_sc_hd__decap_40_12
XANTENNA__2765__B2 _2641_/Y VGND VGND VPWR VPWR sky130_fd_sc_hd__diode_2
XFILLER_109_839 VGND VGND VPWR VPWR sky130_fd_sc_hd__fill_1
XPHY_EDGE_ROW_70_Left_209 VGND VGND VPWR VPWR sky130_fd_sc_hd__decap_3
XFILLER_124_809 VGND VGND VPWR VPWR sky130_fd_sc_hd__fill_2
XTAP_TAPCELL_ROW_94_1709 VGND VPWR sky130_fd_sc_hd__tapvpwrvgnd_1
X_5668_ _5714_/CLK _5668_/D VGND VGND VPWR VPWR _5668_/Q sky130_fd_sc_hd__dfxtp_1
XFILLER_136_669 VPWR VGND VPWR VGND sky130_ef_sc_hd__decap_40_12
X_5599_ _6292_/CLK _5599_/D VGND VGND VPWR VPWR _5599_/Q sky130_fd_sc_hd__dfxtp_1
X_4619_ hold226/X _4958_/A1 _4773_/S VGND VGND VPWR VPWR _4620_/B sky130_fd_sc_hd__mux2_1
XANTENNA__4062__S0 _4228_/S VGND VGND VPWR VPWR sky130_fd_sc_hd__diode_2
Xhold451 _6149_/Q VGND VGND VPWR VPWR hold451/X sky130_fd_sc_hd__dlygate4sd3_1
XANTENNA__4911__C1 _5176_/A VGND VGND VPWR VPWR sky130_fd_sc_hd__diode_2
Xhold462 _3612_/X VGND VGND VPWR VPWR _5643_/D sky130_fd_sc_hd__dlygate4sd3_1
Xhold440 _4299_/X VGND VGND VPWR VPWR _5949_/D sky130_fd_sc_hd__dlygate4sd3_1
XFILLER_104_533 VPWR VGND VPWR VGND sky130_ef_sc_hd__decap_40_12
XANTENNA__3190__A1 _5234_/A0 VGND VGND VPWR VPWR sky130_fd_sc_hd__diode_2
Xhold473 _5928_/Q VGND VGND VPWR VPWR hold473/X sky130_fd_sc_hd__dlygate4sd3_1
Xhold484 _4311_/X VGND VGND VPWR VPWR _5959_/D sky130_fd_sc_hd__dlygate4sd3_1
Xhold495 _5660_/Q VGND VGND VPWR VPWR hold495/X sky130_fd_sc_hd__dlygate4sd3_1
XFILLER_89_277 VGND VGND VPWR VPWR sky130_fd_sc_hd__fill_1
XANTENNA_fanout76_A _5215_/A1 VGND VGND VPWR VPWR sky130_fd_sc_hd__diode_2
Xhold1151 _5230_/X VGND VGND VPWR VPWR _6427_/D sky130_fd_sc_hd__dlygate4sd3_1
Xhold1140 _5246_/Q VGND VGND VPWR VPWR _2673_/A0 sky130_fd_sc_hd__dlygate4sd3_1
Xhold1184 _4891_/X VGND VGND VPWR VPWR _6240_/D sky130_fd_sc_hd__dlygate4sd3_1
Xhold1162 _4870_/X VGND VGND VPWR VPWR _6220_/D sky130_fd_sc_hd__dlygate4sd3_1
XFILLER_73_634 VGND VGND VPWR VPWR sky130_fd_sc_hd__fill_1
XFILLER_57_196 VGND VGND VPWR VPWR sky130_fd_sc_hd__fill_4
XFILLER_46_837 VGND VGND VPWR VPWR sky130_fd_sc_hd__fill_4
Xhold1173 _6115_/Q VGND VGND VPWR VPWR _4511_/A0 sky130_fd_sc_hd__dlygate4sd3_1
XFILLER_72_155 VGND VGND VPWR VPWR sky130_fd_sc_hd__fill_1
Xhold1195 _2714_/X VGND VGND VPWR VPWR _5262_/D sky130_fd_sc_hd__dlygate4sd3_1
XANTENNA__4442__B2 _4846_/A0 VGND VGND VPWR VPWR sky130_fd_sc_hd__diode_2
XFILLER_60_306 VGND VGND VPWR VPWR sky130_fd_sc_hd__fill_2
XFILLER_14_701 VPWR VGND VPWR VGND sky130_ef_sc_hd__decap_40_12
XTAP_TAPCELL_ROW_103_1849 VGND VPWR sky130_fd_sc_hd__tapvpwrvgnd_1
XTAP_TAPCELL_ROW_103_1838 VGND VPWR sky130_fd_sc_hd__tapvpwrvgnd_1
XFILLER_53_391 VGND VGND VPWR VPWR sky130_fd_sc_hd__fill_1
XPHY_EDGE_ROW_109_Left_248 VGND VGND VPWR VPWR sky130_fd_sc_hd__decap_3
XFILLER_41_575 VGND VGND VPWR VPWR sky130_fd_sc_hd__fill_1
XTAP_TAPCELL_ROW_136_2337 VGND VPWR sky130_fd_sc_hd__tapvpwrvgnd_1
XFILLER_70_20 VGND VGND VPWR VPWR sky130_fd_sc_hd__fill_8
XFILLER_13_277 VGND VGND VPWR VPWR sky130_fd_sc_hd__fill_1
XANTENNA__2851__S1 _2962_/A VGND VGND VPWR VPWR sky130_fd_sc_hd__diode_2
Xclkload29 _6338_/CLK VGND VGND VPWR VPWR clkload29/Y sky130_fd_sc_hd__clkinvlp_4
XTAP_TAPCELL_ROW_11_467 VGND VPWR sky130_fd_sc_hd__tapvpwrvgnd_1
Xclkload18 _6313_/CLK VGND VGND VPWR VPWR clkload18/Y sky130_fd_sc_hd__inv_8
XFILLER_127_669 VGND VGND VPWR VPWR sky130_fd_sc_hd__fill_2
XFILLER_115_809 VPWR VGND VPWR VGND sky130_ef_sc_hd__decap_40_12
XANTENNA__3705__A0 _5214_/A1 VGND VGND VPWR VPWR sky130_fd_sc_hd__diode_2
XPHY_EDGE_ROW_118_Left_257 VGND VGND VPWR VPWR sky130_fd_sc_hd__decap_3
XFILLER_110_525 VGND VGND VPWR VPWR sky130_fd_sc_hd__fill_4
XFILLER_96_737 VPWR VGND VPWR VGND sky130_ef_sc_hd__decap_40_12
XFILLER_1_671 VGND VGND VPWR VPWR sky130_fd_sc_hd__fill_1
XFILLER_95_236 VGND VGND VPWR VPWR sky130_fd_sc_hd__fill_1
XANTENNA__3460__S _3463_/S VGND VGND VPWR VPWR sky130_fd_sc_hd__diode_2
XFILLER_110_569 VPWR VGND VPWR VGND sky130_ef_sc_hd__decap_40_12
XANTENNA__4556__S _4561_/S VGND VGND VPWR VPWR sky130_fd_sc_hd__diode_2
XANTENNA__4681__A1 _4791_/A1 VGND VGND VPWR VPWR sky130_fd_sc_hd__diode_2
XFILLER_37_837 VGND VGND VPWR VPWR sky130_fd_sc_hd__fill_2
XANTENNA__4433__B2 _4432_/X VGND VGND VPWR VPWR sky130_fd_sc_hd__diode_2
XFILLER_17_561 VPWR VGND VPWR VGND sky130_ef_sc_hd__decap_40_12
XTAP_TAPCELL_ROW_19_578 VGND VPWR sky130_fd_sc_hd__tapvpwrvgnd_1
XTAP_TAPCELL_ROW_19_589 VGND VPWR sky130_fd_sc_hd__tapvpwrvgnd_1
X_4970_ _4980_/A1 _4970_/A1 _4974_/S VGND VGND VPWR VPWR _4970_/X sky130_fd_sc_hd__mux2_1
XPHY_EDGE_ROW_127_Left_266 VGND VGND VPWR VPWR sky130_fd_sc_hd__decap_3
X_3921_ hold421/X _6411_/Q _3928_/S VGND VGND VPWR VPWR _3921_/X sky130_fd_sc_hd__mux2_1
X_3852_ _3852_/A _3852_/B VGND VGND VPWR VPWR _3852_/X sky130_fd_sc_hd__or2_1
XANTENNA__4291__S _4294_/S VGND VGND VPWR VPWR sky130_fd_sc_hd__diode_2
X_2803_ _6232_/Q _6208_/Q _3091_/S VGND VGND VPWR VPWR _2804_/B sky130_fd_sc_hd__mux2_1
XFILLER_20_737 VPWR VGND VPWR VGND sky130_ef_sc_hd__decap_40_12
X_5522_ _5571_/CLK _5522_/D VGND VGND VPWR VPWR _5522_/Q sky130_fd_sc_hd__dfxtp_1
XFILLER_118_625 VPWR VGND VPWR VGND sky130_ef_sc_hd__decap_40_12
XANTENNA__2747__A1 _5075_/A0 VGND VGND VPWR VPWR sky130_fd_sc_hd__diode_2
X_3783_ _3783_/A0 _5212_/A1 _3787_/S VGND VGND VPWR VPWR _3783_/X sky130_fd_sc_hd__mux2_1
XTAP_TAPCELL_ROW_30_743 VGND VPWR sky130_fd_sc_hd__tapvpwrvgnd_1
XTAP_TAPCELL_ROW_30_754 VGND VPWR sky130_fd_sc_hd__tapvpwrvgnd_1
X_2734_ _2967_/S _2730_/B _2733_/Y VGND VGND VPWR VPWR _5269_/D sky130_fd_sc_hd__o21a_1
XFILLER_133_617 VPWR VGND VPWR VGND sky130_ef_sc_hd__decap_40_12
XFILLER_118_669 VPWR VGND VPWR VGND sky130_ef_sc_hd__decap_40_12
XFILLER_106_809 VGND VGND VPWR VPWR sky130_fd_sc_hd__fill_2
X_2665_ _2666_/B VGND VGND VPWR VPWR _2665_/Y sky130_fd_sc_hd__inv_2
XTAP_TAPCELL_ROW_76_1439 VGND VPWR sky130_fd_sc_hd__tapvpwrvgnd_1
XANTENNA__5146__C1 _2682_/A VGND VGND VPWR VPWR sky130_fd_sc_hd__diode_2
X_5453_ _5731_/CLK _5453_/D VGND VGND VPWR VPWR _5453_/Q sky130_fd_sc_hd__dfxtp_1
XPHY_EDGE_ROW_136_Left_275 VGND VGND VPWR VPWR sky130_fd_sc_hd__decap_3
X_4404_ _5045_/A1 _4404_/A1 _4406_/S VGND VGND VPWR VPWR _4404_/X sky130_fd_sc_hd__mux2_1
X_5384_ _6123_/CLK _5384_/D VGND VGND VPWR VPWR _5384_/Q sky130_fd_sc_hd__dfxtp_4
Xfanout205 _5222_/A VGND VGND VPWR VPWR _5085_/A sky130_fd_sc_hd__clkbuf_8
X_4335_ _5047_/A1 _4335_/A1 _4335_/S VGND VGND VPWR VPWR _4335_/X sky130_fd_sc_hd__mux2_1
XFILLER_115_27 VPWR VGND VPWR VGND sky130_ef_sc_hd__decap_40_12
XFILLER_101_503 VGND VGND VPWR VPWR sky130_fd_sc_hd__fill_1
XFILLER_99_597 VPWR VGND VPWR VGND sky130_ef_sc_hd__decap_40_12
X_4266_ _4263_/X _4264_/X _4265_/X _4205_/A VGND VGND VPWR VPWR _4266_/X sky130_fd_sc_hd__a22o_1
XANTENNA__4466__S _4472_/S VGND VGND VPWR VPWR sky130_fd_sc_hd__diode_2
X_3217_ _4903_/A0 _3217_/A1 _3220_/S VGND VGND VPWR VPWR _3217_/X sky130_fd_sc_hd__mux2_1
XANTENNA__2775__A _3005_/A VGND VGND VPWR VPWR sky130_fd_sc_hd__diode_2
XFILLER_74_409 VGND VGND VPWR VPWR sky130_fd_sc_hd__fill_8
XANTENNA__4672__A1 _2629_/Y VGND VGND VPWR VPWR sky130_fd_sc_hd__diode_2
X_4197_ _4241_/A _4197_/B VGND VGND VPWR VPWR _4197_/Y sky130_fd_sc_hd__nor2_1
X_6005_ clkload9/A _6005_/D VGND VGND VPWR VPWR _6005_/Q sky130_fd_sc_hd__dfxtp_1
XFILLER_131_15 VPWR VGND VPWR VGND sky130_ef_sc_hd__decap_40_12
XFILLER_95_781 VGND VGND VPWR VPWR sky130_fd_sc_hd__fill_2
X_3148_ _5329_/Q _3148_/A1 _3156_/S VGND VGND VPWR VPWR _3148_/X sky130_fd_sc_hd__mux2_1
XFILLER_28_837 VGND VGND VPWR VPWR sky130_fd_sc_hd__fill_4
XFILLER_54_133 VGND VGND VPWR VPWR sky130_fd_sc_hd__fill_2
XTAP_TAPCELL_ROW_38_865 VGND VPWR sky130_fd_sc_hd__tapvpwrvgnd_1
XTAP_TAPCELL_ROW_120_2105 VGND VPWR sky130_fd_sc_hd__tapvpwrvgnd_1
X_3079_ _3051_/S _5536_/Q _3050_/A VGND VGND VPWR VPWR _3079_/X sky130_fd_sc_hd__a21bo_1
XTAP_TAPCELL_ROW_38_876 VGND VPWR sky130_fd_sc_hd__tapvpwrvgnd_1
XFILLER_54_199 VGND VGND VPWR VPWR sky130_fd_sc_hd__fill_1
XFILLER_35_380 VGND VGND VPWR VPWR sky130_fd_sc_hd__fill_2
XFILLER_35_391 VGND VGND VPWR VPWR sky130_fd_sc_hd__fill_1
XANTENNA__2714__S _2716_/S VGND VGND VPWR VPWR sky130_fd_sc_hd__diode_2
XANTENNA__3935__A0 _5044_/A1 VGND VGND VPWR VPWR sky130_fd_sc_hd__diode_2
XTAP_TAPCELL_ROW_118_2067 VGND VPWR sky130_fd_sc_hd__tapvpwrvgnd_1
XFILLER_109_647 VPWR VGND VPWR VGND sky130_ef_sc_hd__decap_40_12
XFILLER_136_477 VPWR VGND VPWR VGND sky130_ef_sc_hd__decap_40_12
XTAP_TAPCELL_ROW_131_2267 VGND VPWR sky130_fd_sc_hd__tapvpwrvgnd_1
XFILLER_2_457 VPWR VGND VPWR VGND sky130_ef_sc_hd__decap_40_12
Xhold270 _5777_/Q VGND VGND VPWR VPWR hold270/X sky130_fd_sc_hd__dlygate4sd3_1
XFILLER_104_363 VGND VGND VPWR VPWR sky130_fd_sc_hd__fill_1
Xhold292 _2749_/X VGND VGND VPWR VPWR _5279_/D sky130_fd_sc_hd__dlygate4sd3_1
Xhold281 _3384_/X VGND VGND VPWR VPWR _5443_/D sky130_fd_sc_hd__dlygate4sd3_1
XANTENNA_fanout79_X _5214_/A1 VGND VGND VPWR VPWR sky130_fd_sc_hd__diode_2
XFILLER_93_729 VPWR VGND VPWR VGND sky130_ef_sc_hd__decap_40_12
XFILLER_86_781 VPWR VGND VPWR VGND sky130_ef_sc_hd__decap_40_12
XFILLER_19_837 VGND VGND VPWR VPWR sky130_fd_sc_hd__fill_2
XTAP_TAPCELL_ROW_47_1007 VGND VPWR sky130_fd_sc_hd__tapvpwrvgnd_1
XFILLER_45_199 VGND VGND VPWR VPWR sky130_fd_sc_hd__fill_1
XFILLER_14_531 VGND VGND VPWR VPWR sky130_fd_sc_hd__fill_1
XTAP_TAPCELL_ROW_16_537 VGND VPWR sky130_fd_sc_hd__tapvpwrvgnd_1
XFILLER_81_63 VGND VGND VPWR VPWR sky130_fd_sc_hd__fill_1
XTAP_TAPCELL_ROW_60_1207 VGND VPWR sky130_fd_sc_hd__tapvpwrvgnd_1
XFILLER_10_781 VPWR VGND VPWR VGND sky130_ef_sc_hd__decap_40_12
XANTENNA__3455__S _3463_/S VGND VGND VPWR VPWR sky130_fd_sc_hd__diode_2
XPHY_EDGE_ROW_116_Right_116 VGND VGND VPWR VPWR sky130_fd_sc_hd__decap_3
XFILLER_115_617 VPWR VGND VPWR VGND sky130_ef_sc_hd__decap_40_12
XFILLER_127_499 VGND VGND VPWR VPWR sky130_fd_sc_hd__fill_4
XTAP_TAPCELL_ROW_58_1169 VGND VPWR sky130_fd_sc_hd__tapvpwrvgnd_1
XFILLER_96_545 VPWR VGND VPWR VGND sky130_ef_sc_hd__decap_40_12
XFILLER_96_523 VGND VGND VPWR VPWR sky130_fd_sc_hd__fill_8
Xhold1909 _3012_/X VGND VGND VPWR VPWR _5292_/D sky130_fd_sc_hd__dlygate4sd3_1
XTAP_TAPCELL_ROW_71_1369 VGND VPWR sky130_fd_sc_hd__tapvpwrvgnd_1
XTAP_TAPCELL_ROW_71_1358 VGND VPWR sky130_fd_sc_hd__tapvpwrvgnd_1
X_4120_ _5985_/Q _5976_/Q _4237_/S VGND VGND VPWR VPWR _4121_/B sky130_fd_sc_hd__mux2_1
XFILLER_96_589 VPWR VGND VPWR VGND sky130_ef_sc_hd__decap_40_12
XANTENNA__4286__S _4294_/S VGND VGND VPWR VPWR sky130_fd_sc_hd__diode_2
X_4051_ _4051_/A0 _4051_/A1 _4237_/S VGND VGND VPWR VPWR _4051_/X sky130_fd_sc_hd__mux2_1
X_3002_ _3031_/A1 _3001_/X _3000_/X _3089_/C1 VGND VGND VPWR VPWR _3002_/X sky130_fd_sc_hd__o211a_1
Xinput5 s_axil_araddr[3] VGND VGND VPWR VPWR input5/X sky130_fd_sc_hd__clkbuf_4
XFILLER_37_612 VGND VGND VPWR VPWR sky130_fd_sc_hd__fill_2
XFILLER_52_626 VGND VGND VPWR VPWR sky130_fd_sc_hd__fill_2
XFILLER_24_317 VGND VGND VPWR VPWR sky130_fd_sc_hd__fill_4
XTAP_TAPCELL_ROW_86_1590 VGND VPWR sky130_fd_sc_hd__tapvpwrvgnd_1
X_4953_ _4983_/A1 _4953_/A1 _4954_/S VGND VGND VPWR VPWR _4953_/X sky130_fd_sc_hd__mux2_1
XFILLER_17_391 VGND VGND VPWR VPWR sky130_fd_sc_hd__fill_1
XTAP_TAPCELL_ROW_35_824 VGND VPWR sky130_fd_sc_hd__tapvpwrvgnd_1
XANTENNA__3090__B1 _2995_/A VGND VGND VPWR VPWR sky130_fd_sc_hd__diode_2
XFILLER_51_169 VGND VGND VPWR VPWR sky130_fd_sc_hd__fill_1
X_3904_ hold465/X _5212_/A1 _3908_/S VGND VGND VPWR VPWR _3904_/X sky130_fd_sc_hd__mux2_1
X_4884_ hold167/X _4445_/A _4893_/S VGND VGND VPWR VPWR _4884_/X sky130_fd_sc_hd__mux2_1
XFILLER_20_501 VPWR VGND VPWR VGND sky130_ef_sc_hd__decap_40_12
XFILLER_32_383 VGND VGND VPWR VPWR sky130_fd_sc_hd__fill_1
XFILLER_137_219 VGND VGND VPWR VPWR sky130_fd_sc_hd__fill_1
X_3835_ _3834_/X _5047_/A1 _3835_/S VGND VGND VPWR VPWR _5832_/D sky130_fd_sc_hd__mux2_1
XANTENNA__4265__S0 _4228_/S VGND VGND VPWR VPWR sky130_fd_sc_hd__diode_2
XFILLER_20_545 VPWR VGND VPWR VGND sky130_ef_sc_hd__decap_40_12
X_3766_ hold270/X _4984_/A1 _3766_/S VGND VGND VPWR VPWR _3766_/X sky130_fd_sc_hd__mux2_1
XFILLER_20_589 VPWR VGND VPWR VGND sky130_ef_sc_hd__decap_40_12
X_5505_ _6248_/CLK _5505_/D VGND VGND VPWR VPWR _5505_/Q sky130_fd_sc_hd__dfxtp_1
X_2717_ _3328_/B _5265_/Q VGND VGND VPWR VPWR _2721_/B sky130_fd_sc_hd__and2b_1
XANTENNA__3393__A1 _4976_/A1 VGND VGND VPWR VPWR sky130_fd_sc_hd__diode_2
XFILLER_10_15 VGND VGND VPWR VPWR sky130_fd_sc_hd__fill_4
XANTENNA__4050__A _4251_/A VGND VGND VPWR VPWR sky130_fd_sc_hd__diode_2
X_3697_ hold853/X _4521_/A1 _3698_/S VGND VGND VPWR VPWR _3697_/X sky130_fd_sc_hd__mux2_1
X_5436_ _6408_/CLK _5436_/D VGND VGND VPWR VPWR _5436_/Q sky130_fd_sc_hd__dfxtp_1
XFILLER_133_447 VGND VGND VPWR VPWR sky130_fd_sc_hd__fill_1
XFILLER_126_15 VPWR VGND VPWR VGND sky130_ef_sc_hd__decap_40_12
XFILLER_121_609 VGND VGND VPWR VPWR sky130_fd_sc_hd__fill_4
X_2648_ _3801_/A VGND VGND VPWR VPWR _3237_/A sky130_fd_sc_hd__inv_4
X_5367_ _6148_/CLK _5367_/D VGND VGND VPWR VPWR _5367_/Q sky130_fd_sc_hd__dfxtp_1
XANTENNA__4893__A1 _4906_/A0 VGND VGND VPWR VPWR sky130_fd_sc_hd__diode_2
XFILLER_86_19 VGND VGND VPWR VPWR sky130_fd_sc_hd__fill_8
X_5298_ _6365_/CLK hold21/X VGND VGND VPWR VPWR hold20/A sky130_fd_sc_hd__dfxtp_1
X_4318_ hold621/X _5040_/A1 _4325_/S VGND VGND VPWR VPWR _4318_/X sky130_fd_sc_hd__mux2_1
XFILLER_75_729 VGND VGND VPWR VPWR sky130_fd_sc_hd__fill_1
XANTENNA__2709__S _2716_/S VGND VGND VPWR VPWR sky130_fd_sc_hd__diode_2
X_4249_ _5768_/Q _5746_/Q _4250_/S VGND VGND VPWR VPWR _4249_/X sky130_fd_sc_hd__mux2_1
XANTENNA__4196__S _4257_/S VGND VGND VPWR VPWR sky130_fd_sc_hd__diode_2
XANTENNA__4740__S1 _4794_/A VGND VGND VPWR VPWR sky130_fd_sc_hd__diode_2
XANTENNA__3853__C1 _5200_/A VGND VGND VPWR VPWR sky130_fd_sc_hd__diode_2
XFILLER_27_166 VGND VGND VPWR VPWR sky130_fd_sc_hd__fill_2
XANTENNA__2959__A1 _3036_/A1 VGND VGND VPWR VPWR sky130_fd_sc_hd__diode_2
XFILLER_129_709 VPWR VGND VPWR VGND sky130_ef_sc_hd__decap_40_12
XFILLER_11_501 VGND VGND VPWR VPWR sky130_fd_sc_hd__fill_2
XFILLER_23_361 VPWR VGND VPWR VGND sky130_ef_sc_hd__decap_40_12
XFILLER_136_3 VPWR VGND VPWR VGND sky130_ef_sc_hd__decap_40_12
XFILLER_7_505 VPWR VGND VPWR VGND sky130_ef_sc_hd__decap_40_12
XFILLER_137_753 VPWR VGND VPWR VGND sky130_ef_sc_hd__decap_40_12
XANTENNA__3384__A1 _4978_/A1 VGND VGND VPWR VPWR sky130_fd_sc_hd__diode_2
XFILLER_137_797 VPWR VGND VPWR VGND sky130_ef_sc_hd__decap_40_12
XANTENNA__4333__A0 _4982_/A1 VGND VGND VPWR VPWR sky130_fd_sc_hd__diode_2
XANTENNA__4884__A1 _4445_/A VGND VGND VPWR VPWR sky130_fd_sc_hd__diode_2
XFILLER_3_777 VGND VGND VPWR VPWR sky130_fd_sc_hd__fill_4
XTAP_TAPCELL_ROW_111_1959 VGND VPWR sky130_fd_sc_hd__tapvpwrvgnd_1
XFILLER_104_171 VGND VGND VPWR VPWR sky130_fd_sc_hd__fill_1
XFILLER_2_287 VGND VGND VPWR VPWR sky130_fd_sc_hd__fill_4
XFILLER_76_41 VPWR VGND VPWR VGND sky130_ef_sc_hd__decap_40_12
XTAP_TAPCELL_ROW_53_1088 VGND VPWR sky130_fd_sc_hd__tapvpwrvgnd_1
XFILLER_120_697 VGND VGND VPWR VPWR sky130_fd_sc_hd__fill_2
XTAP_TAPCELL_ROW_53_1099 VGND VPWR sky130_fd_sc_hd__tapvpwrvgnd_1
XFILLER_58_291 VGND VGND VPWR VPWR sky130_fd_sc_hd__fill_2
XANTENNA__4834__S _4841_/S VGND VGND VPWR VPWR sky130_fd_sc_hd__diode_2
XFILLER_61_401 VGND VGND VPWR VPWR sky130_fd_sc_hd__fill_2
XFILLER_46_486 VGND VGND VPWR VPWR sky130_fd_sc_hd__fill_4
XANTENNA__3958__B _4007_/A VGND VGND VPWR VPWR sky130_fd_sc_hd__diode_2
XANTENNA__3310__Y _5035_/C VGND VGND VPWR VPWR sky130_fd_sc_hd__diode_2
X_3620_ _3620_/A0 _4515_/A1 _3627_/S VGND VGND VPWR VPWR _3620_/X sky130_fd_sc_hd__mux2_1
XFILLER_128_753 VGND VGND VPWR VPWR sky130_fd_sc_hd__fill_2
X_3551_ _3551_/A0 _4521_/A1 _3552_/S VGND VGND VPWR VPWR _3551_/X sky130_fd_sc_hd__mux2_1
XTAP_TAPCELL_ROW_40_893 VGND VPWR sky130_fd_sc_hd__tapvpwrvgnd_1
X_3482_ hold487/X _5818_/Q _3490_/S VGND VGND VPWR VPWR _3482_/X sky130_fd_sc_hd__mux2_1
XFILLER_51_3 VGND VGND VPWR VPWR sky130_fd_sc_hd__fill_1
X_6270_ _6316_/CLK _6270_/D VGND VGND VPWR VPWR _6270_/Q sky130_fd_sc_hd__dfxtp_1
XFILLER_130_417 VGND VGND VPWR VPWR sky130_fd_sc_hd__fill_2
XFILLER_130_406 VGND VGND VPWR VPWR sky130_fd_sc_hd__fill_1
XFILLER_103_609 VGND VGND VPWR VPWR sky130_fd_sc_hd__fill_4
XANTENNA__4875__A1 _4901_/A0 VGND VGND VPWR VPWR sky130_fd_sc_hd__diode_2
XFILLER_69_501 VGND VGND VPWR VPWR sky130_fd_sc_hd__fill_2
X_5221_ _5219_/B _5221_/A1 _5221_/S VGND VGND VPWR VPWR _5221_/X sky130_fd_sc_hd__mux2_1
XFILLER_97_821 VPWR VGND VPWR VGND sky130_ef_sc_hd__decap_40_12
X_5152_ _5152_/A _5152_/B VGND VGND VPWR VPWR _5152_/Y sky130_fd_sc_hd__xnor2_1
XFILLER_111_653 VPWR VGND VPWR VGND sky130_ef_sc_hd__decap_40_12
XFILLER_96_331 VGND VGND VPWR VPWR sky130_fd_sc_hd__fill_1
Xhold1706 _5037_/X VGND VGND VPWR VPWR _6333_/D sky130_fd_sc_hd__dlygate4sd3_1
Xhold1717 _5913_/Q VGND VGND VPWR VPWR _3937_/A1 sky130_fd_sc_hd__dlygate4sd3_1
X_4103_ _4103_/A0 _4102_/X _4274_/S VGND VGND VPWR VPWR _4103_/X sky130_fd_sc_hd__mux2_1
XFILLER_111_697 VPWR VGND VPWR VGND sky130_ef_sc_hd__decap_40_12
Xhold1728 _3436_/X VGND VGND VPWR VPWR _5487_/D sky130_fd_sc_hd__dlygate4sd3_1
Xhold1739 _4850_/X VGND VGND VPWR VPWR _6202_/D sky130_fd_sc_hd__dlygate4sd3_1
XANTENNA__4627__A1 _4791_/A1 VGND VGND VPWR VPWR sky130_fd_sc_hd__diode_2
X_5083_ _6459_/A _6373_/Q VGND VGND VPWR VPWR _5083_/Y sky130_fd_sc_hd__nand2_1
XFILLER_2_93 VGND VGND VPWR VPWR sky130_fd_sc_hd__fill_1
X_4034_ _5778_/Q _5906_/Q _4237_/S VGND VGND VPWR VPWR _4035_/B sky130_fd_sc_hd__mux2_1
XANTENNA__4744__S _4803_/S VGND VGND VPWR VPWR sky130_fd_sc_hd__diode_2
XFILLER_25_615 VGND VGND VPWR VPWR sky130_fd_sc_hd__fill_1
XFILLER_92_581 VGND VGND VPWR VPWR sky130_fd_sc_hd__fill_4
XFILLER_37_497 VGND VGND VPWR VPWR sky130_fd_sc_hd__fill_1
XANTENNA__5052__A1 _5052_/A1 VGND VGND VPWR VPWR sky130_fd_sc_hd__diode_2
X_5985_ clkload7/A _5985_/D VGND VGND VPWR VPWR _5985_/Q sky130_fd_sc_hd__dfxtp_1
XFILLER_80_798 VPWR VGND VPWR VGND sky130_ef_sc_hd__decap_40_12
X_4936_ _4976_/A1 _4936_/A1 _4944_/S VGND VGND VPWR VPWR _4936_/X sky130_fd_sc_hd__mux2_1
XFILLER_21_821 VPWR VGND VPWR VGND sky130_ef_sc_hd__decap_40_12
XFILLER_138_517 VPWR VGND VPWR VGND sky130_ef_sc_hd__decap_40_12
X_4867_ _4906_/A0 _4867_/A1 _4867_/S VGND VGND VPWR VPWR _4867_/X sky130_fd_sc_hd__mux2_1
X_3818_ _4916_/A _4882_/A1 _3818_/S VGND VGND VPWR VPWR _5821_/D sky130_fd_sc_hd__mux2_1
XFILLER_119_753 VPWR VGND VPWR VGND sky130_ef_sc_hd__decap_40_12
XTAP_TAPCELL_ROW_115_2026 VGND VPWR sky130_fd_sc_hd__tapvpwrvgnd_1
XTAP_TAPCELL_ROW_99_1781 VGND VPWR sky130_fd_sc_hd__tapvpwrvgnd_1
X_4798_ _4791_/B1 _4797_/X _4794_/Y _4796_/Y VGND VGND VPWR VPWR _4799_/B sky130_fd_sc_hd__o2bb2a_1
XANTENNA_fanout129_X _4903_/A0 VGND VGND VPWR VPWR sky130_fd_sc_hd__diode_2
XFILLER_134_701 VPWR VGND VPWR VGND sky130_ef_sc_hd__decap_40_12
XFILLER_119_797 VPWR VGND VPWR VGND sky130_ef_sc_hd__decap_40_12
XTAP_TAPCELL_ROW_99_1792 VGND VPWR sky130_fd_sc_hd__tapvpwrvgnd_1
X_3749_ _4978_/A1 _3749_/A1 _3755_/S VGND VGND VPWR VPWR _3749_/X sky130_fd_sc_hd__mux2_1
XANTENNA__3118__A1 _5241_/A1 VGND VGND VPWR VPWR sky130_fd_sc_hd__diode_2
XANTENNA_clkbuf_leaf_63_clk_A clkload5/A VGND VGND VPWR VPWR sky130_fd_sc_hd__diode_2
XANTENNA__3890__Y _3899_/S VGND VGND VPWR VPWR sky130_fd_sc_hd__diode_2
X_5419_ _6146_/CLK hold38/X VGND VGND VPWR VPWR hold37/A sky130_fd_sc_hd__dfxtp_1
X_6399_ _6399_/CLK _6399_/D VGND VGND VPWR VPWR _6399_/Q sky130_fd_sc_hd__dfxtp_1
XFILLER_0_725 VGND VGND VPWR VPWR sky130_fd_sc_hd__fill_2
XANTENNA_clkbuf_leaf_78_clk_A clkload2/A VGND VGND VPWR VPWR sky130_fd_sc_hd__diode_2
XFILLER_0_769 VPWR VGND VPWR VGND sky130_ef_sc_hd__decap_40_12
XFILLER_102_697 VGND VGND VPWR VPWR sky130_fd_sc_hd__fill_2
XFILLER_101_152 VGND VGND VPWR VPWR sky130_fd_sc_hd__fill_1
XFILLER_75_559 VGND VGND VPWR VPWR sky130_fd_sc_hd__fill_1
XFILLER_46_33 VGND VGND VPWR VPWR sky130_fd_sc_hd__fill_2
XTAP_TAPCELL_ROW_126_2188 VGND VPWR sky130_fd_sc_hd__tapvpwrvgnd_1
XFILLER_90_529 VGND VGND VPWR VPWR sky130_fd_sc_hd__fill_2
XFILLER_28_475 VGND VGND VPWR VPWR sky130_fd_sc_hd__fill_1
XFILLER_71_732 VGND VGND VPWR VPWR sky130_fd_sc_hd__fill_1
XFILLER_16_637 VGND VGND VPWR VPWR sky130_fd_sc_hd__fill_4
XFILLER_70_231 VGND VGND VPWR VPWR sky130_fd_sc_hd__fill_1
XANTENNA__5043__A1 _5043_/A1 VGND VGND VPWR VPWR sky130_fd_sc_hd__diode_2
XFILLER_15_169 VGND VGND VPWR VPWR sky130_fd_sc_hd__fill_2
XTAP_TAPCELL_ROW_26_687 VGND VPWR sky130_fd_sc_hd__tapvpwrvgnd_1
XFILLER_129_517 VPWR VGND VPWR VGND sky130_ef_sc_hd__decap_40_12
XANTENNA_clkbuf_leaf_16_clk_A clkbuf_leaf_9_clk/A VGND VGND VPWR VPWR sky130_fd_sc_hd__diode_2
XFILLER_11_320 VGND VGND VPWR VPWR sky130_fd_sc_hd__fill_2
XFILLER_8_825 VPWR VGND VPWR VGND sky130_ef_sc_hd__decap_40_12
XFILLER_7_27 VGND VGND VPWR VPWR sky130_fd_sc_hd__fill_2
XFILLER_11_364 VPWR VGND VPWR VGND sky130_ef_sc_hd__decap_40_12
XFILLER_7_335 VGND VGND VPWR VPWR sky130_fd_sc_hd__fill_1
XFILLER_137_561 VPWR VGND VPWR VGND sky130_ef_sc_hd__decap_40_12
XANTENNA__3109__A1 _5234_/A0 VGND VGND VPWR VPWR sky130_fd_sc_hd__diode_2
XTAP_TAPCELL_ROW_55_1128 VGND VPWR sky130_fd_sc_hd__tapvpwrvgnd_1
XFILLER_3_541 VPWR VGND VPWR VGND sky130_ef_sc_hd__decap_40_12
XFILLER_79_821 VPWR VGND VPWR VGND sky130_ef_sc_hd__decap_40_12
XFILLER_3_585 VPWR VGND VPWR VGND sky130_ef_sc_hd__decap_40_12
XFILLER_39_718 VGND VGND VPWR VPWR sky130_fd_sc_hd__fill_1
XFILLER_120_483 VGND VGND VPWR VPWR sky130_fd_sc_hd__fill_2
XFILLER_94_813 VPWR VGND VPWR VGND sky130_ef_sc_hd__decap_40_12
XFILLER_78_375 VGND VGND VPWR VPWR sky130_fd_sc_hd__fill_2
XANTENNA__4609__A1 _4792_/A1 VGND VGND VPWR VPWR sky130_fd_sc_hd__diode_2
XTAP_TAPCELL_ROW_6_390 VGND VPWR sky130_fd_sc_hd__tapvpwrvgnd_1
XANTENNA__3832__A2 _4451_/A VGND VGND VPWR VPWR sky130_fd_sc_hd__diode_2
XFILLER_19_497 VGND VGND VPWR VPWR sky130_fd_sc_hd__fill_4
XFILLER_99_3 VPWR VGND VPWR VGND sky130_ef_sc_hd__decap_40_12
X_2982_ _3152_/A1 _2981_/X _2982_/S VGND VGND VPWR VPWR _5291_/D sky130_fd_sc_hd__mux2_1
XFILLER_62_798 VPWR VGND VPWR VGND sky130_ef_sc_hd__decap_40_12
XTAP_TAPCELL_ROW_45_974 VGND VPWR sky130_fd_sc_hd__tapvpwrvgnd_1
X_5770_ _6302_/CLK _5770_/D VGND VGND VPWR VPWR _5770_/Q sky130_fd_sc_hd__dfxtp_1
X_4721_ _4718_/X _4719_/X _4720_/X _4663_/A VGND VGND VPWR VPWR _4721_/X sky130_fd_sc_hd__a22o_1
X_4652_ _4791_/A1 _4651_/X _4791_/B1 VGND VGND VPWR VPWR _4652_/X sky130_fd_sc_hd__o21a_1
X_3603_ _4730_/A2 _5214_/A1 _3605_/S VGND VGND VPWR VPWR _3603_/X sky130_fd_sc_hd__mux2_1
Xinput30 s_axil_wvalid VGND VGND VPWR VPWR _3729_/C sky130_fd_sc_hd__clkbuf_1
XFILLER_116_701 VPWR VGND VPWR VGND sky130_ef_sc_hd__decap_40_12
Xhold803 _5589_/Q VGND VGND VPWR VPWR hold803/X sky130_fd_sc_hd__dlygate4sd3_1
X_4583_ _5675_/Q _5657_/Q _4808_/S VGND VGND VPWR VPWR _4584_/B sky130_fd_sc_hd__mux2_1
Xhold836 _3287_/X VGND VGND VPWR VPWR _5406_/D sky130_fd_sc_hd__dlygate4sd3_1
X_3534_ _3534_/A0 _4886_/A1 _3541_/S VGND VGND VPWR VPWR _3534_/X sky130_fd_sc_hd__mux2_1
Xhold814 _3584_/X VGND VGND VPWR VPWR _5620_/D sky130_fd_sc_hd__dlygate4sd3_1
X_6322_ _6339_/CLK _6322_/D VGND VGND VPWR VPWR _6322_/Q sky130_fd_sc_hd__dfxtp_1
Xhold825 _6268_/Q VGND VGND VPWR VPWR hold825/X sky130_fd_sc_hd__dlygate4sd3_1
Xhold858 _3455_/X VGND VGND VPWR VPWR _5504_/D sky130_fd_sc_hd__dlygate4sd3_1
Xhold869 _6139_/Q VGND VGND VPWR VPWR hold869/X sky130_fd_sc_hd__dlygate4sd3_1
X_6253_ _6254_/CLK _6253_/D VGND VGND VPWR VPWR _6253_/Q sky130_fd_sc_hd__dfxtp_1
X_3465_ _5225_/B _3465_/B VGND VGND VPWR VPWR _3477_/S sky130_fd_sc_hd__or2_4
XFILLER_107_39 VGND VGND VPWR VPWR sky130_fd_sc_hd__fill_1
Xhold847 _6238_/Q VGND VGND VPWR VPWR hold847/X sky130_fd_sc_hd__dlygate4sd3_1
XFILLER_88_139 VGND VGND VPWR VPWR sky130_fd_sc_hd__fill_1
XFILLER_88_117 VGND VGND VPWR VPWR sky130_fd_sc_hd__fill_2
X_5204_ _2653_/Y _6419_/Q _6408_/Q VGND VGND VPWR VPWR _5204_/X sky130_fd_sc_hd__a21o_1
X_6184_ _6398_/CLK _6184_/D VGND VGND VPWR VPWR _6184_/Q sky130_fd_sc_hd__dfxtp_1
XFILLER_69_353 VPWR VGND VPWR VGND sky130_ef_sc_hd__decap_40_12
XFILLER_69_331 VGND VGND VPWR VPWR sky130_fd_sc_hd__fill_2
Xhold2226 _5824_/Q VGND VGND VPWR VPWR hold2226/X sky130_fd_sc_hd__dlygate4sd3_1
Xhold2215 _3268_/Y VGND VGND VPWR VPWR _5397_/D sky130_fd_sc_hd__dlygate4sd3_1
Xhold2204 _6459_/A VGND VGND VPWR VPWR _5221_/A1 sky130_fd_sc_hd__dlygate4sd3_1
X_3396_ hold375/X _4929_/A1 _3401_/S VGND VGND VPWR VPWR _3396_/X sky130_fd_sc_hd__mux2_1
Xhold2237 _5341_/Q VGND VGND VPWR VPWR hold2237/X sky130_fd_sc_hd__dlygate4sd3_1
Xhold1514 _3486_/X VGND VGND VPWR VPWR _5532_/D sky130_fd_sc_hd__dlygate4sd3_1
XANTENNA_fanout193_A _3016_/S VGND VGND VPWR VPWR sky130_fd_sc_hd__diode_2
Xhold2259 _5250_/Q VGND VGND VPWR VPWR _2667_/B sky130_fd_sc_hd__dlygate4sd3_1
XFILLER_97_673 VPWR VGND VPWR VGND sky130_ef_sc_hd__decap_40_12
X_5135_ _5160_/A _5135_/B VGND VGND VPWR VPWR _5135_/Y sky130_fd_sc_hd__nand2_1
Xhold2248 _4492_/S VGND VGND VPWR VPWR _4488_/S sky130_fd_sc_hd__dlygate4sd3_1
Xhold1503 _4405_/X VGND VGND VPWR VPWR _6043_/D sky130_fd_sc_hd__dlygate4sd3_1
Xhold1525 _6011_/Q VGND VGND VPWR VPWR _4370_/A1 sky130_fd_sc_hd__dlygate4sd3_1
XFILLER_123_27 VPWR VGND VPWR VGND sky130_ef_sc_hd__decap_40_12
Xhold1536 _3490_/X VGND VGND VPWR VPWR _5536_/D sky130_fd_sc_hd__dlygate4sd3_1
XFILLER_111_494 VGND VGND VPWR VPWR sky130_fd_sc_hd__fill_8
XFILLER_96_183 VGND VGND VPWR VPWR sky130_fd_sc_hd__fill_1
Xhold1547 _6093_/Q VGND VGND VPWR VPWR _4487_/A1 sky130_fd_sc_hd__dlygate4sd3_1
X_5066_ _5066_/A0 _2651_/A _5207_/S VGND VGND VPWR VPWR _5066_/X sky130_fd_sc_hd__mux2_1
XFILLER_57_559 VGND VGND VPWR VPWR sky130_fd_sc_hd__fill_1
Xhold1558 _4369_/X VGND VGND VPWR VPWR _6010_/D sky130_fd_sc_hd__dlygate4sd3_1
Xhold1569 _4492_/X VGND VGND VPWR VPWR _6098_/D sky130_fd_sc_hd__dlygate4sd3_1
X_4017_ _4013_/B _5218_/B _4015_/X _4012_/X _5048_/A VGND VGND VPWR VPWR _4017_/X
+ sky130_fd_sc_hd__a2111o_1
XFILLER_25_445 VGND VGND VPWR VPWR sky130_fd_sc_hd__fill_2
XANTENNA__3036__B1 _3094_/C1 VGND VGND VPWR VPWR sky130_fd_sc_hd__diode_2
X_5968_ _6334_/CLK _5968_/D VGND VGND VPWR VPWR _5968_/Q sky130_fd_sc_hd__dfxtp_1
XANTENNA__4233__C1 _5343_/Q VGND VGND VPWR VPWR sky130_fd_sc_hd__diode_2
XFILLER_13_629 VPWR VGND VPWR VGND sky130_ef_sc_hd__decap_40_12
XANTENNA__3587__A1 _4484_/A0 VGND VGND VPWR VPWR sky130_fd_sc_hd__diode_2
X_4919_ _5190_/A1 _4907_/Y _4918_/X _5200_/A VGND VGND VPWR VPWR _6260_/D sky130_fd_sc_hd__o211a_1
XTAP_TAPCELL_ROW_23_646 VGND VPWR sky130_fd_sc_hd__tapvpwrvgnd_1
XFILLER_138_303 VGND VGND VPWR VPWR sky130_fd_sc_hd__fill_1
X_5899_ _5902_/CLK _5899_/D VGND VGND VPWR VPWR _5899_/Q sky130_fd_sc_hd__dfxtp_1
XFILLER_32_68 VGND VGND VPWR VPWR sky130_fd_sc_hd__fill_1
XFILLER_119_561 VPWR VGND VPWR VGND sky130_ef_sc_hd__decap_40_12
XFILLER_5_839 VGND VGND VPWR VPWR sky130_fd_sc_hd__fill_1
XFILLER_134_531 VGND VGND VPWR VPWR sky130_fd_sc_hd__fill_1
XFILLER_106_233 VGND VGND VPWR VPWR sky130_fd_sc_hd__fill_1
XFILLER_122_737 VPWR VGND VPWR VGND sky130_ef_sc_hd__decap_40_12
XFILLER_121_214 VGND VGND VPWR VPWR sky130_fd_sc_hd__fill_1
XFILLER_79_139 VGND VGND VPWR VPWR sky130_fd_sc_hd__fill_8
XTAP_TAPCELL_ROW_128_2217 VGND VPWR sky130_fd_sc_hd__tapvpwrvgnd_1
XFILLER_0_533 VPWR VGND VPWR VGND sky130_ef_sc_hd__decap_40_12
XFILLER_130_781 VPWR VGND VPWR VGND sky130_ef_sc_hd__decap_40_12
XFILLER_76_813 VPWR VGND VPWR VGND sky130_ef_sc_hd__decap_40_12
XFILLER_57_21 VGND VGND VPWR VPWR sky130_fd_sc_hd__fill_1
XTAP_TAPCELL_ROW_50_1047 VGND VPWR sky130_fd_sc_hd__tapvpwrvgnd_1
XANTENNA_input19_A s_axil_wdata[1] VGND VGND VPWR VPWR sky130_fd_sc_hd__diode_2
XFILLER_57_98 VGND VGND VPWR VPWR sky130_fd_sc_hd__fill_1
XFILLER_113_93 VGND VGND VPWR VPWR sky130_fd_sc_hd__fill_1
XFILLER_16_445 VPWR VGND VPWR VGND sky130_ef_sc_hd__decap_40_12
XANTENNA__4224__C1 _4271_/S1 VGND VGND VPWR VPWR sky130_fd_sc_hd__diode_2
XFILLER_16_489 VPWR VGND VPWR VGND sky130_ef_sc_hd__decap_40_12
XFILLER_31_415 VPWR VGND VPWR VGND sky130_ef_sc_hd__decap_40_12
XANTENNA__3578__A1 _6412_/Q VGND VGND VPWR VPWR sky130_fd_sc_hd__diode_2
XTAP_TAPCELL_ROW_42_933 VGND VPWR sky130_fd_sc_hd__tapvpwrvgnd_1
XFILLER_7_121 VGND VGND VPWR VPWR sky130_fd_sc_hd__fill_1
XFILLER_8_699 VGND VGND VPWR VPWR sky130_fd_sc_hd__fill_1
XFILLER_125_553 VGND VGND VPWR VPWR sky130_fd_sc_hd__fill_4
XANTENNA__4559__S _4561_/S VGND VGND VPWR VPWR sky130_fd_sc_hd__diode_2
XFILLER_125_597 VPWR VGND VPWR VGND sky130_ef_sc_hd__decap_40_12
XANTENNA__3463__S _3463_/S VGND VGND VPWR VPWR sky130_fd_sc_hd__diode_2
X_3250_ _3228_/B _3908_/S _3249_/Y VGND VGND VPWR VPWR _3250_/X sky130_fd_sc_hd__o21a_1
XFILLER_3_393 VGND VGND VPWR VPWR sky130_fd_sc_hd__fill_2
XFILLER_121_781 VGND VGND VPWR VPWR sky130_fd_sc_hd__fill_2
XANTENNA__2936__S0 _3077_/S VGND VGND VPWR VPWR sky130_fd_sc_hd__diode_2
X_3181_ _3438_/A _5225_/B VGND VGND VPWR VPWR _3193_/S sky130_fd_sc_hd__nor2_8
XFILLER_67_813 VGND VGND VPWR VPWR sky130_fd_sc_hd__fill_8
XFILLER_94_643 VGND VGND VPWR VPWR sky130_fd_sc_hd__fill_1
XFILLER_14_3 VPWR VGND VPWR VGND sky130_ef_sc_hd__decap_40_12
XFILLER_39_559 VGND VGND VPWR VPWR sky130_fd_sc_hd__fill_1
XTAP_TAPCELL_ROW_68_1319 VGND VPWR sky130_fd_sc_hd__tapvpwrvgnd_1
XTAP_TAPCELL_ROW_1_308 VGND VPWR sky130_fd_sc_hd__tapvpwrvgnd_1
XTAP_TAPCELL_ROW_1_319 VGND VPWR sky130_fd_sc_hd__tapvpwrvgnd_1
XANTENNA__4294__S _4294_/S VGND VGND VPWR VPWR sky130_fd_sc_hd__diode_2
XFILLER_81_337 VGND VGND VPWR VPWR sky130_fd_sc_hd__fill_4
XANTENNA__3266__B1 _4773_/S VGND VGND VPWR VPWR sky130_fd_sc_hd__diode_2
XFILLER_19_261 VGND VGND VPWR VPWR sky130_fd_sc_hd__fill_2
XTAP_TAPCELL_ROW_81_1508 VGND VPWR sky130_fd_sc_hd__tapvpwrvgnd_1
XTAP_TAPCELL_ROW_81_1519 VGND VPWR sky130_fd_sc_hd__tapvpwrvgnd_1
X_5822_ _6261_/CLK _5822_/D VGND VGND VPWR VPWR _5822_/Q sky130_fd_sc_hd__dfxtp_1
X_5753_ _5753_/CLK _5753_/D VGND VGND VPWR VPWR _5753_/Q sky130_fd_sc_hd__dfxtp_1
XANTENNA__3569__A1 _4517_/A1 VGND VGND VPWR VPWR sky130_fd_sc_hd__diode_2
XFILLER_50_757 VPWR VGND VPWR VGND sky130_ef_sc_hd__decap_40_12
X_2965_ _6133_/Q _5556_/Q _5755_/Q _5279_/Q _2963_/S _2962_/A VGND VGND VPWR VPWR
+ _2965_/X sky130_fd_sc_hd__mux4_1
X_4704_ hold979/X _5590_/Q _4795_/S VGND VGND VPWR VPWR _4704_/X sky130_fd_sc_hd__mux2_1
XTAP_TAPCELL_ROW_20_605 VGND VPWR sky130_fd_sc_hd__tapvpwrvgnd_1
X_2896_ _5270_/Q _2881_/X _2895_/Y _2925_/S VGND VGND VPWR VPWR _2896_/X sky130_fd_sc_hd__o211a_1
X_5684_ _5870_/CLK _5684_/D VGND VGND VPWR VPWR _5684_/Q sky130_fd_sc_hd__dfxtp_1
XFILLER_108_509 VPWR VGND VPWR VGND sky130_ef_sc_hd__decap_40_12
X_4635_ _4802_/A _4635_/B VGND VGND VPWR VPWR _4635_/X sky130_fd_sc_hd__or2_1
XFILLER_118_27 VGND VGND VPWR VPWR sky130_fd_sc_hd__fill_1
XFILLER_116_531 VGND VGND VPWR VPWR sky130_fd_sc_hd__fill_1
XANTENNA_fanout206_A _3801_/A VGND VGND VPWR VPWR sky130_fd_sc_hd__diode_2
XTAP_TAPCELL_ROW_96_1740 VGND VPWR sky130_fd_sc_hd__tapvpwrvgnd_1
X_4566_ _4791_/A1 _4565_/X _4791_/B1 VGND VGND VPWR VPWR _4566_/X sky130_fd_sc_hd__o21a_1
Xhold611 _4294_/X VGND VGND VPWR VPWR _5945_/D sky130_fd_sc_hd__dlygate4sd3_1
Xhold600 _6081_/Q VGND VGND VPWR VPWR hold600/X sky130_fd_sc_hd__dlygate4sd3_1
XANTENNA__4469__S _4472_/S VGND VGND VPWR VPWR sky130_fd_sc_hd__diode_2
X_3517_ _5069_/B _3517_/B VGND VGND VPWR VPWR _3529_/S sky130_fd_sc_hd__or2_4
Xhold633 _5496_/Q VGND VGND VPWR VPWR hold633/X sky130_fd_sc_hd__dlygate4sd3_1
XANTENNA__3741__A1 _5233_/A0 VGND VGND VPWR VPWR sky130_fd_sc_hd__diode_2
XFILLER_2_809 VGND VGND VPWR VPWR sky130_fd_sc_hd__fill_2
X_6305_ _6312_/CLK _6305_/D VGND VGND VPWR VPWR _6305_/Q sky130_fd_sc_hd__dfxtp_1
Xhold622 _4318_/X VGND VGND VPWR VPWR _5965_/D sky130_fd_sc_hd__dlygate4sd3_1
Xhold644 _4514_/X VGND VGND VPWR VPWR _6117_/D sky130_fd_sc_hd__dlygate4sd3_1
XFILLER_131_501 VGND VGND VPWR VPWR sky130_fd_sc_hd__fill_2
XFILLER_104_737 VPWR VGND VPWR VGND sky130_ef_sc_hd__decap_40_12
Xhold666 _2746_/X VGND VGND VPWR VPWR _5276_/D sky130_fd_sc_hd__dlygate4sd3_1
Xhold688 _5281_/Q VGND VGND VPWR VPWR hold688/X sky130_fd_sc_hd__dlygate4sd3_1
Xhold677 _5755_/Q VGND VGND VPWR VPWR hold677/X sky130_fd_sc_hd__dlygate4sd3_1
Xhold655 _5899_/Q VGND VGND VPWR VPWR hold655/X sky130_fd_sc_hd__dlygate4sd3_1
X_4497_ hold554/X _5211_/A1 _4502_/S VGND VGND VPWR VPWR _4497_/X sky130_fd_sc_hd__mux2_1
XFILLER_134_15 VPWR VGND VPWR VGND sky130_ef_sc_hd__decap_40_12
X_3448_ hold745/X _5235_/A0 _3450_/S VGND VGND VPWR VPWR _3448_/X sky130_fd_sc_hd__mux2_1
X_6236_ _6236_/CLK hold34/X VGND VGND VPWR VPWR hold33/A sky130_fd_sc_hd__dfxtp_1
Xhold2001 _5161_/X VGND VGND VPWR VPWR _6396_/D sky130_fd_sc_hd__dlygate4sd3_1
Xhold2012 _6392_/Q VGND VGND VPWR VPWR _5137_/A sky130_fd_sc_hd__dlygate4sd3_1
Xhold699 _3386_/X VGND VGND VPWR VPWR _5445_/D sky130_fd_sc_hd__dlygate4sd3_1
XFILLER_134_59 VGND VGND VPWR VPWR sky130_fd_sc_hd__fill_1
Xhold1300 _3466_/X VGND VGND VPWR VPWR _5513_/D sky130_fd_sc_hd__dlygate4sd3_1
XFILLER_112_781 VPWR VGND VPWR VGND sky130_ef_sc_hd__decap_40_12
XANTENNA_fanout196_X _3091_/S VGND VGND VPWR VPWR sky130_fd_sc_hd__diode_2
X_3379_ _5837_/Q input5/X input4/X VGND VGND VPWR VPWR _3379_/X sky130_fd_sc_hd__and3_1
X_6167_ _6382_/CLK _6167_/D VGND VGND VPWR VPWR _6167_/Q sky130_fd_sc_hd__dfxtp_1
XFILLER_58_813 VPWR VGND VPWR VGND sky130_ef_sc_hd__decap_40_12
Xhold2023 _3282_/X VGND VGND VPWR VPWR _5402_/D sky130_fd_sc_hd__dlygate4sd3_1
Xhold2034 _5433_/Q VGND VGND VPWR VPWR _5212_/A0 sky130_fd_sc_hd__dlygate4sd3_1
Xhold2045 _4248_/X VGND VGND VPWR VPWR _5926_/D sky130_fd_sc_hd__dlygate4sd3_1
Xhold1322 _6431_/Q VGND VGND VPWR VPWR _5234_/A1 sky130_fd_sc_hd__dlygate4sd3_1
Xhold2056 _5216_/Y VGND VGND VPWR VPWR _5217_/A2 sky130_fd_sc_hd__dlygate4sd3_1
XFILLER_57_334 VGND VGND VPWR VPWR sky130_fd_sc_hd__fill_2
Xhold2078 _6422_/Q VGND VGND VPWR VPWR _5223_/B1 sky130_fd_sc_hd__dlygate4sd3_1
X_5118_ _5915_/Q _3997_/S _5218_/C VGND VGND VPWR VPWR _5118_/Y sky130_fd_sc_hd__a21oi_1
Xhold1311 _5039_/X VGND VGND VPWR VPWR _6334_/D sky130_fd_sc_hd__dlygate4sd3_1
Xhold1333 _3692_/X VGND VGND VPWR VPWR _5713_/D sky130_fd_sc_hd__dlygate4sd3_1
Xhold2067 _3365_/X VGND VGND VPWR VPWR _5436_/D sky130_fd_sc_hd__dlygate4sd3_1
Xhold1366 _3518_/X VGND VGND VPWR VPWR _5561_/D sky130_fd_sc_hd__dlygate4sd3_1
Xhold1377 _6192_/Q VGND VGND VPWR VPWR _4839_/A1 sky130_fd_sc_hd__dlygate4sd3_1
Xhold1355 _5293_/Q VGND VGND VPWR VPWR _3154_/A1 sky130_fd_sc_hd__dlygate4sd3_1
X_6098_ _6098_/CLK _6098_/D VGND VGND VPWR VPWR _6098_/Q sky130_fd_sc_hd__dfxtp_1
XFILLER_73_827 VGND VGND VPWR VPWR sky130_fd_sc_hd__fill_1
Xhold1344 _5762_/Q VGND VGND VPWR VPWR _3749_/A1 sky130_fd_sc_hd__dlygate4sd3_1
Xhold2089 _6413_/Q VGND VGND VPWR VPWR hold2089/X sky130_fd_sc_hd__dlygate4sd3_1
XTAP_TAPCELL_ROW_123_2147 VGND VPWR sky130_fd_sc_hd__tapvpwrvgnd_1
Xhold1399 _6434_/Q VGND VGND VPWR VPWR _5237_/A1 sky130_fd_sc_hd__dlygate4sd3_1
XFILLER_84_197 VPWR VGND VPWR VGND sky130_ef_sc_hd__decap_40_12
XANTENNA__4454__C1 _3801_/B VGND VGND VPWR VPWR sky130_fd_sc_hd__diode_2
X_5049_ hold1/X _5208_/A0 _5049_/S VGND VGND VPWR VPWR _6343_/D sky130_fd_sc_hd__mux2_1
XFILLER_45_529 VGND VGND VPWR VPWR sky130_fd_sc_hd__fill_4
Xhold1388 _4968_/X VGND VGND VPWR VPWR _6301_/D sky130_fd_sc_hd__dlygate4sd3_1
XFILLER_26_732 VGND VGND VPWR VPWR sky130_fd_sc_hd__fill_1
XTAP_TAPCELL_ROW_28_716 VGND VPWR sky130_fd_sc_hd__tapvpwrvgnd_1
XTAP_TAPCELL_ROW_28_727 VGND VPWR sky130_fd_sc_hd__tapvpwrvgnd_1
XANTENNA__4932__S _4934_/S VGND VGND VPWR VPWR sky130_fd_sc_hd__diode_2
XFILLER_41_724 VGND VGND VPWR VPWR sky130_fd_sc_hd__fill_4
XTAP_TAPCELL_ROW_105_1880 VGND VPWR sky130_fd_sc_hd__tapvpwrvgnd_1
XTAP_TAPCELL_ROW_138_2390 VGND VPWR sky130_fd_sc_hd__tapvpwrvgnd_1
XANTENNA__4604__S0 _4773_/S VGND VGND VPWR VPWR sky130_fd_sc_hd__diode_2
XFILLER_5_669 VGND VGND VPWR VPWR sky130_fd_sc_hd__fill_2
XFILLER_107_597 VPWR VGND VPWR VGND sky130_ef_sc_hd__decap_40_12
XFILLER_122_545 VPWR VGND VPWR VGND sky130_ef_sc_hd__decap_40_12
XANTENNA__3496__A0 _4899_/A0 VGND VGND VPWR VPWR sky130_fd_sc_hd__diode_2
XFILLER_122_589 VPWR VGND VPWR VGND sky130_ef_sc_hd__decap_40_12
XFILLER_0_363 VGND VGND VPWR VPWR sky130_fd_sc_hd__fill_1
XFILLER_103_781 VGND VGND VPWR VPWR sky130_fd_sc_hd__fill_2
XFILLER_91_613 VGND VGND VPWR VPWR sky130_fd_sc_hd__fill_2
XFILLER_84_41 VPWR VGND VPWR VGND sky130_ef_sc_hd__decap_40_12
XFILLER_64_805 VGND VGND VPWR VPWR sky130_fd_sc_hd__fill_4
XFILLER_90_101 VGND VGND VPWR VPWR sky130_fd_sc_hd__fill_1
XFILLER_17_721 VGND VGND VPWR VPWR sky130_fd_sc_hd__fill_4
XFILLER_17_765 VPWR VGND VPWR VGND sky130_ef_sc_hd__decap_40_12
XFILLER_90_189 VGND VGND VPWR VPWR sky130_fd_sc_hd__fill_1
XTAP_TAPCELL_ROW_63_1249 VGND VPWR sky130_fd_sc_hd__tapvpwrvgnd_1
XTAP_TAPCELL_ROW_63_1238 VGND VPWR sky130_fd_sc_hd__tapvpwrvgnd_1
XFILLER_44_595 VGND VGND VPWR VPWR sky130_fd_sc_hd__fill_1
XFILLER_32_735 VGND VGND VPWR VPWR sky130_fd_sc_hd__fill_1
XFILLER_32_757 VPWR VGND VPWR VGND sky130_ef_sc_hd__decap_40_12
XANTENNA__3458__S _3463_/S VGND VGND VPWR VPWR sky130_fd_sc_hd__diode_2
XFILLER_129_111 VGND VGND VPWR VPWR sky130_fd_sc_hd__fill_1
X_2750_ hold849/X _5234_/A0 _2753_/S VGND VGND VPWR VPWR _2750_/X sky130_fd_sc_hd__mux2_1
XFILLER_31_289 VGND VGND VPWR VPWR sky130_fd_sc_hd__fill_2
X_2681_ _2681_/A _2681_/B VGND VGND VPWR VPWR _4868_/A sky130_fd_sc_hd__nand2_8
XFILLER_117_339 VGND VGND VPWR VPWR sky130_fd_sc_hd__fill_1
X_4420_ _4887_/A1 _4445_/B _3801_/B VGND VGND VPWR VPWR _4420_/X sky130_fd_sc_hd__a21o_1
XANTENNA__4430__X _4430_/X VGND VGND VPWR VPWR sky130_fd_sc_hd__diode_2
XTAP_TAPCELL_ROW_78_1470 VGND VPWR sky130_fd_sc_hd__tapvpwrvgnd_1
XANTENNA__3723__A1 _4929_/A1 VGND VGND VPWR VPWR sky130_fd_sc_hd__diode_2
XANTENNA__4289__S _4294_/S VGND VGND VPWR VPWR sky130_fd_sc_hd__diode_2
X_4351_ _4351_/A0 _5042_/A1 _4356_/S VGND VGND VPWR VPWR _4351_/X sky130_fd_sc_hd__mux2_1
X_3302_ hold260/X _5075_/A0 _3308_/S VGND VGND VPWR VPWR _3302_/X sky130_fd_sc_hd__mux2_1
X_4282_ hold445/X _5045_/A1 _4284_/S VGND VGND VPWR VPWR _4282_/X sky130_fd_sc_hd__mux2_1
XFILLER_101_729 VPWR VGND VPWR VGND sky130_ef_sc_hd__decap_40_12
XTAP_TAPCELL_ROW_91_1670 VGND VPWR sky130_fd_sc_hd__tapvpwrvgnd_1
X_3233_ _3232_/A _3553_/C _3801_/A VGND VGND VPWR VPWR _3234_/B sky130_fd_sc_hd__a21o_1
XANTENNA_clkbuf_3_3__f_clk_A clkbuf_0_clk/X VGND VGND VPWR VPWR sky130_fd_sc_hd__diode_2
X_6021_ _6312_/CLK _6021_/D VGND VGND VPWR VPWR _6021_/Q sky130_fd_sc_hd__dfxtp_1
XFILLER_100_239 VGND VGND VPWR VPWR sky130_fd_sc_hd__fill_1
XFILLER_104_29 VGND VGND VPWR VPWR sky130_fd_sc_hd__fill_8
XFILLER_94_440 VGND VGND VPWR VPWR sky130_fd_sc_hd__fill_4
XFILLER_66_153 VGND VGND VPWR VPWR sky130_fd_sc_hd__fill_1
X_3164_ _4213_/S _3167_/C _5085_/A VGND VGND VPWR VPWR _3164_/Y sky130_fd_sc_hd__a21oi_1
X_3095_ _6182_/Q _6206_/Q _6194_/Q _5488_/Q _3062_/S _3034_/A VGND VGND VPWR VPWR
+ _3095_/X sky130_fd_sc_hd__mux4_1
XFILLER_94_473 VGND VGND VPWR VPWR sky130_fd_sc_hd__fill_2
XFILLER_54_315 VGND VGND VPWR VPWR sky130_fd_sc_hd__fill_1
XFILLER_54_304 VGND VGND VPWR VPWR sky130_fd_sc_hd__fill_4
XANTENNA__3239__B1 _3801_/A VGND VGND VPWR VPWR sky130_fd_sc_hd__diode_2
XFILLER_70_819 VGND VGND VPWR VPWR sky130_fd_sc_hd__fill_1
XFILLER_54_348 VGND VGND VPWR VPWR sky130_fd_sc_hd__fill_2
XFILLER_50_543 VGND VGND VPWR VPWR sky130_fd_sc_hd__fill_1
XFILLER_23_735 VGND VGND VPWR VPWR sky130_fd_sc_hd__fill_1
XANTENNA__4739__B1 _4792_/A1 VGND VGND VPWR VPWR sky130_fd_sc_hd__diode_2
X_5805_ _6380_/CLK _5805_/D VGND VGND VPWR VPWR _5805_/Q sky130_fd_sc_hd__dfxtp_1
X_3997_ _3996_/Y _5915_/Q _3997_/S VGND VGND VPWR VPWR _3997_/X sky130_fd_sc_hd__mux2_1
XFILLER_13_15 VGND VGND VPWR VPWR sky130_fd_sc_hd__fill_4
XFILLER_129_15 VPWR VGND VPWR VGND sky130_ef_sc_hd__decap_40_12
X_2948_ _6156_/Q _6225_/Q _3062_/S VGND VGND VPWR VPWR _2948_/X sky130_fd_sc_hd__mux2_1
XANTENNA__3411__A0 _4983_/A1 VGND VGND VPWR VPWR sky130_fd_sc_hd__diode_2
X_5736_ _5908_/CLK _5736_/D VGND VGND VPWR VPWR _5736_/Q sky130_fd_sc_hd__dfxtp_1
XTAP_TAPCELL_ROW_33_796 VGND VPWR sky130_fd_sc_hd__tapvpwrvgnd_1
X_5667_ _5898_/CLK _5667_/D VGND VGND VPWR VPWR _5667_/Q sky130_fd_sc_hd__dfxtp_1
XFILLER_136_637 VGND VGND VPWR VPWR sky130_fd_sc_hd__fill_4
X_2879_ _5242_/Q _6247_/Q _5407_/Q _5505_/Q _3051_/S _3050_/A VGND VGND VPWR VPWR
+ _2879_/X sky130_fd_sc_hd__mux4_1
XFILLER_89_19 VPWR VGND VPWR VGND sky130_ef_sc_hd__decap_40_12
X_4618_ _4618_/A0 hold443/X _4618_/A2 _4618_/A3 _4773_/S _4789_/A VGND VGND VPWR VPWR
+ _4618_/X sky130_fd_sc_hd__mux4_1
XANTENNA_fanout111_X _4976_/A1 VGND VGND VPWR VPWR sky130_fd_sc_hd__diode_2
X_5598_ _6094_/CLK _5598_/D VGND VGND VPWR VPWR _5598_/Q sky130_fd_sc_hd__dfxtp_1
XANTENNA__4062__S1 _4263_/A VGND VGND VPWR VPWR sky130_fd_sc_hd__diode_2
XANTENNA__3714__A1 _5044_/A1 VGND VGND VPWR VPWR sky130_fd_sc_hd__diode_2
Xhold463 _5535_/Q VGND VGND VPWR VPWR hold463/X sky130_fd_sc_hd__dlygate4sd3_1
Xhold452 _4547_/X VGND VGND VPWR VPWR _6149_/D sky130_fd_sc_hd__dlygate4sd3_1
X_4549_ _5225_/B _4881_/B VGND VGND VPWR VPWR _4561_/S sky130_fd_sc_hd__nor2_8
Xhold430 _3742_/X VGND VGND VPWR VPWR _5756_/D sky130_fd_sc_hd__dlygate4sd3_1
Xhold441 _5794_/Q VGND VGND VPWR VPWR hold441/X sky130_fd_sc_hd__dlygate4sd3_1
XFILLER_104_545 VPWR VGND VPWR VGND sky130_ef_sc_hd__decap_40_12
Xhold485 _5277_/Q VGND VGND VPWR VPWR hold485/X sky130_fd_sc_hd__dlygate4sd3_1
Xhold474 _4276_/X VGND VGND VPWR VPWR _5928_/D sky130_fd_sc_hd__dlygate4sd3_1
Xhold496 _3632_/X VGND VGND VPWR VPWR _5660_/D sky130_fd_sc_hd__dlygate4sd3_1
XFILLER_104_589 VPWR VGND VPWR VGND sky130_ef_sc_hd__decap_40_12
X_6219_ _6232_/CLK _6219_/D VGND VGND VPWR VPWR _6219_/Q sky130_fd_sc_hd__dfxtp_1
XANTENNA__4927__S _4934_/S VGND VGND VPWR VPWR sky130_fd_sc_hd__diode_2
XFILLER_58_643 VGND VGND VPWR VPWR sky130_fd_sc_hd__fill_1
XANTENNA__4675__C1 _5401_/Q VGND VGND VPWR VPWR sky130_fd_sc_hd__diode_2
XFILLER_38_23 VGND VGND VPWR VPWR sky130_fd_sc_hd__fill_2
Xhold1141 _2673_/X VGND VGND VPWR VPWR _5246_/D sky130_fd_sc_hd__dlygate4sd3_1
Xhold1130 _5624_/Q VGND VGND VPWR VPWR _3590_/A0 sky130_fd_sc_hd__dlygate4sd3_1
XANTENNA_fanout69_A _2636_/Y VGND VGND VPWR VPWR sky130_fd_sc_hd__diode_2
Xhold1152 _5869_/Q VGND VGND VPWR VPWR _3889_/A0 sky130_fd_sc_hd__dlygate4sd3_1
Xhold1163 _6044_/Q VGND VGND VPWR VPWR _4406_/A1 sky130_fd_sc_hd__dlygate4sd3_1
XFILLER_18_529 VGND VGND VPWR VPWR sky130_fd_sc_hd__fill_2
Xhold1185 _6124_/Q VGND VGND VPWR VPWR _4521_/A0 sky130_fd_sc_hd__dlygate4sd3_1
Xhold1174 _4511_/X VGND VGND VPWR VPWR _6115_/D sky130_fd_sc_hd__dlygate4sd3_1
XANTENNA__3132__A _5200_/A VGND VGND VPWR VPWR sky130_fd_sc_hd__diode_2
XFILLER_38_89 VGND VGND VPWR VPWR sky130_fd_sc_hd__fill_1
XFILLER_73_679 VGND VGND VPWR VPWR sky130_fd_sc_hd__fill_1
Xhold1196 _6322_/Q VGND VGND VPWR VPWR _4990_/A0 sky130_fd_sc_hd__dlygate4sd3_1
XFILLER_45_337 VPWR VGND VPWR VGND sky130_ef_sc_hd__decap_40_12
XANTENNA__4442__A2 _4994_/B VGND VGND VPWR VPWR sky130_fd_sc_hd__diode_2
XFILLER_60_318 VGND VGND VPWR VPWR sky130_fd_sc_hd__fill_8
XFILLER_14_713 VPWR VGND VPWR VGND sky130_ef_sc_hd__decap_40_12
XFILLER_26_551 VGND VGND VPWR VPWR sky130_fd_sc_hd__fill_1
XTAP_TAPCELL_ROW_103_1839 VGND VPWR sky130_fd_sc_hd__tapvpwrvgnd_1
XFILLER_14_757 VPWR VGND VPWR VGND sky130_ef_sc_hd__decap_40_12
XTAP_TAPCELL_ROW_136_2338 VGND VPWR sky130_fd_sc_hd__tapvpwrvgnd_1
XFILLER_127_615 VGND VGND VPWR VPWR sky130_fd_sc_hd__fill_1
XFILLER_70_65 VGND VGND VPWR VPWR sky130_fd_sc_hd__fill_2
XFILLER_70_98 VGND VGND VPWR VPWR sky130_fd_sc_hd__fill_1
XTAP_TAPCELL_ROW_11_468 VGND VPWR sky130_fd_sc_hd__tapvpwrvgnd_1
Xclkload19 _6307_/CLK VGND VGND VPWR VPWR clkload19/Y sky130_fd_sc_hd__bufinv_16
XANTENNA__2689__Y _4547_/S VGND VGND VPWR VPWR sky130_fd_sc_hd__diode_2
XFILLER_123_821 VPWR VGND VPWR VGND sky130_ef_sc_hd__decap_40_12
XANTENNA__4902__A0 _5812_/Q VGND VGND VPWR VPWR sky130_fd_sc_hd__diode_2
XFILLER_122_331 VGND VGND VPWR VPWR sky130_fd_sc_hd__fill_2
XANTENNA__3469__A0 _5241_/A1 VGND VGND VPWR VPWR sky130_fd_sc_hd__diode_2
XANTENNA__4837__S _4841_/S VGND VGND VPWR VPWR sky130_fd_sc_hd__diode_2
XFILLER_96_749 VGND VGND VPWR VPWR sky130_fd_sc_hd__fill_4
XANTENNA__3741__S _3745_/S VGND VGND VPWR VPWR sky130_fd_sc_hd__diode_2
XFILLER_49_676 VGND VGND VPWR VPWR sky130_fd_sc_hd__fill_4
XFILLER_48_153 VGND VGND VPWR VPWR sky130_fd_sc_hd__fill_1
XFILLER_0_193 VGND VGND VPWR VPWR sky130_fd_sc_hd__fill_2
XFILLER_76_473 VGND VGND VPWR VPWR sky130_fd_sc_hd__fill_1
XFILLER_49_698 VGND VGND VPWR VPWR sky130_fd_sc_hd__fill_4
XFILLER_48_186 VGND VGND VPWR VPWR sky130_fd_sc_hd__fill_1
XFILLER_48_197 VGND VGND VPWR VPWR sky130_fd_sc_hd__fill_1
XANTENNA__4969__A0 _5042_/A1 VGND VGND VPWR VPWR sky130_fd_sc_hd__diode_2
XFILLER_64_679 VGND VGND VPWR VPWR sky130_fd_sc_hd__fill_2
XFILLER_51_318 VGND VGND VPWR VPWR sky130_fd_sc_hd__fill_2
XANTENNA__4433__A2 _4457_/S VGND VGND VPWR VPWR sky130_fd_sc_hd__diode_2
XFILLER_17_573 VPWR VGND VPWR VGND sky130_ef_sc_hd__decap_40_12
XTAP_TAPCELL_ROW_19_579 VGND VPWR sky130_fd_sc_hd__tapvpwrvgnd_1
X_3920_ _3920_/A0 _4484_/A0 _3928_/S VGND VGND VPWR VPWR _3920_/X sky130_fd_sc_hd__mux2_1
XFILLER_60_841 VGND VGND VPWR VPWR sky130_fd_sc_hd__fill_1
X_3851_ input24/X _3837_/A _4922_/C _3850_/X _5176_/A VGND VGND VPWR VPWR _5839_/D
+ sky130_fd_sc_hd__o311a_1
X_2802_ _2797_/X _2801_/X _2995_/A VGND VGND VPWR VPWR _2802_/Y sky130_fd_sc_hd__o21ai_1
XFILLER_20_749 VGND VGND VPWR VPWR sky130_fd_sc_hd__fill_4
X_3782_ hold977/X _5211_/A1 _3787_/S VGND VGND VPWR VPWR _3782_/X sky130_fd_sc_hd__mux2_1
X_5521_ _6233_/CLK _5521_/D VGND VGND VPWR VPWR _5521_/Q sky130_fd_sc_hd__dfxtp_1
X_2733_ _5222_/A _2735_/B VGND VGND VPWR VPWR _2733_/Y sky130_fd_sc_hd__nor2_1
XTAP_TAPCELL_ROW_30_744 VGND VPWR sky130_fd_sc_hd__tapvpwrvgnd_1
XTAP_TAPCELL_ROW_30_755 VGND VPWR sky130_fd_sc_hd__tapvpwrvgnd_1
XANTENNA__2820__S _3077_/S VGND VGND VPWR VPWR sky130_fd_sc_hd__diode_2
XFILLER_118_637 VGND VGND VPWR VPWR sky130_fd_sc_hd__fill_4
XFILLER_117_103 VGND VGND VPWR VPWR sky130_fd_sc_hd__fill_1
XFILLER_9_783 VGND VGND VPWR VPWR sky130_fd_sc_hd__fill_1
X_2664_ _2722_/A _2722_/B _2722_/C _2664_/D VGND VGND VPWR VPWR _2666_/B sky130_fd_sc_hd__or4_1
X_5452_ _5731_/CLK _5452_/D VGND VGND VPWR VPWR _5452_/Q sky130_fd_sc_hd__dfxtp_1
XFILLER_133_629 VPWR VGND VPWR VGND sky130_ef_sc_hd__decap_40_12
XFILLER_126_681 VPWR VGND VPWR VGND sky130_ef_sc_hd__decap_40_12
X_5383_ _6123_/CLK _5383_/D VGND VGND VPWR VPWR _5383_/Q sky130_fd_sc_hd__dfxtp_2
X_4403_ _4981_/A1 _4403_/A1 _4406_/S VGND VGND VPWR VPWR _4403_/X sky130_fd_sc_hd__mux2_1
X_4334_ _5046_/A1 _4334_/A1 _4335_/S VGND VGND VPWR VPWR _4334_/X sky130_fd_sc_hd__mux2_1
Xfanout206 _3801_/A VGND VGND VPWR VPWR _5222_/A sky130_fd_sc_hd__buf_4
XFILLER_87_727 VGND VGND VPWR VPWR sky130_fd_sc_hd__fill_1
XFILLER_115_39 VGND VGND VPWR VPWR sky130_fd_sc_hd__fill_8
XANTENNA__3504__X _3516_/S VGND VGND VPWR VPWR sky130_fd_sc_hd__diode_2
X_4265_ _5954_/Q _6342_/Q _5936_/Q _6325_/Q _4228_/S _4263_/A VGND VGND VPWR VPWR
+ _4265_/X sky130_fd_sc_hd__mux4_1
X_6004_ _6345_/CLK hold46/X VGND VGND VPWR VPWR hold45/A sky130_fd_sc_hd__dfxtp_1
X_3216_ _5233_/A0 _3216_/A1 _3220_/S VGND VGND VPWR VPWR _3216_/X sky130_fd_sc_hd__mux2_1
XFILLER_101_559 VGND VGND VPWR VPWR sky130_fd_sc_hd__fill_1
X_4196_ _6305_/Q _6287_/Q _4257_/S VGND VGND VPWR VPWR _4197_/B sky130_fd_sc_hd__mux2_1
XFILLER_28_805 VGND VGND VPWR VPWR sky130_fd_sc_hd__fill_4
X_3147_ _4002_/B hold8/X _3156_/S VGND VGND VPWR VPWR _3147_/X sky130_fd_sc_hd__mux2_1
XFILLER_131_27 VPWR VGND VPWR VGND sky130_ef_sc_hd__decap_40_12
XFILLER_27_337 VGND VGND VPWR VPWR sky130_fd_sc_hd__fill_2
XTAP_TAPCELL_ROW_120_2106 VGND VPWR sky130_fd_sc_hd__tapvpwrvgnd_1
X_3078_ _3092_/A _5524_/Q VGND VGND VPWR VPWR _3078_/X sky130_fd_sc_hd__and2_1
XANTENNA__4424__A2 _4994_/B VGND VGND VPWR VPWR sky130_fd_sc_hd__diode_2
XTAP_TAPCELL_ROW_38_866 VGND VPWR sky130_fd_sc_hd__tapvpwrvgnd_1
XTAP_TAPCELL_ROW_38_877 VGND VPWR sky130_fd_sc_hd__tapvpwrvgnd_1
XFILLER_51_841 VGND VGND VPWR VPWR sky130_fd_sc_hd__fill_1
XANTENNA_fanout159_X _4205_/A VGND VGND VPWR VPWR sky130_fd_sc_hd__diode_2
XFILLER_24_58 VGND VGND VPWR VPWR sky130_fd_sc_hd__fill_4
XANTENNA__4807__S0 _4810_/S VGND VGND VPWR VPWR sky130_fd_sc_hd__diode_2
XFILLER_11_727 VGND VGND VPWR VPWR sky130_fd_sc_hd__fill_1
XFILLER_109_615 VGND VGND VPWR VPWR sky130_fd_sc_hd__fill_1
XFILLER_7_709 VPWR VGND VPWR VGND sky130_ef_sc_hd__decap_40_12
XTAP_TAPCELL_ROW_118_2068 VGND VPWR sky130_fd_sc_hd__tapvpwrvgnd_1
X_5719_ _5902_/CLK _5719_/D VGND VGND VPWR VPWR _5719_/Q sky130_fd_sc_hd__dfxtp_1
XFILLER_109_659 VPWR VGND VPWR VGND sky130_ef_sc_hd__decap_40_12
XFILLER_136_489 VPWR VGND VPWR VGND sky130_ef_sc_hd__decap_40_12
XFILLER_123_117 VGND VGND VPWR VPWR sky130_fd_sc_hd__fill_1
XFILLER_105_821 VPWR VGND VPWR VGND sky130_ef_sc_hd__decap_40_12
XANTENNA__3699__A0 _5208_/A1 VGND VGND VPWR VPWR sky130_fd_sc_hd__diode_2
XFILLER_40_79 VGND VGND VPWR VPWR sky130_fd_sc_hd__fill_4
XTAP_TAPCELL_ROW_131_2268 VGND VPWR sky130_fd_sc_hd__tapvpwrvgnd_1
Xhold260 _5420_/Q VGND VGND VPWR VPWR hold260/X sky130_fd_sc_hd__dlygate4sd3_1
XANTENNA__4360__A1 _5053_/A1 VGND VGND VPWR VPWR sky130_fd_sc_hd__diode_2
Xhold271 _3766_/X VGND VGND VPWR VPWR _5777_/D sky130_fd_sc_hd__dlygate4sd3_1
XFILLER_120_813 VPWR VGND VPWR VGND sky130_ef_sc_hd__decap_40_12
XFILLER_104_353 VGND VGND VPWR VPWR sky130_fd_sc_hd__fill_4
XFILLER_2_469 VGND VGND VPWR VPWR sky130_fd_sc_hd__fill_4
Xhold293 _6104_/Q VGND VGND VPWR VPWR hold293/X sky130_fd_sc_hd__dlygate4sd3_1
Xhold282 _5675_/Q VGND VGND VPWR VPWR hold282/X sky130_fd_sc_hd__dlygate4sd3_1
XTAP_TAPCELL_ROW_113_1990 VGND VPWR sky130_fd_sc_hd__tapvpwrvgnd_1
XFILLER_78_738 VGND VGND VPWR VPWR sky130_fd_sc_hd__fill_2
XFILLER_1_18 VPWR VGND VPWR VGND sky130_ef_sc_hd__decap_40_12
XANTENNA__2674__A1 _4904_/A0 VGND VGND VPWR VPWR sky130_fd_sc_hd__diode_2
XFILLER_100_581 VGND VGND VPWR VPWR sky130_fd_sc_hd__fill_4
XFILLER_86_793 VPWR VGND VPWR VGND sky130_ef_sc_hd__decap_40_12
XANTENNA__3871__A0 _4484_/A0 VGND VGND VPWR VPWR sky130_fd_sc_hd__diode_2
XTAP_TAPCELL_ROW_47_1008 VGND VPWR sky130_fd_sc_hd__tapvpwrvgnd_1
XFILLER_45_167 VGND VGND VPWR VPWR sky130_fd_sc_hd__fill_1
XFILLER_60_115 VGND VGND VPWR VPWR sky130_fd_sc_hd__fill_1
XFILLER_42_841 VGND VGND VPWR VPWR sky130_fd_sc_hd__fill_1
XTAP_TAPCELL_ROW_16_538 VGND VPWR sky130_fd_sc_hd__tapvpwrvgnd_1
XFILLER_14_587 VGND VGND VPWR VPWR sky130_fd_sc_hd__fill_1
XANTENNA__3926__A1 _3926_/A1 VGND VGND VPWR VPWR sky130_fd_sc_hd__diode_2
XFILLER_127_412 VGND VGND VPWR VPWR sky130_fd_sc_hd__fill_1
XANTENNA__3736__S _3745_/S VGND VGND VPWR VPWR sky130_fd_sc_hd__diode_2
XFILLER_10_793 VPWR VGND VPWR VGND sky130_ef_sc_hd__decap_40_12
XFILLER_6_753 VGND VGND VPWR VPWR sky130_fd_sc_hd__fill_2
XFILLER_115_629 VPWR VGND VPWR VGND sky130_ef_sc_hd__decap_40_12
XFILLER_108_681 VPWR VGND VPWR VGND sky130_ef_sc_hd__decap_40_12
XANTENNA__4351__A1 _5042_/A1 VGND VGND VPWR VPWR sky130_fd_sc_hd__diode_2
XFILLER_123_673 VPWR VGND VPWR VGND sky130_ef_sc_hd__decap_40_12
XANTENNA__2876__A _3050_/A VGND VGND VPWR VPWR sky130_fd_sc_hd__diode_2
XANTENNA__3471__S _3477_/S VGND VGND VPWR VPWR sky130_fd_sc_hd__diode_2
XFILLER_122_172 VGND VGND VPWR VPWR sky130_fd_sc_hd__fill_1
XTAP_TAPCELL_ROW_71_1359 VGND VPWR sky130_fd_sc_hd__tapvpwrvgnd_1
XFILLER_96_557 VPWR VGND VPWR VGND sky130_ef_sc_hd__decap_40_12
XFILLER_68_248 VGND VGND VPWR VPWR sky130_fd_sc_hd__fill_1
X_4050_ _4251_/A _4050_/B VGND VGND VPWR VPWR _4050_/X sky130_fd_sc_hd__or2_1
X_3001_ hold429/X hold849/X _3030_/S VGND VGND VPWR VPWR _3001_/X sky130_fd_sc_hd__mux2_1
XFILLER_76_270 VGND VGND VPWR VPWR sky130_fd_sc_hd__fill_1
Xinput6 s_axil_arvalid VGND VGND VPWR VPWR input6/X sky130_fd_sc_hd__buf_1
XFILLER_64_454 VGND VGND VPWR VPWR sky130_fd_sc_hd__fill_1
XANTENNA__2815__S _3072_/S VGND VGND VPWR VPWR sky130_fd_sc_hd__diode_2
XTAP_TAPCELL_ROW_86_1591 VGND VPWR sky130_fd_sc_hd__tapvpwrvgnd_1
X_4952_ _5045_/A1 _4952_/A1 _4954_/S VGND VGND VPWR VPWR _4952_/X sky130_fd_sc_hd__mux2_1
XFILLER_33_841 VGND VGND VPWR VPWR sky130_fd_sc_hd__fill_1
XTAP_TAPCELL_ROW_35_825 VGND VPWR sky130_fd_sc_hd__tapvpwrvgnd_1
XANTENNA__4811__C1 _4811_/C1 VGND VGND VPWR VPWR sky130_fd_sc_hd__diode_2
X_4883_ hold718/X _4883_/A1 _4893_/S VGND VGND VPWR VPWR _4883_/X sky130_fd_sc_hd__mux2_1
X_3903_ hold491/X _5211_/A1 _3908_/S VGND VGND VPWR VPWR _3903_/X sky130_fd_sc_hd__mux2_1
X_3834_ _4910_/A _3834_/B VGND VGND VPWR VPWR _3834_/X sky130_fd_sc_hd__and2_1
XFILLER_20_513 VPWR VGND VPWR VGND sky130_ef_sc_hd__decap_40_12
XFILLER_32_362 VGND VGND VPWR VPWR sky130_fd_sc_hd__fill_2
XFILLER_32_373 VGND VGND VPWR VPWR sky130_fd_sc_hd__fill_2
XANTENNA__4265__S1 _4263_/A VGND VGND VPWR VPWR sky130_fd_sc_hd__diode_2
XFILLER_20_557 VPWR VGND VPWR VGND sky130_ef_sc_hd__decap_40_12
XANTENNA__3917__A1 _5215_/A1 VGND VGND VPWR VPWR sky130_fd_sc_hd__diode_2
X_3765_ _3765_/A0 _4983_/A1 _3766_/S VGND VGND VPWR VPWR _3765_/X sky130_fd_sc_hd__mux2_1
X_5504_ _6432_/CLK _5504_/D VGND VGND VPWR VPWR _5504_/Q sky130_fd_sc_hd__dfxtp_1
XFILLER_118_456 VGND VGND VPWR VPWR sky130_fd_sc_hd__fill_2
X_2716_ _5047_/A1 _2716_/A1 _2716_/S VGND VGND VPWR VPWR _2716_/X sky130_fd_sc_hd__mux2_1
X_3696_ hold111/X _3926_/A1 _3698_/S VGND VGND VPWR VPWR _3696_/X sky130_fd_sc_hd__mux2_1
X_2647_ _2647_/A VGND VGND VPWR VPWR _3207_/B sky130_fd_sc_hd__inv_2
X_5435_ _6408_/CLK _5435_/D VGND VGND VPWR VPWR _5435_/Q sky130_fd_sc_hd__dfxtp_1
XFILLER_126_27 VGND VGND VPWR VPWR sky130_fd_sc_hd__fill_1
XANTENNA__4342__A1 _5044_/A1 VGND VGND VPWR VPWR sky130_fd_sc_hd__diode_2
X_5366_ _6366_/CLK _5366_/D VGND VGND VPWR VPWR _5366_/Q sky130_fd_sc_hd__dfxtp_1
XFILLER_102_813 VPWR VGND VPWR VGND sky130_ef_sc_hd__decap_40_12
X_5297_ _6143_/CLK _5297_/D VGND VGND VPWR VPWR _5297_/Q sky130_fd_sc_hd__dfxtp_1
X_4317_ hold663/X _5051_/A1 _4325_/S VGND VGND VPWR VPWR _4317_/X sky130_fd_sc_hd__mux2_1
X_4248_ _4233_/X _4247_/X _4248_/B1 _4218_/A VGND VGND VPWR VPWR _4248_/X sky130_fd_sc_hd__a2bb2o_1
XFILLER_74_218 VGND VGND VPWR VPWR sky130_fd_sc_hd__fill_2
XFILLER_74_207 VGND VGND VPWR VPWR sky130_fd_sc_hd__fill_4
XFILLER_67_270 VGND VGND VPWR VPWR sky130_fd_sc_hd__fill_8
X_4179_ _5765_/Q _5743_/Q _4250_/S VGND VGND VPWR VPWR _4179_/X sky130_fd_sc_hd__mux2_1
XFILLER_83_785 VPWR VGND VPWR VGND sky130_ef_sc_hd__decap_40_12
XFILLER_70_402 VGND VGND VPWR VPWR sky130_fd_sc_hd__fill_4
XFILLER_35_57 VGND VGND VPWR VPWR sky130_fd_sc_hd__fill_1
XFILLER_42_159 VGND VGND VPWR VPWR sky130_fd_sc_hd__fill_2
XFILLER_42_137 VGND VGND VPWR VPWR sky130_fd_sc_hd__fill_1
XFILLER_24_841 VGND VGND VPWR VPWR sky130_fd_sc_hd__fill_1
XFILLER_23_373 VPWR VGND VPWR VGND sky130_ef_sc_hd__decap_40_12
XANTENNA__4940__S _4944_/S VGND VGND VPWR VPWR sky130_fd_sc_hd__diode_2
Xclkbuf_3_3__f_clk clkbuf_0_clk/X VGND VGND VPWR VPWR clkload2/A sky130_fd_sc_hd__clkbuf_16
XFILLER_11_557 VGND VGND VPWR VPWR sky130_fd_sc_hd__fill_2
XPHY_EDGE_ROW_14_Right_14 VGND VGND VPWR VPWR sky130_fd_sc_hd__decap_3
XFILLER_137_721 VGND VGND VPWR VPWR sky130_fd_sc_hd__fill_4
XFILLER_129_3 VPWR VGND VPWR VGND sky130_ef_sc_hd__decap_40_12
XFILLER_7_517 VPWR VGND VPWR VGND sky130_ef_sc_hd__decap_40_12
XANTENNA__3908__A1 _5202_/A1 VGND VGND VPWR VPWR sky130_fd_sc_hd__diode_2
XFILLER_137_765 VPWR VGND VPWR VGND sky130_ef_sc_hd__decap_40_12
XANTENNA__4241__A _4241_/A VGND VGND VPWR VPWR sky130_fd_sc_hd__diode_2
XANTENNA__4581__A1 _4811_/A1 VGND VGND VPWR VPWR sky130_fd_sc_hd__diode_2
XFILLER_105_673 VPWR VGND VPWR VGND sky130_ef_sc_hd__decap_40_12
XANTENNA_fanout91_X _5208_/A1 VGND VGND VPWR VPWR sky130_fd_sc_hd__diode_2
XANTENNA__3291__S _3295_/S VGND VGND VPWR VPWR sky130_fd_sc_hd__diode_2
XANTENNA__2895__A1 _2995_/A VGND VGND VPWR VPWR sky130_fd_sc_hd__diode_2
XPHY_EDGE_ROW_23_Right_23 VGND VGND VPWR VPWR sky130_fd_sc_hd__decap_3
XANTENNA__2696__A _4263_/A VGND VGND VPWR VPWR sky130_fd_sc_hd__diode_2
XFILLER_120_643 VGND VGND VPWR VPWR sky130_fd_sc_hd__fill_1
XFILLER_104_194 VGND VGND VPWR VPWR sky130_fd_sc_hd__fill_2
XFILLER_93_505 VGND VGND VPWR VPWR sky130_fd_sc_hd__fill_2
XFILLER_76_20 VGND VGND VPWR VPWR sky130_fd_sc_hd__fill_8
XTAP_TAPCELL_ROW_53_1089 VGND VPWR sky130_fd_sc_hd__tapvpwrvgnd_1
XFILLER_93_516 VPWR VGND VPWR VGND sky130_ef_sc_hd__decap_40_12
XFILLER_76_53 VGND VGND VPWR VPWR sky130_fd_sc_hd__fill_4
XFILLER_19_613 VGND VGND VPWR VPWR sky130_fd_sc_hd__fill_2
XFILLER_46_421 VGND VGND VPWR VPWR sky130_fd_sc_hd__fill_2
XFILLER_18_101 VGND VGND VPWR VPWR sky130_fd_sc_hd__fill_4
XFILLER_15_841 VGND VGND VPWR VPWR sky130_fd_sc_hd__fill_1
XPHY_EDGE_ROW_32_Right_32 VGND VGND VPWR VPWR sky130_fd_sc_hd__decap_3
XANTENNA__4850__S _4854_/S VGND VGND VPWR VPWR sky130_fd_sc_hd__diode_2
XFILLER_25_90 VGND VGND VPWR VPWR sky130_fd_sc_hd__fill_1
XFILLER_30_811 VGND VGND VPWR VPWR sky130_fd_sc_hd__fill_1
XFILLER_41_181 VGND VGND VPWR VPWR sky130_fd_sc_hd__fill_1
XANTENNA__3466__S _3477_/S VGND VGND VPWR VPWR sky130_fd_sc_hd__diode_2
XANTENNA__4422__Y _4427_/B VGND VGND VPWR VPWR sky130_fd_sc_hd__diode_2
X_3550_ hold999/X _3926_/A1 _3552_/S VGND VGND VPWR VPWR _3550_/X sky130_fd_sc_hd__mux2_1
XANTENNA__3375__A2 _4457_/S VGND VGND VPWR VPWR sky130_fd_sc_hd__diode_2
XANTENNA__4151__A _4263_/A VGND VGND VPWR VPWR sky130_fd_sc_hd__diode_2
XTAP_TAPCELL_ROW_40_894 VGND VPWR sky130_fd_sc_hd__tapvpwrvgnd_1
X_3481_ hold888/X _4445_/A _3490_/S VGND VGND VPWR VPWR _3481_/X sky130_fd_sc_hd__mux2_1
XFILLER_127_297 VGND VGND VPWR VPWR sky130_fd_sc_hd__fill_1
X_5220_ _3983_/Y _5219_/Y _3958_/Y VGND VGND VPWR VPWR _5221_/S sky130_fd_sc_hd__o21ai_1
XANTENNA__4324__A1 _5046_/A1 VGND VGND VPWR VPWR sky130_fd_sc_hd__diode_2
XANTENNA__3127__A2 _4451_/A VGND VGND VPWR VPWR sky130_fd_sc_hd__diode_2
XFILLER_44_3 VGND VGND VPWR VPWR sky130_fd_sc_hd__fill_1
XPHY_EDGE_ROW_41_Right_41 VGND VGND VPWR VPWR sky130_fd_sc_hd__decap_3
XFILLER_97_833 VGND VGND VPWR VPWR sky130_fd_sc_hd__fill_4
X_5151_ _3945_/A _5160_/A _5150_/Y _2682_/A VGND VGND VPWR VPWR _5151_/X sky130_fd_sc_hd__o211a_1
XFILLER_111_665 VGND VGND VPWR VPWR sky130_fd_sc_hd__fill_4
Xhold1707 _6183_/Q VGND VGND VPWR VPWR _4830_/A1 sky130_fd_sc_hd__dlygate4sd3_1
XFILLER_69_557 VGND VGND VPWR VPWR sky130_fd_sc_hd__fill_2
X_5082_ _5082_/A _5123_/B VGND VGND VPWR VPWR _5219_/A sky130_fd_sc_hd__nor2_1
X_4102_ _4089_/X _4101_/X _5343_/Q VGND VGND VPWR VPWR _4102_/X sky130_fd_sc_hd__mux2_1
X_4033_ _5729_/Q _5459_/Q _5450_/Q _5441_/Q _4237_/S _4251_/A VGND VGND VPWR VPWR
+ _4033_/X sky130_fd_sc_hd__mux4_1
Xhold1718 _3937_/X VGND VGND VPWR VPWR _5913_/D sky130_fd_sc_hd__dlygate4sd3_1
Xhold1729 _6307_/Q VGND VGND VPWR VPWR _4974_/A1 sky130_fd_sc_hd__dlygate4sd3_1
XFILLER_110_186 VGND VGND VPWR VPWR sky130_fd_sc_hd__fill_4
XTAP_TAPCELL_ROW_88_1620 VGND VPWR sky130_fd_sc_hd__tapvpwrvgnd_1
XFILLER_49_281 VGND VGND VPWR VPWR sky130_fd_sc_hd__fill_4
XFILLER_2_83 VGND VGND VPWR VPWR sky130_fd_sc_hd__fill_1
XFILLER_112_29 VPWR VGND VPWR VGND sky130_ef_sc_hd__decap_40_12
XFILLER_65_785 VPWR VGND VPWR VGND sky130_ef_sc_hd__decap_40_12
XFILLER_52_413 VGND VGND VPWR VPWR sky130_fd_sc_hd__fill_4
XPHY_EDGE_ROW_50_Right_50 VGND VGND VPWR VPWR sky130_fd_sc_hd__decap_3
XFILLER_25_638 VGND VGND VPWR VPWR sky130_fd_sc_hd__fill_1
XFILLER_25_649 VGND VGND VPWR VPWR sky130_fd_sc_hd__fill_2
XFILLER_80_755 VGND VGND VPWR VPWR sky130_fd_sc_hd__fill_1
X_5984_ _6341_/CLK _5984_/D VGND VGND VPWR VPWR _5984_/Q sky130_fd_sc_hd__dfxtp_1
XANTENNA__3063__A1 _3062_/S VGND VGND VPWR VPWR sky130_fd_sc_hd__diode_2
X_4935_ _4935_/A _4965_/B VGND VGND VPWR VPWR _4944_/S sky130_fd_sc_hd__or2_4
XFILLER_33_671 VGND VGND VPWR VPWR sky130_fd_sc_hd__fill_1
XFILLER_40_619 VGND VGND VPWR VPWR sky130_fd_sc_hd__fill_1
X_4866_ _4905_/A0 _4866_/A1 _4867_/S VGND VGND VPWR VPWR _4866_/X sky130_fd_sc_hd__mux2_1
XFILLER_21_833 VGND VGND VPWR VPWR sky130_fd_sc_hd__fill_4
XFILLER_138_529 VGND VGND VPWR VPWR sky130_fd_sc_hd__fill_2
XFILLER_119_721 VGND VGND VPWR VPWR sky130_fd_sc_hd__fill_4
X_4797_ _5611_/Q _5692_/Q _6098_/Q _5878_/Q _4795_/S _4794_/A VGND VGND VPWR VPWR
+ _4797_/X sky130_fd_sc_hd__mux4_1
X_3817_ _4914_/A _4883_/A1 _3818_/S VGND VGND VPWR VPWR _5820_/D sky130_fd_sc_hd__mux2_1
XFILLER_20_365 VPWR VGND VPWR VGND sky130_ef_sc_hd__decap_40_12
XFILLER_119_765 VPWR VGND VPWR VGND sky130_ef_sc_hd__decap_40_12
XTAP_TAPCELL_ROW_115_2027 VGND VPWR sky130_fd_sc_hd__tapvpwrvgnd_1
XTAP_TAPCELL_ROW_99_1782 VGND VPWR sky130_fd_sc_hd__tapvpwrvgnd_1
X_3748_ _5040_/A1 _4051_/A0 _3755_/S VGND VGND VPWR VPWR _3748_/X sky130_fd_sc_hd__mux2_1
XFILLER_21_15 VGND VGND VPWR VPWR sky130_fd_sc_hd__fill_4
XFILLER_137_15 VPWR VGND VPWR VGND sky130_ef_sc_hd__decap_40_12
XFILLER_134_713 VPWR VGND VPWR VGND sky130_ef_sc_hd__decap_40_12
XFILLER_134_757 VPWR VGND VPWR VGND sky130_ef_sc_hd__decap_40_12
XFILLER_133_234 VGND VGND VPWR VPWR sky130_fd_sc_hd__fill_1
X_3679_ _4955_/B _3919_/B VGND VGND VPWR VPWR _3688_/S sky130_fd_sc_hd__or2_4
X_5418_ _5753_/CLK _5418_/D VGND VGND VPWR VPWR _5418_/Q sky130_fd_sc_hd__dfxtp_1
XFILLER_88_811 VGND VGND VPWR VPWR sky130_fd_sc_hd__fill_1
X_6398_ _6398_/CLK _6398_/D VGND VGND VPWR VPWR _6398_/Q sky130_fd_sc_hd__dfxtp_1
XANTENNA__4315__A1 _5047_/A1 VGND VGND VPWR VPWR sky130_fd_sc_hd__diode_2
X_5349_ _6146_/CLK _5349_/D VGND VGND VPWR VPWR _5349_/Q sky130_fd_sc_hd__dfxtp_1
XFILLER_87_310 VGND VGND VPWR VPWR sky130_fd_sc_hd__fill_1
XFILLER_0_737 VGND VGND VPWR VPWR sky130_fd_sc_hd__fill_1
XFILLER_102_643 VGND VGND VPWR VPWR sky130_fd_sc_hd__fill_1
XFILLER_101_120 VGND VGND VPWR VPWR sky130_fd_sc_hd__fill_4
XFILLER_0_748 VGND VGND VPWR VPWR sky130_fd_sc_hd__fill_8
XFILLER_47_229 VGND VGND VPWR VPWR sky130_fd_sc_hd__fill_1
XFILLER_28_421 VPWR VGND VPWR VGND sky130_ef_sc_hd__decap_40_12
XTAP_TAPCELL_ROW_126_2189 VGND VPWR sky130_fd_sc_hd__tapvpwrvgnd_1
XFILLER_46_56 VGND VGND VPWR VPWR sky130_fd_sc_hd__fill_1
XFILLER_55_262 VGND VGND VPWR VPWR sky130_fd_sc_hd__fill_1
XANTENNA__4236__A _4251_/A VGND VGND VPWR VPWR sky130_fd_sc_hd__diode_2
XFILLER_28_487 VGND VGND VPWR VPWR sky130_fd_sc_hd__fill_1
XFILLER_102_51 VGND VGND VPWR VPWR sky130_fd_sc_hd__fill_4
XFILLER_15_159 VGND VGND VPWR VPWR sky130_fd_sc_hd__fill_1
XFILLER_62_55 VGND VGND VPWR VPWR sky130_fd_sc_hd__fill_1
XFILLER_12_811 VGND VGND VPWR VPWR sky130_fd_sc_hd__fill_1
XTAP_TAPCELL_ROW_26_688 VGND VPWR sky130_fd_sc_hd__tapvpwrvgnd_1
Xclkbuf_leaf_50_clk clkload3/A VGND VGND VPWR VPWR _6199_/CLK sky130_fd_sc_hd__clkbuf_8
XANTENNA__2801__A1 _3031_/A1 VGND VGND VPWR VPWR sky130_fd_sc_hd__diode_2
XANTENNA__4038__A1_N _4149_/A VGND VGND VPWR VPWR sky130_fd_sc_hd__diode_2
XFILLER_129_529 VPWR VGND VPWR VGND sky130_ef_sc_hd__decap_40_12
XFILLER_8_837 VGND VGND VPWR VPWR sky130_fd_sc_hd__fill_4
XANTENNA__3286__S _3295_/S VGND VGND VPWR VPWR sky130_fd_sc_hd__diode_2
XANTENNA__4554__A1 _4886_/A1 VGND VGND VPWR VPWR sky130_fd_sc_hd__diode_2
XFILLER_11_376 VPWR VGND VPWR VGND sky130_ef_sc_hd__decap_40_12
XFILLER_137_573 VPWR VGND VPWR VGND sky130_ef_sc_hd__decap_40_12
XPHY_EDGE_ROW_12_Left_151 VGND VGND VPWR VPWR sky130_fd_sc_hd__decap_3
XFILLER_124_201 VGND VGND VPWR VPWR sky130_fd_sc_hd__fill_2
XTAP_TAPCELL_ROW_55_1129 VGND VPWR sky130_fd_sc_hd__tapvpwrvgnd_1
XTAP_TAPCELL_ROW_55_1118 VGND VPWR sky130_fd_sc_hd__tapvpwrvgnd_1
XFILLER_3_553 VGND VGND VPWR VPWR sky130_fd_sc_hd__fill_4
XFILLER_79_833 VGND VGND VPWR VPWR sky130_fd_sc_hd__fill_4
XFILLER_3_597 VPWR VGND VPWR VGND sky130_ef_sc_hd__decap_40_12
XFILLER_78_354 VGND VGND VPWR VPWR sky130_fd_sc_hd__fill_8
XFILLER_120_451 VGND VGND VPWR VPWR sky130_fd_sc_hd__fill_1
XFILLER_94_825 VPWR VGND VPWR VGND sky130_ef_sc_hd__decap_40_12
XFILLER_78_365 VGND VGND VPWR VPWR sky130_fd_sc_hd__fill_2
XANTENNA__4845__S _4854_/S VGND VGND VPWR VPWR sky130_fd_sc_hd__diode_2
XTAP_TAPCELL_ROW_6_391 VGND VPWR sky130_fd_sc_hd__tapvpwrvgnd_1
XPHY_EDGE_ROW_21_Left_160 VGND VGND VPWR VPWR sky130_fd_sc_hd__decap_3
XANTENNA__3293__A1 _4904_/A0 VGND VGND VPWR VPWR sky130_fd_sc_hd__diode_2
XANTENNA__4490__A0 _6416_/Q VGND VGND VPWR VPWR sky130_fd_sc_hd__diode_2
XFILLER_47_785 VPWR VGND VPWR VGND sky130_ef_sc_hd__decap_40_12
XANTENNA__4146__A _4260_/S VGND VGND VPWR VPWR sky130_fd_sc_hd__diode_2
XANTENNA__3050__A _3050_/A VGND VGND VPWR VPWR sky130_fd_sc_hd__diode_2
XFILLER_62_755 VGND VGND VPWR VPWR sky130_fd_sc_hd__fill_1
X_2981_ _2967_/X _2980_/X _2981_/S VGND VGND VPWR VPWR _2981_/X sky130_fd_sc_hd__mux2_1
XTAP_TAPCELL_ROW_83_1550 VGND VPWR sky130_fd_sc_hd__tapvpwrvgnd_1
XFILLER_61_265 VGND VGND VPWR VPWR sky130_fd_sc_hd__fill_1
XTAP_TAPCELL_ROW_45_975 VGND VPWR sky130_fd_sc_hd__tapvpwrvgnd_1
XFILLER_15_671 VGND VGND VPWR VPWR sky130_fd_sc_hd__fill_1
Xclkbuf_leaf_41_clk clkload4/A VGND VGND VPWR VPWR _6435_/CLK sky130_fd_sc_hd__clkbuf_8
XFILLER_14_170 VGND VGND VPWR VPWR sky130_fd_sc_hd__fill_1
X_4720_ _6104_/Q _5893_/Q _6086_/Q _5884_/Q _4801_/S _4802_/A VGND VGND VPWR VPWR
+ _4720_/X sky130_fd_sc_hd__mux4_1
X_4651_ _4651_/A0 hold944/X _4790_/S VGND VGND VPWR VPWR _4651_/X sky130_fd_sc_hd__mux2_1
XANTENNA__4545__A1 _5814_/Q VGND VGND VPWR VPWR sky130_fd_sc_hd__diode_2
X_3602_ _3602_/A0 _4961_/A0 _3605_/S VGND VGND VPWR VPWR _3602_/X sky130_fd_sc_hd__mux2_1
Xinput20 s_axil_wdata[2] VGND VGND VPWR VPWR input20/X sky130_fd_sc_hd__buf_1
XFILLER_116_713 VPWR VGND VPWR VGND sky130_ef_sc_hd__decap_40_12
X_4582_ _4577_/X _4581_/X _4813_/S VGND VGND VPWR VPWR _4582_/Y sky130_fd_sc_hd__o21ai_1
Xhold815 _5245_/Q VGND VGND VPWR VPWR hold815/X sky130_fd_sc_hd__dlygate4sd3_1
XFILLER_116_757 VPWR VGND VPWR VGND sky130_ef_sc_hd__decap_40_12
XFILLER_115_223 VGND VGND VPWR VPWR sky130_fd_sc_hd__fill_1
X_3533_ hold453/X _4846_/A0 _3541_/S VGND VGND VPWR VPWR _3533_/X sky130_fd_sc_hd__mux2_1
Xhold804 _3548_/X VGND VGND VPWR VPWR _5589_/D sky130_fd_sc_hd__dlygate4sd3_1
X_6321_ _6338_/CLK _6321_/D VGND VGND VPWR VPWR _6321_/Q sky130_fd_sc_hd__dfxtp_1
Xhold837 _5656_/Q VGND VGND VPWR VPWR hold837/X sky130_fd_sc_hd__dlygate4sd3_1
Xhold826 _4931_/X VGND VGND VPWR VPWR _6268_/D sky130_fd_sc_hd__dlygate4sd3_1
X_6252_ _6252_/CLK _6252_/D VGND VGND VPWR VPWR _6252_/Q sky130_fd_sc_hd__dfxtp_1
X_3464_ _5254_/Q _3464_/B _4548_/C VGND VGND VPWR VPWR _3517_/B sky130_fd_sc_hd__or3_4
Xhold848 _4889_/X VGND VGND VPWR VPWR _6238_/D sky130_fd_sc_hd__dlygate4sd3_1
Xhold859 _5989_/Q VGND VGND VPWR VPWR hold859/X sky130_fd_sc_hd__dlygate4sd3_1
XFILLER_131_727 VGND VGND VPWR VPWR sky130_fd_sc_hd__fill_1
XFILLER_130_215 VGND VGND VPWR VPWR sky130_fd_sc_hd__fill_1
X_6183_ _6239_/CLK _6183_/D VGND VGND VPWR VPWR _6183_/Q sky130_fd_sc_hd__dfxtp_1
X_5203_ _3312_/Y _5097_/Y _3343_/C _5208_/A0 VGND VGND VPWR VPWR _5203_/X sky130_fd_sc_hd__o211a_1
XANTENNA__2859__A1 _3076_/A1 VGND VGND VPWR VPWR sky130_fd_sc_hd__diode_2
XFILLER_111_440 VGND VGND VPWR VPWR sky130_fd_sc_hd__fill_2
XFILLER_97_641 VPWR VGND VPWR VGND sky130_ef_sc_hd__decap_40_12
Xhold2227 _5810_/Q VGND VGND VPWR VPWR hold2227/X sky130_fd_sc_hd__dlygate4sd3_1
Xhold2216 _6326_/Q VGND VGND VPWR VPWR hold2216/X sky130_fd_sc_hd__dlygate4sd3_1
X_5134_ _3958_/A _5132_/X _5133_/Y _5137_/B VGND VGND VPWR VPWR _5135_/B sky130_fd_sc_hd__a2bb2o_1
X_3395_ hold199/X _4978_/A1 _3401_/S VGND VGND VPWR VPWR _3395_/X sky130_fd_sc_hd__mux2_1
Xhold2205 _5221_/X VGND VGND VPWR VPWR _5222_/B sky130_fd_sc_hd__dlygate4sd3_1
XFILLER_97_685 VPWR VGND VPWR VGND sky130_ef_sc_hd__decap_40_12
Xhold1515 _5748_/Q VGND VGND VPWR VPWR _3734_/A0 sky130_fd_sc_hd__dlygate4sd3_1
Xhold2238 _5816_/Q VGND VGND VPWR VPWR hold2238/X sky130_fd_sc_hd__dlygate4sd3_1
Xhold1504 _5256_/Q VGND VGND VPWR VPWR _2708_/A1 sky130_fd_sc_hd__dlygate4sd3_1
Xhold1526 _4370_/X VGND VGND VPWR VPWR _6011_/D sky130_fd_sc_hd__dlygate4sd3_1
Xhold2249 _5324_/Q VGND VGND VPWR VPWR _4924_/A sky130_fd_sc_hd__dlygate4sd3_1
XFILLER_123_39 VGND VGND VPWR VPWR sky130_fd_sc_hd__fill_1
XANTENNA_fanout186_A _3020_/A VGND VGND VPWR VPWR sky130_fd_sc_hd__diode_2
XFILLER_96_195 VGND VGND VPWR VPWR sky130_fd_sc_hd__fill_1
Xhold1548 _4487_/X VGND VGND VPWR VPWR _6093_/D sky130_fd_sc_hd__dlygate4sd3_1
X_5065_ _5065_/A0 _3322_/B _5207_/S VGND VGND VPWR VPWR _5065_/X sky130_fd_sc_hd__mux2_1
Xhold1559 _5845_/Q VGND VGND VPWR VPWR _3863_/A1 sky130_fd_sc_hd__dlygate4sd3_1
Xhold1537 _5699_/Q VGND VGND VPWR VPWR _3676_/A1 sky130_fd_sc_hd__dlygate4sd3_1
XANTENNA__3284__A1 _5238_/A1 VGND VGND VPWR VPWR sky130_fd_sc_hd__diode_2
X_4016_ _3987_/B _5048_/B VGND VGND VPWR VPWR _5218_/B sky130_fd_sc_hd__nand2b_1
XFILLER_53_733 VGND VGND VPWR VPWR sky130_fd_sc_hd__fill_2
XFILLER_16_15 VPWR VGND VPWR VGND sky130_ef_sc_hd__decap_40_12
XFILLER_53_766 VPWR VGND VPWR VGND sky130_ef_sc_hd__decap_40_12
XFILLER_25_457 VGND VGND VPWR VPWR sky130_fd_sc_hd__fill_2
XANTENNA__3036__A1 _3036_/A1 VGND VGND VPWR VPWR sky130_fd_sc_hd__diode_2
X_5967_ clkload8/A _5967_/D VGND VGND VPWR VPWR _5967_/Q sky130_fd_sc_hd__dfxtp_1
XFILLER_40_405 VGND VGND VPWR VPWR sky130_fd_sc_hd__fill_2
Xclkbuf_leaf_32_clk clkload4/A VGND VGND VPWR VPWR _6369_/CLK sky130_fd_sc_hd__clkbuf_8
XANTENNA__4490__S _4492_/S VGND VGND VPWR VPWR sky130_fd_sc_hd__diode_2
X_4918_ _4918_/A _4922_/B _4922_/C VGND VGND VPWR VPWR _4918_/X sky130_fd_sc_hd__or3_1
XANTENNA_fanout141_X _4802_/A VGND VGND VPWR VPWR sky130_fd_sc_hd__diode_2
XTAP_TAPCELL_ROW_23_647 VGND VPWR sky130_fd_sc_hd__tapvpwrvgnd_1
X_5898_ _5898_/CLK _5898_/D VGND VGND VPWR VPWR _5898_/Q sky130_fd_sc_hd__dfxtp_1
XANTENNA__3992__C1 _5034_/B VGND VGND VPWR VPWR sky130_fd_sc_hd__diode_2
XFILLER_138_337 VGND VGND VPWR VPWR sky130_fd_sc_hd__fill_1
XANTENNA__4536__A1 _5821_/Q VGND VGND VPWR VPWR sky130_fd_sc_hd__diode_2
X_4849_ _4901_/A0 _4849_/A1 _4854_/S VGND VGND VPWR VPWR _4849_/X sky130_fd_sc_hd__mux2_1
XFILLER_119_573 VPWR VGND VPWR VGND sky130_ef_sc_hd__decap_40_12
XFILLER_134_587 VGND VGND VPWR VPWR sky130_fd_sc_hd__fill_1
XFILLER_122_749 VGND VGND VPWR VPWR sky130_fd_sc_hd__fill_4
XFILLER_106_289 VGND VGND VPWR VPWR sky130_fd_sc_hd__fill_2
XFILLER_0_501 VGND VGND VPWR VPWR sky130_fd_sc_hd__fill_2
XFILLER_88_641 VGND VGND VPWR VPWR sky130_fd_sc_hd__fill_2
XFILLER_0_545 VPWR VGND VPWR VGND sky130_ef_sc_hd__decap_40_12
Xclkbuf_leaf_99_clk clkload0/A VGND VGND VPWR VPWR _6420_/CLK sky130_fd_sc_hd__clkbuf_8
XTAP_TAPCELL_ROW_128_2218 VGND VPWR sky130_fd_sc_hd__tapvpwrvgnd_1
XFILLER_102_451 VGND VGND VPWR VPWR sky130_fd_sc_hd__fill_1
XFILLER_76_825 VPWR VGND VPWR VGND sky130_ef_sc_hd__decap_40_12
XFILLER_76_803 VGND VGND VPWR VPWR sky130_fd_sc_hd__fill_8
XFILLER_0_589 VPWR VGND VPWR VGND sky130_ef_sc_hd__decap_40_12
XFILLER_130_793 VPWR VGND VPWR VGND sky130_ef_sc_hd__decap_40_12
XFILLER_75_313 VGND VGND VPWR VPWR sky130_fd_sc_hd__fill_1
XTAP_TAPCELL_ROW_50_1048 VGND VPWR sky130_fd_sc_hd__tapvpwrvgnd_1
XANTENNA__4472__A0 _5237_/A0 VGND VGND VPWR VPWR sky130_fd_sc_hd__diode_2
XFILLER_75_368 VGND VGND VPWR VPWR sky130_fd_sc_hd__fill_1
XTAP_TAPCELL_ROW_3_350 VGND VPWR sky130_fd_sc_hd__tapvpwrvgnd_1
XFILLER_113_72 VGND VGND VPWR VPWR sky130_fd_sc_hd__fill_2
XFILLER_91_839 VGND VGND VPWR VPWR sky130_fd_sc_hd__fill_1
XFILLER_28_251 VGND VGND VPWR VPWR sky130_fd_sc_hd__fill_1
XFILLER_29_785 VPWR VGND VPWR VGND sky130_ef_sc_hd__decap_40_12
XFILLER_43_243 VGND VGND VPWR VPWR sky130_fd_sc_hd__fill_2
XFILLER_16_457 VPWR VGND VPWR VGND sky130_ef_sc_hd__decap_40_12
XFILLER_43_254 VGND VGND VPWR VPWR sky130_fd_sc_hd__fill_4
XTAP_TAPCELL_ROW_42_923 VGND VPWR sky130_fd_sc_hd__tapvpwrvgnd_1
Xclkbuf_leaf_23_clk clkload3/A VGND VGND VPWR VPWR _6399_/CLK sky130_fd_sc_hd__clkbuf_8
XTAP_TAPCELL_ROW_65_1280 VGND VPWR sky130_fd_sc_hd__tapvpwrvgnd_1
XTAP_TAPCELL_ROW_42_934 VGND VPWR sky130_fd_sc_hd__tapvpwrvgnd_1
XFILLER_31_427 VPWR VGND VPWR VGND sky130_ef_sc_hd__decap_40_12
XFILLER_8_601 VPWR VGND VPWR VGND sky130_ef_sc_hd__decap_40_12
XFILLER_12_641 VGND VGND VPWR VPWR sky130_fd_sc_hd__fill_2
XANTENNA__4527__A1 _4846_/A0 VGND VGND VPWR VPWR sky130_fd_sc_hd__diode_2
XFILLER_8_645 VPWR VGND VPWR VGND sky130_ef_sc_hd__decap_40_12
XFILLER_11_173 VGND VGND VPWR VPWR sky130_fd_sc_hd__fill_1
XANTENNA__3744__S _3745_/S VGND VGND VPWR VPWR sky130_fd_sc_hd__diode_2
XFILLER_113_727 VGND VGND VPWR VPWR sky130_fd_sc_hd__fill_1
XFILLER_3_361 VPWR VGND VPWR VGND sky130_ef_sc_hd__decap_40_12
XANTENNA__2936__S1 _3020_/A VGND VGND VPWR VPWR sky130_fd_sc_hd__diode_2
X_3180_ _5250_/Q _3207_/C _5251_/Q VGND VGND VPWR VPWR _5225_/B sky130_fd_sc_hd__or3b_4
XANTENNA__2710__A0 _5053_/A1 VGND VGND VPWR VPWR sky130_fd_sc_hd__diode_2
XFILLER_93_121 VGND VGND VPWR VPWR sky130_fd_sc_hd__fill_1
XFILLER_66_379 VGND VGND VPWR VPWR sky130_fd_sc_hd__fill_2
XTAP_TAPCELL_ROW_1_309 VGND VPWR sky130_fd_sc_hd__tapvpwrvgnd_1
XANTENNA__4463__A0 _5228_/A0 VGND VGND VPWR VPWR sky130_fd_sc_hd__diode_2
XFILLER_94_699 VGND VGND VPWR VPWR sky130_fd_sc_hd__fill_1
XANTENNA_clkbuf_leaf_62_clk_A clkload5/A VGND VGND VPWR VPWR sky130_fd_sc_hd__diode_2
XFILLER_35_755 VPWR VGND VPWR VGND sky130_ef_sc_hd__decap_40_12
XANTENNA__3018__A1 _3076_/A1 VGND VGND VPWR VPWR sky130_fd_sc_hd__diode_2
XTAP_TAPCELL_ROW_81_1509 VGND VPWR sky130_fd_sc_hd__tapvpwrvgnd_1
X_5821_ _5841_/CLK _5821_/D VGND VGND VPWR VPWR _5821_/Q sky130_fd_sc_hd__dfxtp_1
X_5752_ _6129_/CLK _5752_/D VGND VGND VPWR VPWR _5752_/Q sky130_fd_sc_hd__dfxtp_1
X_2964_ _3031_/A1 _2963_/X _3085_/A VGND VGND VPWR VPWR _2964_/X sky130_fd_sc_hd__o21a_1
XANTENNA__2777__B1 _3094_/C1 VGND VGND VPWR VPWR sky130_fd_sc_hd__diode_2
X_4703_ _5090_/A1 _4702_/X _4786_/S VGND VGND VPWR VPWR _4703_/X sky130_fd_sc_hd__mux2_1
Xclkbuf_leaf_14_clk clkbuf_leaf_9_clk/A VGND VGND VPWR VPWR _6345_/CLK sky130_fd_sc_hd__clkbuf_8
XFILLER_50_769 VPWR VGND VPWR VGND sky130_ef_sc_hd__decap_40_12
XTAP_TAPCELL_ROW_20_606 VGND VPWR sky130_fd_sc_hd__tapvpwrvgnd_1
X_2895_ _2995_/A _2894_/X _2888_/Y _2735_/A VGND VGND VPWR VPWR _2895_/Y sky130_fd_sc_hd__o211ai_1
XANTENNA_clkbuf_leaf_77_clk_A clkload2/A VGND VGND VPWR VPWR sky130_fd_sc_hd__diode_2
X_5683_ _5714_/CLK _5683_/D VGND VGND VPWR VPWR _5683_/Q sky130_fd_sc_hd__dfxtp_1
XANTENNA__4518__A1 _5212_/A1 VGND VGND VPWR VPWR sky130_fd_sc_hd__diode_2
X_4634_ _5798_/Q _5789_/Q _4801_/S VGND VGND VPWR VPWR _4635_/B sky130_fd_sc_hd__mux2_1
Xhold612 _6129_/Q VGND VGND VPWR VPWR hold612/X sky130_fd_sc_hd__dlygate4sd3_1
XTAP_TAPCELL_ROW_96_1741 VGND VPWR sky130_fd_sc_hd__tapvpwrvgnd_1
X_4565_ _4565_/A0 hold890/X _4795_/S VGND VGND VPWR VPWR _4565_/X sky130_fd_sc_hd__mux2_1
Xhold601 _4474_/X VGND VGND VPWR VPWR _6081_/D sky130_fd_sc_hd__dlygate4sd3_1
X_3516_ _5237_/A0 _3516_/A1 _3516_/S VGND VGND VPWR VPWR _3516_/X sky130_fd_sc_hd__mux2_1
Xhold634 _3446_/X VGND VGND VPWR VPWR _5496_/D sky130_fd_sc_hd__dlygate4sd3_1
Xhold645 _5327_/Q VGND VGND VPWR VPWR _4002_/A sky130_fd_sc_hd__dlygate4sd3_1
X_6304_ _6314_/CLK _6304_/D VGND VGND VPWR VPWR _6304_/Q sky130_fd_sc_hd__dfxtp_1
Xhold623 _6021_/Q VGND VGND VPWR VPWR hold623/X sky130_fd_sc_hd__dlygate4sd3_1
Xhold667 _6071_/Q VGND VGND VPWR VPWR hold667/X sky130_fd_sc_hd__dlygate4sd3_1
XFILLER_116_587 VGND VGND VPWR VPWR sky130_fd_sc_hd__fill_1
XFILLER_103_204 VGND VGND VPWR VPWR sky130_fd_sc_hd__fill_4
XFILLER_89_427 VGND VGND VPWR VPWR sky130_fd_sc_hd__fill_2
Xhold678 _3741_/X VGND VGND VPWR VPWR _5755_/D sky130_fd_sc_hd__dlygate4sd3_1
XPHY_EDGE_ROW_4_Right_4 VGND VGND VPWR VPWR sky130_fd_sc_hd__decap_3
X_4496_ hold773/X _5210_/A1 _4502_/S VGND VGND VPWR VPWR _4496_/X sky130_fd_sc_hd__mux2_1
Xhold656 _3922_/X VGND VGND VPWR VPWR _5899_/D sky130_fd_sc_hd__dlygate4sd3_1
XFILLER_131_557 VGND VGND VPWR VPWR sky130_fd_sc_hd__fill_2
XFILLER_104_749 VGND VGND VPWR VPWR sky130_fd_sc_hd__fill_4
X_6235_ _6242_/CLK _6235_/D VGND VGND VPWR VPWR _6235_/Q sky130_fd_sc_hd__dfxtp_1
Xhold689 _2751_/X VGND VGND VPWR VPWR _5281_/D sky130_fd_sc_hd__dlygate4sd3_1
X_3447_ _3447_/A0 _5234_/A0 _3450_/S VGND VGND VPWR VPWR _3447_/X sky130_fd_sc_hd__mux2_1
Xhold2002 _6407_/Q VGND VGND VPWR VPWR _3732_/A1 sky130_fd_sc_hd__dlygate4sd3_1
XFILLER_134_27 VGND VGND VPWR VPWR sky130_fd_sc_hd__fill_1
X_3378_ _3378_/A1 _4457_/S _3376_/X _3377_/X VGND VGND VPWR VPWR _3378_/X sky130_fd_sc_hd__o22a_1
X_6166_ _6382_/CLK _6166_/D VGND VGND VPWR VPWR _6166_/Q sky130_fd_sc_hd__dfxtp_1
Xhold2013 _5141_/X VGND VGND VPWR VPWR _6392_/D sky130_fd_sc_hd__dlygate4sd3_1
Xhold2024 _5809_/Q VGND VGND VPWR VPWR _3802_/A2 sky130_fd_sc_hd__dlygate4sd3_1
XANTENNA_clkbuf_leaf_15_clk_A clkbuf_leaf_9_clk/A VGND VGND VPWR VPWR sky130_fd_sc_hd__diode_2
XFILLER_58_825 VPWR VGND VPWR VGND sky130_ef_sc_hd__decap_40_12
Xhold2035 _3359_/X VGND VGND VPWR VPWR _5433_/D sky130_fd_sc_hd__dlygate4sd3_1
XFILLER_112_793 VPWR VGND VPWR VGND sky130_ef_sc_hd__decap_40_12
Xhold1323 _5633_/Q VGND VGND VPWR VPWR _4648_/A2 sky130_fd_sc_hd__dlygate4sd3_1
Xhold2046 _6261_/Q VGND VGND VPWR VPWR _5190_/A0 sky130_fd_sc_hd__dlygate4sd3_1
X_6097_ _6097_/CLK _6097_/D VGND VGND VPWR VPWR _6097_/Q sky130_fd_sc_hd__dfxtp_1
Xhold1301 _5260_/Q VGND VGND VPWR VPWR _2712_/A1 sky130_fd_sc_hd__dlygate4sd3_1
Xhold2057 _5217_/Y VGND VGND VPWR VPWR _6418_/D sky130_fd_sc_hd__dlygate4sd3_1
Xhold2079 _5223_/X VGND VGND VPWR VPWR _5224_/B1 sky130_fd_sc_hd__dlygate4sd3_1
X_5117_ _5117_/A _5117_/B VGND VGND VPWR VPWR _5218_/C sky130_fd_sc_hd__nor2_1
Xhold1334 _6007_/Q VGND VGND VPWR VPWR _4365_/A0 sky130_fd_sc_hd__dlygate4sd3_1
Xhold1312 _5741_/Q VGND VGND VPWR VPWR _4107_/A1 sky130_fd_sc_hd__dlygate4sd3_1
Xhold2068 _5432_/Q VGND VGND VPWR VPWR _5213_/A0 sky130_fd_sc_hd__dlygate4sd3_1
XANTENNA__4129__S0 _4213_/S VGND VGND VPWR VPWR sky130_fd_sc_hd__diode_2
Xhold1367 _6173_/Q VGND VGND VPWR VPWR _4819_/A1 sky130_fd_sc_hd__dlygate4sd3_1
XANTENNA_fanout189_X _2963_/S VGND VGND VPWR VPWR sky130_fd_sc_hd__diode_2
Xhold1356 _3041_/X VGND VGND VPWR VPWR _5293_/D sky130_fd_sc_hd__dlygate4sd3_1
X_5048_ _5048_/A _5048_/B _4014_/B VGND VGND VPWR VPWR _5048_/X sky130_fd_sc_hd__or3b_1
Xhold1345 _3749_/X VGND VGND VPWR VPWR _5762_/D sky130_fd_sc_hd__dlygate4sd3_1
Xhold1378 _4839_/X VGND VGND VPWR VPWR _6192_/D sky130_fd_sc_hd__dlygate4sd3_1
XFILLER_85_699 VGND VGND VPWR VPWR sky130_fd_sc_hd__fill_1
Xhold1389 _6054_/Q VGND VGND VPWR VPWR _2721_/A sky130_fd_sc_hd__dlygate4sd3_1
XFILLER_72_327 VGND VGND VPWR VPWR sky130_fd_sc_hd__fill_8
XANTENNA__4454__B1 _4427_/B VGND VGND VPWR VPWR sky130_fd_sc_hd__diode_2
XTAP_TAPCELL_ROW_28_717 VGND VPWR sky130_fd_sc_hd__tapvpwrvgnd_1
XFILLER_38_571 VGND VGND VPWR VPWR sky130_fd_sc_hd__fill_2
XTAP_TAPCELL_ROW_123_2148 VGND VPWR sky130_fd_sc_hd__tapvpwrvgnd_1
XFILLER_53_541 VGND VGND VPWR VPWR sky130_fd_sc_hd__fill_2
XFILLER_26_755 VGND VGND VPWR VPWR sky130_fd_sc_hd__fill_1
XFILLER_13_405 VPWR VGND VPWR VGND sky130_ef_sc_hd__decap_40_12
XFILLER_41_714 VGND VGND VPWR VPWR sky130_fd_sc_hd__fill_1
XTAP_TAPCELL_ROW_105_1881 VGND VPWR sky130_fd_sc_hd__tapvpwrvgnd_1
XTAP_TAPCELL_ROW_105_1870 VGND VPWR sky130_fd_sc_hd__tapvpwrvgnd_1
XANTENNA__4757__A1 _3278_/A VGND VGND VPWR VPWR sky130_fd_sc_hd__diode_2
XFILLER_13_449 VPWR VGND VPWR VGND sky130_ef_sc_hd__decap_40_12
XTAP_TAPCELL_ROW_138_2391 VGND VPWR sky130_fd_sc_hd__tapvpwrvgnd_1
XTAP_TAPCELL_ROW_138_2380 VGND VPWR sky130_fd_sc_hd__tapvpwrvgnd_1
XFILLER_126_318 VGND VGND VPWR VPWR sky130_fd_sc_hd__fill_1
XANTENNA__4509__A1 _5213_/A1 VGND VGND VPWR VPWR sky130_fd_sc_hd__diode_2
XFILLER_138_189 VGND VGND VPWR VPWR sky130_fd_sc_hd__fill_1
XFILLER_119_370 VGND VGND VPWR VPWR sky130_fd_sc_hd__fill_1
XFILLER_111_3 VPWR VGND VPWR VGND sky130_ef_sc_hd__decap_40_12
XANTENNA__5182__A1 _3958_/A VGND VGND VPWR VPWR sky130_fd_sc_hd__diode_2
XANTENNA__4604__S1 _4789_/A VGND VGND VPWR VPWR sky130_fd_sc_hd__diode_2
XFILLER_5_615 VGND VGND VPWR VPWR sky130_fd_sc_hd__fill_1
XFILLER_135_841 VGND VGND VPWR VPWR sky130_fd_sc_hd__fill_1
XFILLER_4_147 VGND VGND VPWR VPWR sky130_fd_sc_hd__fill_2
XTAP_TAPCELL_ROW_8_420 VGND VPWR sky130_fd_sc_hd__tapvpwrvgnd_1
XFILLER_4_29 VPWR VGND VPWR VGND sky130_ef_sc_hd__decap_40_12
XFILLER_122_557 VPWR VGND VPWR VGND sky130_ef_sc_hd__decap_40_12
XFILLER_1_821 VPWR VGND VPWR VGND sky130_ef_sc_hd__decap_40_12
XFILLER_0_331 VGND VGND VPWR VPWR sky130_fd_sc_hd__fill_1
XFILLER_75_110 VGND VGND VPWR VPWR sky130_fd_sc_hd__fill_2
XFILLER_48_313 VGND VGND VPWR VPWR sky130_fd_sc_hd__fill_2
XFILLER_75_154 VPWR VGND VPWR VGND sky130_ef_sc_hd__decap_40_12
Xhold1890 _6174_/Q VGND VGND VPWR VPWR _4820_/A1 sky130_fd_sc_hd__dlygate4sd3_1
XFILLER_84_53 VGND VGND VPWR VPWR sky130_fd_sc_hd__fill_2
XFILLER_76_699 VGND VGND VPWR VPWR sky130_fd_sc_hd__fill_1
XFILLER_91_669 VGND VGND VPWR VPWR sky130_fd_sc_hd__fill_2
XFILLER_56_390 VGND VGND VPWR VPWR sky130_fd_sc_hd__fill_1
XFILLER_17_777 VGND VGND VPWR VPWR sky130_fd_sc_hd__fill_4
XFILLER_32_703 VGND VGND VPWR VPWR sky130_fd_sc_hd__fill_2
XANTENNA__3739__S _3745_/S VGND VGND VPWR VPWR sky130_fd_sc_hd__diode_2
XFILLER_90_8 VPWR VGND VPWR VGND sky130_ef_sc_hd__decap_40_12
XTAP_TAPCELL_ROW_63_1239 VGND VPWR sky130_fd_sc_hd__tapvpwrvgnd_1
XFILLER_44_585 VGND VGND VPWR VPWR sky130_fd_sc_hd__fill_2
XFILLER_32_769 VPWR VGND VPWR VGND sky130_ef_sc_hd__decap_40_12
XANTENNA__2854__S0 _2984_/S VGND VGND VPWR VPWR sky130_fd_sc_hd__diode_2
XANTENNA__3420__A1 _4961_/A0 VGND VGND VPWR VPWR sky130_fd_sc_hd__diode_2
XFILLER_31_279 VGND VGND VPWR VPWR sky130_fd_sc_hd__fill_1
XANTENNA__6412__Q _6412_/Q VGND VGND VPWR VPWR sky130_fd_sc_hd__diode_2
XFILLER_129_167 VGND VGND VPWR VPWR sky130_fd_sc_hd__fill_1
X_2680_ _2681_/A _2681_/B VGND VGND VPWR VPWR _2682_/B sky130_fd_sc_hd__or2_1
XFILLER_8_475 VGND VGND VPWR VPWR sky130_fd_sc_hd__fill_1
XFILLER_126_841 VGND VGND VPWR VPWR sky130_fd_sc_hd__fill_1
XANTENNA__3474__S _3477_/S VGND VGND VPWR VPWR sky130_fd_sc_hd__diode_2
XTAP_TAPCELL_ROW_78_1471 VGND VPWR sky130_fd_sc_hd__tapvpwrvgnd_1
X_4350_ hold799/X _5053_/A1 _4356_/S VGND VGND VPWR VPWR _4350_/X sky130_fd_sc_hd__mux2_1
X_3301_ hold37/X _4886_/A1 _3308_/S VGND VGND VPWR VPWR hold38/A sky130_fd_sc_hd__mux2_1
XFILLER_99_725 VGND VGND VPWR VPWR sky130_fd_sc_hd__fill_2
XFILLER_113_557 VGND VGND VPWR VPWR sky130_fd_sc_hd__fill_2
X_4281_ hold311/X _5044_/A1 _4284_/S VGND VGND VPWR VPWR _4281_/X sky130_fd_sc_hd__mux2_1
XFILLER_4_681 VPWR VGND VPWR VGND sky130_ef_sc_hd__decap_40_12
XANTENNA__3487__A1 _4903_/A0 VGND VGND VPWR VPWR sky130_fd_sc_hd__diode_2
XTAP_TAPCELL_ROW_91_1671 VGND VPWR sky130_fd_sc_hd__tapvpwrvgnd_1
XTAP_TAPCELL_ROW_91_1660 VGND VPWR sky130_fd_sc_hd__tapvpwrvgnd_1
XANTENNA_hold2233_A _5811_/Q VGND VGND VPWR VPWR sky130_fd_sc_hd__diode_2
X_3232_ _3232_/A _3553_/C VGND VGND VPWR VPWR _3606_/B sky130_fd_sc_hd__nor2_4
X_6020_ _6349_/CLK hold84/X VGND VGND VPWR VPWR hold83/A sky130_fd_sc_hd__dfxtp_1
Xclkbuf_leaf_3_clk clkbuf_leaf_9_clk/A VGND VGND VPWR VPWR _6334_/CLK sky130_fd_sc_hd__clkbuf_8
XANTENNA__2818__S _3077_/S VGND VGND VPWR VPWR sky130_fd_sc_hd__diode_2
XFILLER_100_229 VGND VGND VPWR VPWR sky130_fd_sc_hd__fill_8
XFILLER_67_622 VGND VGND VPWR VPWR sky130_fd_sc_hd__fill_4
XFILLER_67_611 VGND VGND VPWR VPWR sky130_fd_sc_hd__fill_4
X_3163_ wire60/X _4218_/A VGND VGND VPWR VPWR _3167_/C sky130_fd_sc_hd__nor2_1
XFILLER_39_302 VGND VGND VPWR VPWR sky130_fd_sc_hd__fill_4
XFILLER_66_121 VGND VGND VPWR VPWR sky130_fd_sc_hd__fill_2
X_3094_ _3034_/A _3091_/X _3092_/X _3093_/X _3094_/C1 VGND VGND VPWR VPWR _3094_/X
+ sky130_fd_sc_hd__o221a_1
XANTENNA__4436__B1 _4427_/B VGND VGND VPWR VPWR sky130_fd_sc_hd__diode_2
XFILLER_66_165 VGND VGND VPWR VPWR sky130_fd_sc_hd__fill_1
XFILLER_55_839 VGND VGND VPWR VPWR sky130_fd_sc_hd__fill_1
XFILLER_70_809 VGND VGND VPWR VPWR sky130_fd_sc_hd__fill_2
XANTENNA__4987__A1 _5053_/A1 VGND VGND VPWR VPWR sky130_fd_sc_hd__diode_2
XFILLER_120_29 VPWR VGND VPWR VGND sky130_ef_sc_hd__decap_40_12
XFILLER_50_500 VGND VGND VPWR VPWR sky130_fd_sc_hd__fill_8
XFILLER_23_703 VGND VGND VPWR VPWR sky130_fd_sc_hd__fill_4
XFILLER_35_563 VGND VGND VPWR VPWR sky130_fd_sc_hd__fill_1
XANTENNA__4739__A1 _4791_/A1 VGND VGND VPWR VPWR sky130_fd_sc_hd__diode_2
XFILLER_62_371 VGND VGND VPWR VPWR sky130_fd_sc_hd__fill_1
X_5804_ _6120_/CLK _5804_/D VGND VGND VPWR VPWR _5804_/Q sky130_fd_sc_hd__dfxtp_1
X_3996_ _5123_/A _5916_/Q _5915_/Q VGND VGND VPWR VPWR _3996_/Y sky130_fd_sc_hd__o21ai_1
XANTENNA_fanout149_A _4713_/S VGND VGND VPWR VPWR sky130_fd_sc_hd__diode_2
X_2947_ _3005_/A _2947_/B VGND VGND VPWR VPWR _2947_/Y sky130_fd_sc_hd__nor2_1
XFILLER_10_419 VGND VGND VPWR VPWR sky130_fd_sc_hd__fill_1
X_5735_ _5784_/CLK _5735_/D VGND VGND VPWR VPWR _5735_/Q sky130_fd_sc_hd__dfxtp_1
XFILLER_22_279 VGND VGND VPWR VPWR sky130_fd_sc_hd__fill_1
XTAP_TAPCELL_ROW_33_797 VGND VPWR sky130_fd_sc_hd__tapvpwrvgnd_1
XFILLER_129_27 VPWR VGND VPWR VGND sky130_ef_sc_hd__decap_40_12
X_5666_ _5681_/CLK _5666_/D VGND VGND VPWR VPWR _5666_/Q sky130_fd_sc_hd__dfxtp_1
X_2878_ _3036_/A1 _2877_/X _3094_/C1 VGND VGND VPWR VPWR _2878_/X sky130_fd_sc_hd__o21a_1
X_4617_ _5087_/A1 _4616_/X _4786_/S VGND VGND VPWR VPWR _4617_/X sky130_fd_sc_hd__mux2_1
XANTENNA__4598__S0 _4803_/S VGND VGND VPWR VPWR sky130_fd_sc_hd__diode_2
XFILLER_117_841 VGND VGND VPWR VPWR sky130_fd_sc_hd__fill_1
Xhold420 _3894_/X VGND VGND VPWR VPWR _5873_/D sky130_fd_sc_hd__dlygate4sd3_1
X_5597_ _6098_/CLK _5597_/D VGND VGND VPWR VPWR _5597_/Q sky130_fd_sc_hd__dfxtp_1
XANTENNA__3384__S _3390_/S VGND VGND VPWR VPWR sky130_fd_sc_hd__diode_2
XFILLER_132_811 VGND VGND VPWR VPWR sky130_fd_sc_hd__fill_1
X_4548_ _4548_/A _5253_/Q _4548_/C VGND VGND VPWR VPWR _4881_/B sky130_fd_sc_hd__or3_4
XFILLER_104_513 VPWR VGND VPWR VGND sky130_ef_sc_hd__decap_40_12
Xhold453 _5576_/Q VGND VGND VPWR VPWR hold453/X sky130_fd_sc_hd__dlygate4sd3_1
Xhold442 _3786_/X VGND VGND VPWR VPWR _5794_/D sky130_fd_sc_hd__dlygate4sd3_1
Xhold431 _5682_/Q VGND VGND VPWR VPWR hold431/X sky130_fd_sc_hd__dlygate4sd3_1
XANTENNA_fanout104_X _4929_/A1 VGND VGND VPWR VPWR sky130_fd_sc_hd__diode_2
Xhold464 _3489_/X VGND VGND VPWR VPWR _5535_/D sky130_fd_sc_hd__dlygate4sd3_1
XFILLER_104_557 VPWR VGND VPWR VGND sky130_ef_sc_hd__decap_40_12
Xhold486 _2747_/X VGND VGND VPWR VPWR _5277_/D sky130_fd_sc_hd__dlygate4sd3_1
Xhold475 _5489_/Q VGND VGND VPWR VPWR hold475/X sky130_fd_sc_hd__dlygate4sd3_1
X_4479_ hold331/X _5213_/A1 _4482_/S VGND VGND VPWR VPWR _4479_/X sky130_fd_sc_hd__mux2_1
X_6218_ _6242_/CLK _6218_/D VGND VGND VPWR VPWR _6218_/Q sky130_fd_sc_hd__dfxtp_1
Xhold497 _6008_/Q VGND VGND VPWR VPWR hold497/X sky130_fd_sc_hd__dlygate4sd3_1
XFILLER_57_110 VGND VGND VPWR VPWR sky130_fd_sc_hd__fill_2
Xhold1120 _5318_/Q VGND VGND VPWR VPWR _3125_/A0 sky130_fd_sc_hd__dlygate4sd3_1
Xhold1142 _5533_/Q VGND VGND VPWR VPWR _3487_/A0 sky130_fd_sc_hd__dlygate4sd3_1
X_6149_ _6369_/CLK _6149_/D VGND VGND VPWR VPWR _6149_/Q sky130_fd_sc_hd__dfxtp_1
Xhold1131 _3590_/X VGND VGND VPWR VPWR _5624_/D sky130_fd_sc_hd__dlygate4sd3_1
XTAP_TAPCELL_ROW_107_1910 VGND VPWR sky130_fd_sc_hd__tapvpwrvgnd_1
Xhold1153 _3889_/X VGND VGND VPWR VPWR _5869_/D sky130_fd_sc_hd__dlygate4sd3_1
XPHY_EDGE_ROW_79_Right_79 VGND VGND VPWR VPWR sky130_fd_sc_hd__decap_3
XFILLER_73_614 VGND VGND VPWR VPWR sky130_fd_sc_hd__fill_2
Xhold1175 _5623_/Q VGND VGND VPWR VPWR _3589_/A0 sky130_fd_sc_hd__dlygate4sd3_1
XFILLER_58_699 VGND VGND VPWR VPWR sky130_fd_sc_hd__fill_1
Xhold1164 _4406_/X VGND VGND VPWR VPWR _6044_/D sky130_fd_sc_hd__dlygate4sd3_1
XFILLER_61_809 VPWR VGND VPWR VGND sky130_ef_sc_hd__decap_40_12
Xhold1197 _4990_/X VGND VGND VPWR VPWR _6322_/D sky130_fd_sc_hd__dlygate4sd3_1
XANTENNA__5401__Q _5401_/Q VGND VGND VPWR VPWR sky130_fd_sc_hd__diode_2
XFILLER_45_349 VGND VGND VPWR VPWR sky130_fd_sc_hd__fill_4
XANTENNA__4943__S _4944_/S VGND VGND VPWR VPWR sky130_fd_sc_hd__diode_2
XANTENNA__4978__A1 _4978_/A1 VGND VGND VPWR VPWR sky130_fd_sc_hd__diode_2
XFILLER_26_530 VGND VGND VPWR VPWR sky130_fd_sc_hd__fill_2
Xhold1186 _4521_/X VGND VGND VPWR VPWR _6124_/D sky130_fd_sc_hd__dlygate4sd3_1
XFILLER_54_45 VGND VGND VPWR VPWR sky130_fd_sc_hd__fill_1
XFILLER_54_89 VGND VGND VPWR VPWR sky130_fd_sc_hd__fill_1
XFILLER_53_393 VPWR VGND VPWR VGND sky130_ef_sc_hd__decap_40_12
XFILLER_14_725 VPWR VGND VPWR VGND sky130_ef_sc_hd__decap_40_12
XFILLER_14_769 VPWR VGND VPWR VGND sky130_ef_sc_hd__decap_40_12
XANTENNA__2836__S0 _3033_/S VGND VGND VPWR VPWR sky130_fd_sc_hd__diode_2
XTAP_TAPCELL_ROW_136_2339 VGND VPWR sky130_fd_sc_hd__tapvpwrvgnd_1
XPHY_EDGE_ROW_88_Right_88 VGND VGND VPWR VPWR sky130_fd_sc_hd__decap_3
XTAP_TAPCELL_ROW_11_458 VGND VPWR sky130_fd_sc_hd__tapvpwrvgnd_1
XTAP_TAPCELL_ROW_11_469 VGND VPWR sky130_fd_sc_hd__tapvpwrvgnd_1
XANTENNA__3294__S _3295_/S VGND VGND VPWR VPWR sky130_fd_sc_hd__diode_2
XFILLER_108_841 VGND VGND VPWR VPWR sky130_fd_sc_hd__fill_1
XFILLER_79_20 VPWR VGND VPWR VGND sky130_ef_sc_hd__decap_40_12
XANTENNA__3166__B1 _4241_/A VGND VGND VPWR VPWR sky130_fd_sc_hd__diode_2
XFILLER_135_671 VGND VGND VPWR VPWR sky130_fd_sc_hd__fill_1
XFILLER_123_833 VGND VGND VPWR VPWR sky130_fd_sc_hd__fill_4
XFILLER_122_365 VGND VGND VPWR VPWR sky130_fd_sc_hd__fill_1
XANTENNA__3013__S0 _2984_/S VGND VGND VPWR VPWR sky130_fd_sc_hd__diode_2
XTAP_TAPCELL_ROW_73_1390 VGND VPWR sky130_fd_sc_hd__tapvpwrvgnd_1
XFILLER_1_673 VPWR VGND VPWR VGND sky130_ef_sc_hd__decap_40_12
XPHY_EDGE_ROW_97_Right_97 VGND VGND VPWR VPWR sky130_fd_sc_hd__decap_3
XFILLER_76_452 VGND VGND VPWR VPWR sky130_fd_sc_hd__fill_1
XANTENNA__4418__B1 _5085_/A VGND VGND VPWR VPWR sky130_fd_sc_hd__diode_2
XFILLER_37_839 VGND VGND VPWR VPWR sky130_fd_sc_hd__fill_1
XANTENNA__4853__S _4854_/S VGND VGND VPWR VPWR sky130_fd_sc_hd__diode_2
XFILLER_64_658 VGND VGND VPWR VPWR sky130_fd_sc_hd__fill_1
XFILLER_63_135 VGND VGND VPWR VPWR sky130_fd_sc_hd__fill_4
XFILLER_52_809 VGND VGND VPWR VPWR sky130_fd_sc_hd__fill_2
XFILLER_17_541 VPWR VGND VPWR VGND sky130_ef_sc_hd__decap_40_12
XANTENNA__3469__S _3477_/S VGND VGND VPWR VPWR sky130_fd_sc_hd__diode_2
XFILLER_17_585 VPWR VGND VPWR VGND sky130_ef_sc_hd__decap_40_12
XANTENNA__3641__A1 _4958_/A0 VGND VGND VPWR VPWR sky130_fd_sc_hd__diode_2
X_3850_ _3850_/A _3852_/B VGND VGND VPWR VPWR _3850_/X sky130_fd_sc_hd__or2_1
X_2801_ _3031_/A1 _2800_/X _2799_/X _3089_/C1 VGND VGND VPWR VPWR _2801_/X sky130_fd_sc_hd__o211a_1
XPHY_EDGE_ROW_4_Left_143 VGND VGND VPWR VPWR sky130_fd_sc_hd__decap_3
X_3781_ hold377/X _5210_/A1 _3787_/S VGND VGND VPWR VPWR _3781_/X sky130_fd_sc_hd__mux2_1
X_5520_ _6222_/CLK _5520_/D VGND VGND VPWR VPWR _5520_/Q sky130_fd_sc_hd__dfxtp_1
X_2732_ _2967_/S _3085_/A _2732_/C VGND VGND VPWR VPWR _2735_/B sky130_fd_sc_hd__and3_1
XTAP_TAPCELL_ROW_30_745 VGND VPWR sky130_fd_sc_hd__tapvpwrvgnd_1
XTAP_TAPCELL_ROW_30_756 VGND VPWR sky130_fd_sc_hd__tapvpwrvgnd_1
X_2663_ _2663_/A _2663_/B VGND VGND VPWR VPWR _2664_/D sky130_fd_sc_hd__xnor2_1
XTAP_TAPCELL_ROW_93_1700 VGND VPWR sky130_fd_sc_hd__tapvpwrvgnd_1
X_5451_ _5731_/CLK _5451_/D VGND VGND VPWR VPWR _5451_/Q sky130_fd_sc_hd__dfxtp_1
XFILLER_114_811 VGND VGND VPWR VPWR sky130_fd_sc_hd__fill_1
X_4402_ _4980_/A1 _4402_/A1 _4406_/S VGND VGND VPWR VPWR _4402_/X sky130_fd_sc_hd__mux2_1
X_5382_ _6123_/CLK _5382_/D VGND VGND VPWR VPWR _5382_/Q sky130_fd_sc_hd__dfxtp_2
XFILLER_126_693 VGND VGND VPWR VPWR sky130_fd_sc_hd__fill_4
X_4333_ _4982_/A1 _4333_/A1 _4335_/S VGND VGND VPWR VPWR _5979_/D sky130_fd_sc_hd__mux2_1
Xfanout207 input3/X VGND VGND VPWR VPWR _3801_/A sky130_fd_sc_hd__buf_8
XFILLER_101_505 VPWR VGND VPWR VGND sky130_ef_sc_hd__decap_40_12
X_4264_ _4264_/A1 _4261_/X _4271_/S1 VGND VGND VPWR VPWR _4264_/X sky130_fd_sc_hd__o21a_1
X_3215_ _5232_/A0 _3215_/A1 _3220_/S VGND VGND VPWR VPWR _3215_/X sky130_fd_sc_hd__mux2_1
XANTENNA__2808__A1_N _3089_/C1 VGND VGND VPWR VPWR sky130_fd_sc_hd__diode_2
XANTENNA__4657__B1 _4792_/A1 VGND VGND VPWR VPWR sky130_fd_sc_hd__diode_2
X_6003_ _6421_/CLK _6003_/D VGND VGND VPWR VPWR _6003_/Q sky130_fd_sc_hd__dfxtp_1
XFILLER_79_290 VGND VGND VPWR VPWR sky130_fd_sc_hd__fill_4
X_4195_ _4149_/A _4190_/X _4192_/X _4194_/X VGND VGND VPWR VPWR _4195_/X sky130_fd_sc_hd__a22o_1
XFILLER_95_783 VGND VGND VPWR VPWR sky130_fd_sc_hd__fill_1
X_3146_ _4002_/A hold4/X _3156_/S VGND VGND VPWR VPWR _3146_/X sky130_fd_sc_hd__mux2_1
XFILLER_55_625 VGND VGND VPWR VPWR sky130_fd_sc_hd__fill_1
XANTENNA__4409__A0 _5052_/A1 VGND VGND VPWR VPWR sky130_fd_sc_hd__diode_2
XFILLER_131_39 VGND VGND VPWR VPWR sky130_fd_sc_hd__fill_8
X_3077_ _5548_/Q _5572_/Q _3077_/S VGND VGND VPWR VPWR _3077_/X sky130_fd_sc_hd__mux2_1
XFILLER_54_135 VGND VGND VPWR VPWR sky130_fd_sc_hd__fill_1
XFILLER_43_809 VPWR VGND VPWR VGND sky130_ef_sc_hd__decap_40_12
XFILLER_39_198 VGND VGND VPWR VPWR sky130_fd_sc_hd__fill_2
XTAP_TAPCELL_ROW_120_2107 VGND VPWR sky130_fd_sc_hd__tapvpwrvgnd_1
XFILLER_54_157 VGND VGND VPWR VPWR sky130_fd_sc_hd__fill_4
XTAP_TAPCELL_ROW_38_867 VGND VPWR sky130_fd_sc_hd__tapvpwrvgnd_1
XANTENNA__3632__A1 _4517_/A1 VGND VGND VPWR VPWR sky130_fd_sc_hd__diode_2
XFILLER_24_15 VPWR VGND VPWR VGND sky130_ef_sc_hd__decap_40_12
XFILLER_35_382 VGND VGND VPWR VPWR sky130_fd_sc_hd__fill_1
XPHY_EDGE_ROW_59_Left_198 VGND VGND VPWR VPWR sky130_fd_sc_hd__decap_3
XFILLER_50_363 VGND VGND VPWR VPWR sky130_fd_sc_hd__fill_1
XANTENNA__4807__S1 _4809_/A VGND VGND VPWR VPWR sky130_fd_sc_hd__diode_2
X_3979_ _3993_/B _3993_/C VGND VGND VPWR VPWR _5110_/A sky130_fd_sc_hd__nor2_2
X_5718_ _6122_/CLK _5718_/D VGND VGND VPWR VPWR _5718_/Q sky130_fd_sc_hd__dfxtp_1
XTAP_TAPCELL_ROW_118_2069 VGND VPWR sky130_fd_sc_hd__tapvpwrvgnd_1
X_5649_ _5898_/CLK _5649_/D VGND VGND VPWR VPWR _5649_/Q sky130_fd_sc_hd__dfxtp_1
XTAP_TAPCELL_ROW_131_2258 VGND VPWR sky130_fd_sc_hd__tapvpwrvgnd_1
XANTENNA__4896__A0 _5239_/A1 VGND VGND VPWR VPWR sky130_fd_sc_hd__diode_2
XFILLER_117_671 VGND VGND VPWR VPWR sky130_fd_sc_hd__fill_1
Xhold250 _6140_/Q VGND VGND VPWR VPWR hold250/X sky130_fd_sc_hd__dlygate4sd3_1
XFILLER_132_641 VGND VGND VPWR VPWR sky130_fd_sc_hd__fill_2
XTAP_TAPCELL_ROW_131_2269 VGND VPWR sky130_fd_sc_hd__tapvpwrvgnd_1
XFILLER_105_833 VGND VGND VPWR VPWR sky130_fd_sc_hd__fill_4
Xhold261 _3302_/X VGND VGND VPWR VPWR _5420_/D sky130_fd_sc_hd__dlygate4sd3_1
XANTENNA__4938__S _4944_/S VGND VGND VPWR VPWR sky130_fd_sc_hd__diode_2
Xhold272 _5407_/Q VGND VGND VPWR VPWR hold272/X sky130_fd_sc_hd__dlygate4sd3_1
XFILLER_49_23 VGND VGND VPWR VPWR sky130_fd_sc_hd__fill_1
Xhold294 _4499_/X VGND VGND VPWR VPWR _6104_/D sky130_fd_sc_hd__dlygate4sd3_1
Xhold283 _3649_/X VGND VGND VPWR VPWR _5675_/D sky130_fd_sc_hd__dlygate4sd3_1
XFILLER_120_825 VPWR VGND VPWR VGND sky130_ef_sc_hd__decap_40_12
XTAP_TAPCELL_ROW_113_1991 VGND VPWR sky130_fd_sc_hd__tapvpwrvgnd_1
XFILLER_49_89 VGND VGND VPWR VPWR sky130_fd_sc_hd__fill_1
XANTENNA_fanout81_A _6415_/Q VGND VGND VPWR VPWR sky130_fd_sc_hd__diode_2
XPHY_EDGE_ROW_130_Right_130 VGND VGND VPWR VPWR sky130_fd_sc_hd__decap_3
XFILLER_93_709 VPWR VGND VPWR VGND sky130_ef_sc_hd__decap_40_12
XFILLER_85_271 VGND VGND VPWR VPWR sky130_fd_sc_hd__fill_1
XFILLER_19_839 VGND VGND VPWR VPWR sky130_fd_sc_hd__fill_1
XFILLER_34_809 VGND VGND VPWR VPWR sky130_fd_sc_hd__fill_2
XANTENNA__5073__A0 _5241_/A1 VGND VGND VPWR VPWR sky130_fd_sc_hd__diode_2
XTAP_TAPCELL_ROW_47_1009 VGND VPWR sky130_fd_sc_hd__tapvpwrvgnd_1
XANTENNA__3289__S _3295_/S VGND VGND VPWR VPWR sky130_fd_sc_hd__diode_2
XANTENNA__4820__A0 _4846_/A0 VGND VGND VPWR VPWR sky130_fd_sc_hd__diode_2
XFILLER_81_10 VPWR VGND VPWR VGND sky130_ef_sc_hd__decap_40_12
XFILLER_61_639 VGND VGND VPWR VPWR sky130_fd_sc_hd__fill_2
XTAP_TAPCELL_ROW_16_539 VGND VPWR sky130_fd_sc_hd__tapvpwrvgnd_1
XANTENNA__3623__A1 _4488_/A0 VGND VGND VPWR VPWR sky130_fd_sc_hd__diode_2
XFILLER_81_54 VGND VGND VPWR VPWR sky130_fd_sc_hd__fill_2
XFILLER_14_533 VPWR VGND VPWR VGND sky130_ef_sc_hd__decap_40_12
XANTENNA__4421__B input5/X VGND VGND VPWR VPWR sky130_fd_sc_hd__diode_2
XFILLER_108_693 VGND VGND VPWR VPWR sky130_fd_sc_hd__fill_4
XANTENNA__4848__S _4854_/S VGND VGND VPWR VPWR sky130_fd_sc_hd__diode_2
XTAP_TAPCELL_ROW_75_1430 VGND VPWR sky130_fd_sc_hd__tapvpwrvgnd_1
XFILLER_123_641 VPWR VGND VPWR VGND sky130_ef_sc_hd__decap_40_12
XFILLER_123_685 VPWR VGND VPWR VGND sky130_ef_sc_hd__decap_40_12
XFILLER_68_216 VGND VGND VPWR VPWR sky130_fd_sc_hd__fill_4
XFILLER_122_195 VGND VGND VPWR VPWR sky130_fd_sc_hd__fill_1
XFILLER_96_569 VPWR VGND VPWR VGND sky130_ef_sc_hd__decap_40_12
XANTENNA__4149__A _4149_/A VGND VGND VPWR VPWR sky130_fd_sc_hd__diode_2
X_3000_ _3029_/A _3000_/B VGND VGND VPWR VPWR _3000_/X sky130_fd_sc_hd__or2_1
XFILLER_83_219 VGND VGND VPWR VPWR sky130_fd_sc_hd__fill_2
Xinput7 s_axil_awaddr[2] VGND VGND VPWR VPWR input7/X sky130_fd_sc_hd__clkbuf_2
XFILLER_92_753 VGND VGND VPWR VPWR sky130_fd_sc_hd__fill_2
XANTENNA__4436__X _4436_/X VGND VGND VPWR VPWR sky130_fd_sc_hd__diode_2
XFILLER_25_809 VPWR VGND VPWR VGND sky130_ef_sc_hd__decap_40_12
XANTENNA__3075__C1 _3075_/C1 VGND VGND VPWR VPWR sky130_fd_sc_hd__diode_2
XANTENNA__3614__A1 _5214_/A1 VGND VGND VPWR VPWR sky130_fd_sc_hd__diode_2
XTAP_TAPCELL_ROW_86_1592 VGND VPWR sky130_fd_sc_hd__tapvpwrvgnd_1
X_4951_ _4981_/A1 _4951_/A1 _4954_/S VGND VGND VPWR VPWR _4951_/X sky130_fd_sc_hd__mux2_1
XTAP_TAPCELL_ROW_35_826 VGND VPWR sky130_fd_sc_hd__tapvpwrvgnd_1
X_4882_ hold181/X _4882_/A1 _4893_/S VGND VGND VPWR VPWR _4882_/X sky130_fd_sc_hd__mux2_1
XFILLER_17_393 VPWR VGND VPWR VGND sky130_ef_sc_hd__decap_40_12
X_3902_ hold761/X _5210_/A1 _3908_/S VGND VGND VPWR VPWR _3902_/X sky130_fd_sc_hd__mux2_1
X_3833_ _5085_/A _3833_/B VGND VGND VPWR VPWR _5831_/D sky130_fd_sc_hd__nor2_1
XANTENNA__3378__B1 _3376_/X VGND VGND VPWR VPWR sky130_fd_sc_hd__diode_2
XANTENNA__4575__C1 _3278_/A VGND VGND VPWR VPWR sky130_fd_sc_hd__diode_2
XFILLER_20_525 VGND VGND VPWR VPWR sky130_fd_sc_hd__fill_4
XFILLER_118_413 VGND VGND VPWR VPWR sky130_fd_sc_hd__fill_2
X_3764_ _3764_/A0 _4982_/A1 _3766_/S VGND VGND VPWR VPWR _3764_/X sky130_fd_sc_hd__mux2_1
XFILLER_20_569 VPWR VGND VPWR VGND sky130_ef_sc_hd__decap_40_12
X_5503_ _6248_/CLK _5503_/D VGND VGND VPWR VPWR _5503_/Q sky130_fd_sc_hd__dfxtp_1
XFILLER_118_435 VGND VGND VPWR VPWR sky130_fd_sc_hd__fill_1
X_2715_ _5046_/A1 _2715_/A1 _2716_/S VGND VGND VPWR VPWR _2715_/X sky130_fd_sc_hd__mux2_1
X_3695_ hold413/X _5213_/A1 _3698_/S VGND VGND VPWR VPWR _3695_/X sky130_fd_sc_hd__mux2_1
X_2646_ _2658_/B VGND VGND VPWR VPWR _4548_/C sky130_fd_sc_hd__inv_2
X_5434_ _6420_/CLK _5434_/D VGND VGND VPWR VPWR _5434_/Q sky130_fd_sc_hd__dfxtp_1
XFILLER_114_641 VGND VGND VPWR VPWR sky130_fd_sc_hd__fill_2
X_5365_ _6146_/CLK _5365_/D VGND VGND VPWR VPWR _5365_/Q sky130_fd_sc_hd__dfxtp_1
XANTENNA__3662__S _3667_/S VGND VGND VPWR VPWR sky130_fd_sc_hd__diode_2
X_5296_ _6148_/CLK hold90/X VGND VGND VPWR VPWR hold89/A sky130_fd_sc_hd__dfxtp_1
XFILLER_102_825 VPWR VGND VPWR VGND sky130_ef_sc_hd__decap_40_12
XFILLER_101_302 VGND VGND VPWR VPWR sky130_fd_sc_hd__fill_4
XFILLER_87_514 VGND VGND VPWR VPWR sky130_fd_sc_hd__fill_2
X_4316_ _4935_/A _4336_/B VGND VGND VPWR VPWR _4325_/S sky130_fd_sc_hd__nor2_4
XFILLER_101_335 VGND VGND VPWR VPWR sky130_fd_sc_hd__fill_1
XFILLER_87_547 VGND VGND VPWR VPWR sky130_fd_sc_hd__fill_2
XFILLER_19_15 VGND VGND VPWR VPWR sky130_fd_sc_hd__fill_4
X_4247_ _2634_/Y _4246_/X _4218_/A VGND VGND VPWR VPWR _4247_/X sky130_fd_sc_hd__a21o_1
X_4178_ _4178_/A _4178_/B VGND VGND VPWR VPWR _4178_/X sky130_fd_sc_hd__or2_1
X_3129_ _5085_/A _3129_/B _3402_/B VGND VGND VPWR VPWR _3129_/Y sky130_fd_sc_hd__nor3_1
XFILLER_16_809 VGND VGND VPWR VPWR sky130_fd_sc_hd__fill_2
XANTENNA_fanout171_X _4213_/S VGND VGND VPWR VPWR sky130_fd_sc_hd__diode_2
XFILLER_83_797 VPWR VGND VPWR VGND sky130_ef_sc_hd__decap_40_12
XANTENNA__3605__A1 _4964_/A0 VGND VGND VPWR VPWR sky130_fd_sc_hd__diode_2
XPHY_EDGE_ROW_67_Left_206 VGND VGND VPWR VPWR sky130_fd_sc_hd__decap_3
XFILLER_42_116 VGND VGND VPWR VPWR sky130_fd_sc_hd__fill_1
XFILLER_15_319 VGND VGND VPWR VPWR sky130_fd_sc_hd__fill_2
XFILLER_23_341 VGND VGND VPWR VPWR sky130_fd_sc_hd__fill_2
XFILLER_11_503 VGND VGND VPWR VPWR sky130_fd_sc_hd__fill_1
XFILLER_23_385 VGND VGND VPWR VPWR sky130_fd_sc_hd__fill_4
XANTENNA__4030__B2 _4271_/S1 VGND VGND VPWR VPWR sky130_fd_sc_hd__diode_2
XFILLER_7_529 VPWR VGND VPWR VGND sky130_ef_sc_hd__decap_40_12
XANTENNA_clkbuf_3_5__f_clk_X clkload4/A VGND VGND VPWR VPWR sky130_fd_sc_hd__diode_2
XFILLER_137_777 VGND VGND VPWR VPWR sky130_fd_sc_hd__fill_4
XPHY_EDGE_ROW_76_Left_215 VGND VGND VPWR VPWR sky130_fd_sc_hd__decap_3
XFILLER_105_641 VPWR VGND VPWR VGND sky130_ef_sc_hd__decap_40_12
XANTENNA__3572__S _3574_/S VGND VGND VPWR VPWR sky130_fd_sc_hd__diode_2
XTAP_TAPCELL_ROW_57_1160 VGND VPWR sky130_fd_sc_hd__tapvpwrvgnd_1
XFILLER_4_3 VPWR VGND VPWR VGND sky130_ef_sc_hd__decap_40_12
XFILLER_105_685 VPWR VGND VPWR VGND sky130_ef_sc_hd__decap_40_12
XANTENNA_fanout84_X _4517_/A1 VGND VGND VPWR VPWR sky130_fd_sc_hd__diode_2
XFILLER_116_72 VGND VGND VPWR VPWR sky130_fd_sc_hd__fill_1
XFILLER_76_10 VGND VGND VPWR VPWR sky130_fd_sc_hd__fill_1
XFILLER_120_699 VGND VGND VPWR VPWR sky130_fd_sc_hd__fill_1
XFILLER_93_528 VPWR VGND VPWR VGND sky130_ef_sc_hd__decap_40_12
XFILLER_76_76 VGND VGND VPWR VPWR sky130_fd_sc_hd__fill_1
XFILLER_59_772 VPWR VGND VPWR VGND sky130_ef_sc_hd__decap_40_12
XFILLER_46_400 VGND VGND VPWR VPWR sky130_fd_sc_hd__fill_2
XFILLER_58_293 VGND VGND VPWR VPWR sky130_fd_sc_hd__fill_1
XFILLER_46_411 VGND VGND VPWR VPWR sky130_fd_sc_hd__fill_8
XPHY_EDGE_ROW_85_Left_224 VGND VGND VPWR VPWR sky130_fd_sc_hd__decap_3
XFILLER_19_669 VGND VGND VPWR VPWR sky130_fd_sc_hd__fill_2
XFILLER_33_138 VGND VGND VPWR VPWR sky130_fd_sc_hd__fill_8
XFILLER_128_755 VGND VGND VPWR VPWR sky130_fd_sc_hd__fill_1
XTAP_TAPCELL_ROW_40_895 VGND VPWR sky130_fd_sc_hd__tapvpwrvgnd_1
X_3480_ hold337/X _5239_/A1 _3490_/S VGND VGND VPWR VPWR _3480_/X sky130_fd_sc_hd__mux2_1
XPHY_EDGE_ROW_94_Left_233 VGND VGND VPWR VPWR sky130_fd_sc_hd__decap_3
XANTENNA__3482__S _3490_/S VGND VGND VPWR VPWR sky130_fd_sc_hd__diode_2
XFILLER_130_419 VGND VGND VPWR VPWR sky130_fd_sc_hd__fill_1
X_5150_ _5160_/A _5150_/B VGND VGND VPWR VPWR _5150_/Y sky130_fd_sc_hd__nand2_1
XFILLER_69_503 VGND VGND VPWR VPWR sky130_fd_sc_hd__fill_1
XFILLER_37_3 VGND VGND VPWR VPWR sky130_fd_sc_hd__fill_8
X_5081_ _5237_/A0 _5081_/A1 _5081_/S VGND VGND VPWR VPWR _5081_/X sky130_fd_sc_hd__mux2_1
Xhold1708 _4830_/X VGND VGND VPWR VPWR _6183_/D sky130_fd_sc_hd__dlygate4sd3_1
X_4101_ _4100_/X _4094_/X _4272_/S VGND VGND VPWR VPWR _4101_/X sky130_fd_sc_hd__mux2_1
Xhold1719 _5482_/Q VGND VGND VPWR VPWR _3431_/A0 sky130_fd_sc_hd__dlygate4sd3_1
X_4032_ _4272_/S _4024_/Y _4031_/Y _5343_/Q VGND VGND VPWR VPWR _4032_/X sky130_fd_sc_hd__o211a_1
XTAP_TAPCELL_ROW_88_1621 VGND VPWR sky130_fd_sc_hd__tapvpwrvgnd_1
XANTENNA__3835__A1 _5047_/A1 VGND VGND VPWR VPWR sky130_fd_sc_hd__diode_2
XFILLER_65_753 VPWR VGND VPWR VGND sky130_ef_sc_hd__decap_40_12
XFILLER_65_797 VPWR VGND VPWR VGND sky130_ef_sc_hd__decap_40_12
XFILLER_64_285 VGND VGND VPWR VPWR sky130_fd_sc_hd__fill_4
XFILLER_25_617 VGND VGND VPWR VPWR sky130_fd_sc_hd__fill_1
X_5983_ _5990_/CLK _5983_/D VGND VGND VPWR VPWR _5983_/Q sky130_fd_sc_hd__dfxtp_1
X_4934_ hold827/X _4984_/A1 _4934_/S VGND VGND VPWR VPWR _4934_/X sky130_fd_sc_hd__mux2_1
X_4865_ _4904_/A0 _4865_/A1 _4867_/S VGND VGND VPWR VPWR _4865_/X sky130_fd_sc_hd__mux2_1
X_4796_ _2629_/Y _4795_/X _2628_/A VGND VGND VPWR VPWR _4796_/Y sky130_fd_sc_hd__o21ai_1
X_3816_ _4912_/A _5228_/A0 _3818_/S VGND VGND VPWR VPWR _5819_/D sky130_fd_sc_hd__mux2_1
XANTENNA_fanout131_A _5812_/Q VGND VGND VPWR VPWR sky130_fd_sc_hd__diode_2
XTAP_TAPCELL_ROW_115_2028 VGND VPWR sky130_fd_sc_hd__tapvpwrvgnd_1
X_3747_ _4976_/A1 _3747_/A1 _3755_/S VGND VGND VPWR VPWR _3747_/X sky130_fd_sc_hd__mux2_1
XFILLER_20_377 VPWR VGND VPWR VGND sky130_ef_sc_hd__decap_40_12
XFILLER_137_27 VPWR VGND VPWR VGND sky130_ef_sc_hd__decap_40_12
XFILLER_119_777 VGND VGND VPWR VPWR sky130_fd_sc_hd__fill_4
XTAP_TAPCELL_ROW_99_1783 VGND VPWR sky130_fd_sc_hd__tapvpwrvgnd_1
XANTENNA__3771__A0 _4929_/A1 VGND VGND VPWR VPWR sky130_fd_sc_hd__diode_2
XFILLER_134_725 VPWR VGND VPWR VGND sky130_ef_sc_hd__decap_40_12
X_3678_ _5202_/A1 _3678_/A1 _3678_/S VGND VGND VPWR VPWR _3678_/X sky130_fd_sc_hd__mux2_1
XFILLER_134_769 VPWR VGND VPWR VGND sky130_ef_sc_hd__decap_40_12
XANTENNA__3523__A0 _4887_/A1 VGND VGND VPWR VPWR sky130_fd_sc_hd__diode_2
X_5417_ _6129_/CLK _5417_/D VGND VGND VPWR VPWR _5417_/Q sky130_fd_sc_hd__dfxtp_1
XANTENNA__2797__A _3085_/A VGND VGND VPWR VPWR sky130_fd_sc_hd__diode_2
X_6397_ _6402_/CLK _6397_/D VGND VGND VPWR VPWR _6397_/Q sky130_fd_sc_hd__dfxtp_1
X_2629_ _4809_/A VGND VGND VPWR VPWR _2629_/Y sky130_fd_sc_hd__inv_2
X_5348_ _5753_/CLK _5348_/D VGND VGND VPWR VPWR _5348_/Q sky130_fd_sc_hd__dfxtp_1
XFILLER_0_727 VGND VGND VPWR VPWR sky130_fd_sc_hd__fill_1
XTAP_TAPCELL_ROW_110_1950 VGND VPWR sky130_fd_sc_hd__tapvpwrvgnd_1
X_5279_ _6399_/CLK _5279_/D VGND VGND VPWR VPWR _5279_/Q sky130_fd_sc_hd__dfxtp_1
XFILLER_102_699 VGND VGND VPWR VPWR sky130_fd_sc_hd__fill_1
XANTENNA__3826__A1 _5053_/A1 VGND VGND VPWR VPWR sky130_fd_sc_hd__diode_2
XFILLER_46_24 VGND VGND VPWR VPWR sky130_fd_sc_hd__fill_4
XFILLER_28_433 VPWR VGND VPWR VGND sky130_ef_sc_hd__decap_40_12
XFILLER_55_285 VGND VGND VPWR VPWR sky130_fd_sc_hd__fill_1
XANTENNA__4951__S _4954_/S VGND VGND VPWR VPWR sky130_fd_sc_hd__diode_2
XFILLER_71_789 VPWR VGND VPWR VGND sky130_ef_sc_hd__decap_40_12
XTAP_TAPCELL_ROW_26_689 VGND VPWR sky130_fd_sc_hd__tapvpwrvgnd_1
XANTENNA__4523__Y _4535_/S VGND VGND VPWR VPWR sky130_fd_sc_hd__diode_2
XANTENNA__3567__S _3574_/S VGND VGND VPWR VPWR sky130_fd_sc_hd__diode_2
XFILLER_8_805 VGND VGND VPWR VPWR sky130_fd_sc_hd__fill_4
XFILLER_23_171 VGND VGND VPWR VPWR sky130_fd_sc_hd__fill_2
XFILLER_137_541 VPWR VGND VPWR VGND sky130_ef_sc_hd__decap_40_12
XFILLER_11_388 VGND VGND VPWR VPWR sky130_fd_sc_hd__fill_4
XANTENNA__3139__Y _3390_/S VGND VGND VPWR VPWR sky130_fd_sc_hd__diode_2
XFILLER_137_585 VPWR VGND VPWR VGND sky130_ef_sc_hd__decap_40_12
XFILLER_125_725 VGND VGND VPWR VPWR sky130_fd_sc_hd__fill_2
XANTENNA__3514__A0 _5235_/A0 VGND VGND VPWR VPWR sky130_fd_sc_hd__diode_2
XTAP_TAPCELL_ROW_55_1119 VGND VPWR sky130_fd_sc_hd__tapvpwrvgnd_1
XANTENNA__4398__S _4406_/S VGND VGND VPWR VPWR sky130_fd_sc_hd__diode_2
XANTENNA__5083__A _6459_/A VGND VGND VPWR VPWR sky130_fd_sc_hd__diode_2
XFILLER_127_93 VGND VGND VPWR VPWR sky130_fd_sc_hd__fill_2
XFILLER_105_460 VGND VGND VPWR VPWR sky130_fd_sc_hd__fill_1
XFILLER_78_344 VGND VGND VPWR VPWR sky130_fd_sc_hd__fill_2
XFILLER_94_837 VGND VGND VPWR VPWR sky130_fd_sc_hd__fill_4
XFILLER_78_377 VGND VGND VPWR VPWR sky130_fd_sc_hd__fill_1
XFILLER_120_485 VGND VGND VPWR VPWR sky130_fd_sc_hd__fill_1
XANTENNA__3817__A1 _4883_/A1 VGND VGND VPWR VPWR sky130_fd_sc_hd__diode_2
XTAP_TAPCELL_ROW_6_392 VGND VPWR sky130_fd_sc_hd__tapvpwrvgnd_1
XANTENNA__4130__A1_N _4271_/S1 VGND VGND VPWR VPWR sky130_fd_sc_hd__diode_2
XFILLER_47_797 VPWR VGND VPWR VGND sky130_ef_sc_hd__decap_40_12
XANTENNA__4861__S _4867_/S VGND VGND VPWR VPWR sky130_fd_sc_hd__diode_2
XTAP_TAPCELL_ROW_83_1540 VGND VPWR sky130_fd_sc_hd__tapvpwrvgnd_1
XANTENNA__6415__Q _6415_/Q VGND VGND VPWR VPWR sky130_fd_sc_hd__diode_2
X_2980_ _2973_/X _2979_/X _3083_/S VGND VGND VPWR VPWR _2980_/X sky130_fd_sc_hd__mux2_1
XTAP_TAPCELL_ROW_83_1551 VGND VPWR sky130_fd_sc_hd__tapvpwrvgnd_1
XTAP_TAPCELL_ROW_45_976 VGND VPWR sky130_fd_sc_hd__tapvpwrvgnd_1
XANTENNA__4145__A1_N _4252_/B1 VGND VGND VPWR VPWR sky130_fd_sc_hd__diode_2
XANTENNA__3477__S _3477_/S VGND VGND VPWR VPWR sky130_fd_sc_hd__diode_2
X_4650_ _4789_/A _4650_/B VGND VGND VPWR VPWR _4650_/X sky130_fd_sc_hd__or2_1
XFILLER_14_193 VGND VGND VPWR VPWR sky130_fd_sc_hd__fill_2
Xinput10 s_axil_bready VGND VGND VPWR VPWR _2656_/A sky130_fd_sc_hd__clkbuf_1
X_3601_ _3601_/A0 _5212_/A1 _3605_/S VGND VGND VPWR VPWR _3601_/X sky130_fd_sc_hd__mux2_1
Xinput21 s_axil_wdata[3] VGND VGND VPWR VPWR _2625_/A sky130_fd_sc_hd__clkbuf_2
X_6320_ _6339_/CLK _6320_/D VGND VGND VPWR VPWR _6320_/Q sky130_fd_sc_hd__dfxtp_1
XANTENNA__3753__A0 _4982_/A1 VGND VGND VPWR VPWR sky130_fd_sc_hd__diode_2
X_4581_ _4811_/A1 _4580_/X _4579_/X _4811_/C1 VGND VGND VPWR VPWR _4581_/X sky130_fd_sc_hd__o211a_1
XFILLER_128_585 VGND VGND VPWR VPWR sky130_fd_sc_hd__fill_2
Xhold816 _2672_/X VGND VGND VPWR VPWR _5245_/D sky130_fd_sc_hd__dlygate4sd3_1
XFILLER_116_725 VPWR VGND VPWR VGND sky130_ef_sc_hd__decap_40_12
X_3532_ _3532_/A0 _5228_/A0 _3541_/S VGND VGND VPWR VPWR _3532_/X sky130_fd_sc_hd__mux2_1
Xhold805 _5995_/Q VGND VGND VPWR VPWR hold805/X sky130_fd_sc_hd__dlygate4sd3_1
Xhold827 _6271_/Q VGND VGND VPWR VPWR hold827/X sky130_fd_sc_hd__dlygate4sd3_1
XFILLER_116_769 VPWR VGND VPWR VGND sky130_ef_sc_hd__decap_40_12
X_6251_ _6254_/CLK _6251_/D VGND VGND VPWR VPWR _6251_/Q sky130_fd_sc_hd__dfxtp_1
X_3463_ hold55/X _5816_/Q _3463_/S VGND VGND VPWR VPWR hold56/A sky130_fd_sc_hd__mux2_1
Xhold849 _5280_/Q VGND VGND VPWR VPWR hold849/X sky130_fd_sc_hd__dlygate4sd3_1
Xhold838 _3627_/X VGND VGND VPWR VPWR _5656_/D sky130_fd_sc_hd__dlygate4sd3_1
X_6182_ _6241_/CLK _6182_/D VGND VGND VPWR VPWR _6182_/Q sky130_fd_sc_hd__dfxtp_1
XFILLER_88_119 VGND VGND VPWR VPWR sky130_fd_sc_hd__fill_1
XANTENNA__3505__A0 _4882_/A1 VGND VGND VPWR VPWR sky130_fd_sc_hd__diode_2
X_5202_ _3965_/A _5202_/A1 _5213_/S VGND VGND VPWR VPWR _6406_/D sky130_fd_sc_hd__mux2_1
XANTENNA__4101__S _4272_/S VGND VGND VPWR VPWR sky130_fd_sc_hd__diode_2
Xhold2206 _5251_/Q VGND VGND VPWR VPWR _2681_/A sky130_fd_sc_hd__dlygate4sd3_1
XFILLER_97_653 VPWR VGND VPWR VGND sky130_ef_sc_hd__decap_40_12
Xhold2217 _5268_/Q VGND VGND VPWR VPWR hold2217/X sky130_fd_sc_hd__dlygate4sd3_1
X_5133_ _6390_/Q _6389_/Q _3941_/B VGND VGND VPWR VPWR _5133_/Y sky130_fd_sc_hd__o21ai_1
Xhold2228 _5826_/Q VGND VGND VPWR VPWR hold2228/X sky130_fd_sc_hd__dlygate4sd3_1
X_3394_ _4048_/A2 _5040_/A1 _3401_/S VGND VGND VPWR VPWR _3394_/X sky130_fd_sc_hd__mux2_1
Xhold2239 _5269_/Q VGND VGND VPWR VPWR hold2239/X sky130_fd_sc_hd__dlygate4sd3_1
Xhold1516 _3734_/X VGND VGND VPWR VPWR _5748_/D sky130_fd_sc_hd__dlygate4sd3_1
Xhold1505 _2708_/X VGND VGND VPWR VPWR _5256_/D sky130_fd_sc_hd__dlygate4sd3_1
XFILLER_97_697 VPWR VGND VPWR VGND sky130_ef_sc_hd__decap_40_12
XFILLER_85_837 VGND VGND VPWR VPWR sky130_fd_sc_hd__fill_2
Xhold1549 _5692_/Q VGND VGND VPWR VPWR _3667_/A1 sky130_fd_sc_hd__dlygate4sd3_1
XANTENNA__3808__A1 _5235_/A0 VGND VGND VPWR VPWR sky130_fd_sc_hd__diode_2
X_5064_ _2650_/A _5064_/A1 _5207_/S VGND VGND VPWR VPWR _5064_/X sky130_fd_sc_hd__mux2_1
XFILLER_69_388 VGND VGND VPWR VPWR sky130_fd_sc_hd__fill_4
Xhold1527 _5605_/Q VGND VGND VPWR VPWR _3568_/A0 sky130_fd_sc_hd__dlygate4sd3_1
Xhold1538 _3676_/X VGND VGND VPWR VPWR _5699_/D sky130_fd_sc_hd__dlygate4sd3_1
X_4015_ _5117_/B _4014_/B _3988_/B _5915_/Q VGND VGND VPWR VPWR _4015_/X sky130_fd_sc_hd__o211a_1
XANTENNA_fanout179_A _3027_/A VGND VGND VPWR VPWR sky130_fd_sc_hd__diode_2
XANTENNA__4481__A1 _5215_/A1 VGND VGND VPWR VPWR sky130_fd_sc_hd__diode_2
XFILLER_92_391 VGND VGND VPWR VPWR sky130_fd_sc_hd__fill_1
XFILLER_16_27 VGND VGND VPWR VPWR sky130_fd_sc_hd__fill_1
XFILLER_25_447 VGND VGND VPWR VPWR sky130_fd_sc_hd__fill_1
XFILLER_53_778 VGND VGND VPWR VPWR sky130_fd_sc_hd__fill_4
XANTENNA__4233__A1 _4272_/S VGND VGND VPWR VPWR sky130_fd_sc_hd__diode_2
X_5966_ _5990_/CLK hold88/X VGND VGND VPWR VPWR hold87/A sky130_fd_sc_hd__dfxtp_1
XFILLER_13_609 VGND VGND VPWR VPWR sky130_fd_sc_hd__fill_4
X_4917_ _5185_/A1 _4907_/Y _4916_/X _5176_/A VGND VGND VPWR VPWR _6259_/D sky130_fd_sc_hd__o211a_1
XTAP_TAPCELL_ROW_23_648 VGND VPWR sky130_fd_sc_hd__tapvpwrvgnd_1
XANTENNA__3387__S _3390_/S VGND VGND VPWR VPWR sky130_fd_sc_hd__diode_2
X_5897_ _5902_/CLK _5897_/D VGND VGND VPWR VPWR _5897_/Q sky130_fd_sc_hd__dfxtp_1
X_4848_ _4887_/A1 _4848_/A1 _4854_/S VGND VGND VPWR VPWR _4848_/X sky130_fd_sc_hd__mux2_1
XANTENNA_fanout134_X _5075_/A0 VGND VGND VPWR VPWR sky130_fd_sc_hd__diode_2
XFILLER_20_130 VGND VGND VPWR VPWR sky130_fd_sc_hd__fill_1
XFILLER_20_141 VGND VGND VPWR VPWR sky130_fd_sc_hd__fill_4
X_4779_ _4794_/A _4779_/B VGND VGND VPWR VPWR _4779_/X sky130_fd_sc_hd__or2_1
XFILLER_134_533 VPWR VGND VPWR VGND sky130_ef_sc_hd__decap_40_12
XFILLER_119_585 VPWR VGND VPWR VGND sky130_ef_sc_hd__decap_40_12
XFILLER_107_725 VGND VGND VPWR VPWR sky130_fd_sc_hd__fill_2
XFILLER_88_631 VGND VGND VPWR VPWR sky130_fd_sc_hd__fill_2
XTAP_TAPCELL_ROW_128_2219 VGND VPWR sky130_fd_sc_hd__tapvpwrvgnd_1
XFILLER_48_517 VGND VGND VPWR VPWR sky130_fd_sc_hd__fill_4
XANTENNA__4946__S _4954_/S VGND VGND VPWR VPWR sky130_fd_sc_hd__diode_2
XFILLER_0_557 VGND VGND VPWR VPWR sky130_fd_sc_hd__fill_2
XFILLER_76_837 VGND VGND VPWR VPWR sky130_fd_sc_hd__fill_4
XTAP_TAPCELL_ROW_50_1049 VGND VPWR sky130_fd_sc_hd__tapvpwrvgnd_1
XFILLER_29_731 VGND VGND VPWR VPWR sky130_fd_sc_hd__fill_1
XTAP_TAPCELL_ROW_3_351 VGND VPWR sky130_fd_sc_hd__tapvpwrvgnd_1
XTAP_TAPCELL_ROW_3_340 VGND VPWR sky130_fd_sc_hd__tapvpwrvgnd_1
XFILLER_28_230 VGND VGND VPWR VPWR sky130_fd_sc_hd__fill_1
XFILLER_44_701 VGND VGND VPWR VPWR sky130_fd_sc_hd__fill_1
XFILLER_29_797 VPWR VGND VPWR VGND sky130_ef_sc_hd__decap_40_12
XFILLER_73_33 VGND VGND VPWR VPWR sky130_fd_sc_hd__fill_2
XFILLER_71_531 VGND VGND VPWR VPWR sky130_fd_sc_hd__fill_1
XFILLER_43_222 VGND VGND VPWR VPWR sky130_fd_sc_hd__fill_2
XANTENNA__2990__A _3020_/A VGND VGND VPWR VPWR sky130_fd_sc_hd__diode_2
XFILLER_71_586 VGND VGND VPWR VPWR sky130_fd_sc_hd__fill_2
XANTENNA__4224__A1 _4264_/A1 VGND VGND VPWR VPWR sky130_fd_sc_hd__diode_2
XFILLER_43_277 VGND VGND VPWR VPWR sky130_fd_sc_hd__fill_2
XFILLER_16_469 VGND VGND VPWR VPWR sky130_fd_sc_hd__fill_4
XFILLER_73_99 VGND VGND VPWR VPWR sky130_fd_sc_hd__fill_1
XTAP_TAPCELL_ROW_65_1281 VGND VPWR sky130_fd_sc_hd__tapvpwrvgnd_1
XTAP_TAPCELL_ROW_65_1270 VGND VPWR sky130_fd_sc_hd__tapvpwrvgnd_1
XTAP_TAPCELL_ROW_42_935 VGND VPWR sky130_fd_sc_hd__tapvpwrvgnd_1
XTAP_TAPCELL_ROW_42_924 VGND VPWR sky130_fd_sc_hd__tapvpwrvgnd_1
XFILLER_31_439 VGND VGND VPWR VPWR sky130_fd_sc_hd__fill_1
XFILLER_8_613 VPWR VGND VPWR VGND sky130_ef_sc_hd__decap_40_12
XFILLER_12_697 VGND VGND VPWR VPWR sky130_fd_sc_hd__fill_2
XFILLER_8_657 VPWR VGND VPWR VGND sky130_ef_sc_hd__decap_40_12
XFILLER_7_189 VGND VGND VPWR VPWR sky130_fd_sc_hd__fill_4
XFILLER_7_167 VGND VGND VPWR VPWR sky130_fd_sc_hd__fill_1
XFILLER_138_81 VGND VGND VPWR VPWR sky130_fd_sc_hd__fill_2
XFILLER_4_841 VGND VGND VPWR VPWR sky130_fd_sc_hd__fill_1
XFILLER_3_395 VGND VGND VPWR VPWR sky130_fd_sc_hd__fill_1
XFILLER_3_373 VPWR VGND VPWR VGND sky130_ef_sc_hd__decap_40_12
XFILLER_94_601 VPWR VGND VPWR VGND sky130_ef_sc_hd__decap_40_12
XANTENNA__4856__S _4867_/S VGND VGND VPWR VPWR sky130_fd_sc_hd__diode_2
XANTENNA__3760__S _3766_/S VGND VGND VPWR VPWR sky130_fd_sc_hd__diode_2
XFILLER_121_783 VGND VGND VPWR VPWR sky130_fd_sc_hd__fill_1
XFILLER_94_645 VPWR VGND VPWR VGND sky130_ef_sc_hd__decap_40_12
XFILLER_66_369 VGND VGND VPWR VPWR sky130_fd_sc_hd__fill_2
XANTENNA_hold2109_A _5438_/Q VGND VGND VPWR VPWR sky130_fd_sc_hd__diode_2
XFILLER_19_263 VGND VGND VPWR VPWR sky130_fd_sc_hd__fill_1
XFILLER_62_531 VGND VGND VPWR VPWR sky130_fd_sc_hd__fill_1
X_5820_ _5820_/CLK _5820_/D VGND VGND VPWR VPWR _5820_/Q sky130_fd_sc_hd__dfxtp_1
XFILLER_62_564 VPWR VGND VPWR VGND sky130_ef_sc_hd__decap_40_12
XFILLER_22_417 VGND VGND VPWR VPWR sky130_fd_sc_hd__fill_2
XFILLER_35_767 VPWR VGND VPWR VGND sky130_ef_sc_hd__decap_40_12
X_5751_ _5753_/CLK _5751_/D VGND VGND VPWR VPWR _5751_/Q sky130_fd_sc_hd__dfxtp_1
X_2963_ _5352_/Q _5580_/Q _2963_/S VGND VGND VPWR VPWR _2963_/X sky130_fd_sc_hd__mux2_1
XANTENNA__2777__A1 _3036_/A1 VGND VGND VPWR VPWR sky130_fd_sc_hd__diode_2
X_4702_ _4689_/X _4701_/X _5401_/Q VGND VGND VPWR VPWR _4702_/X sky130_fd_sc_hd__mux2_1
X_2894_ _3096_/A1 _2893_/X _2890_/Y _2892_/Y VGND VGND VPWR VPWR _2894_/X sky130_fd_sc_hd__o2bb2a_1
XFILLER_8_50 VGND VGND VPWR VPWR sky130_fd_sc_hd__fill_1
XTAP_TAPCELL_ROW_20_607 VGND VPWR sky130_fd_sc_hd__tapvpwrvgnd_1
X_5682_ _5682_/CLK _5682_/D VGND VGND VPWR VPWR _5682_/Q sky130_fd_sc_hd__dfxtp_1
XFILLER_136_809 VGND VGND VPWR VPWR sky130_fd_sc_hd__fill_2
X_4633_ _4663_/A _4633_/B VGND VGND VPWR VPWR _4633_/X sky130_fd_sc_hd__and2_1
XFILLER_118_29 VPWR VGND VPWR VGND sky130_ef_sc_hd__decap_40_12
XTAP_TAPCELL_ROW_96_1742 VGND VPWR sky130_fd_sc_hd__tapvpwrvgnd_1
X_4564_ _4789_/A _4564_/B VGND VGND VPWR VPWR _4564_/X sky130_fd_sc_hd__or2_1
XANTENNA__4620__A _4789_/A VGND VGND VPWR VPWR sky130_fd_sc_hd__diode_2
XANTENNA__4923__C1 _5200_/A VGND VGND VPWR VPWR sky130_fd_sc_hd__diode_2
Xhold602 _6018_/Q VGND VGND VPWR VPWR hold602/X sky130_fd_sc_hd__dlygate4sd3_1
XFILLER_116_533 VPWR VGND VPWR VGND sky130_ef_sc_hd__decap_40_12
X_3515_ _5080_/A0 _3515_/A1 _3516_/S VGND VGND VPWR VPWR _3515_/X sky130_fd_sc_hd__mux2_1
Xhold613 _4527_/X VGND VGND VPWR VPWR _6129_/D sky130_fd_sc_hd__dlygate4sd3_1
Xhold635 _5730_/Q VGND VGND VPWR VPWR hold635/X sky130_fd_sc_hd__dlygate4sd3_1
X_6303_ _6312_/CLK _6303_/D VGND VGND VPWR VPWR _6303_/Q sky130_fd_sc_hd__dfxtp_1
Xhold624 _4381_/X VGND VGND VPWR VPWR _6021_/D sky130_fd_sc_hd__dlygate4sd3_1
Xhold679 _6438_/Q VGND VGND VPWR VPWR hold679/X sky130_fd_sc_hd__dlygate4sd3_1
Xhold668 _4463_/X VGND VGND VPWR VPWR _6071_/D sky130_fd_sc_hd__dlygate4sd3_1
XFILLER_131_503 VGND VGND VPWR VPWR sky130_fd_sc_hd__fill_1
X_6234_ _6242_/CLK _6234_/D VGND VGND VPWR VPWR _6234_/Q sky130_fd_sc_hd__dfxtp_1
Xhold646 _3146_/X VGND VGND VPWR VPWR _5327_/D sky130_fd_sc_hd__dlygate4sd3_1
Xhold657 _6346_/Q VGND VGND VPWR VPWR hold657/X sky130_fd_sc_hd__dlygate4sd3_1
X_4495_ hold983/X _5209_/A1 _4502_/S VGND VGND VPWR VPWR _4495_/X sky130_fd_sc_hd__mux2_1
XFILLER_103_249 VGND VGND VPWR VPWR sky130_fd_sc_hd__fill_2
X_3446_ hold633/X _5233_/A0 _3450_/S VGND VGND VPWR VPWR _3446_/X sky130_fd_sc_hd__mux2_1
Xhold2003 _3732_/X VGND VGND VPWR VPWR _5747_/D sky130_fd_sc_hd__dlygate4sd3_1
Xhold2014 _5271_/Q VGND VGND VPWR VPWR _2663_/A sky130_fd_sc_hd__dlygate4sd3_1
X_3377_ _5091_/A0 _4994_/B _4445_/B _4905_/A0 _3801_/B VGND VGND VPWR VPWR _3377_/X
+ sky130_fd_sc_hd__a221o_1
X_6165_ _6297_/CLK _6165_/D VGND VGND VPWR VPWR _6165_/Q sky130_fd_sc_hd__dfxtp_1
XFILLER_58_804 VGND VGND VPWR VPWR sky130_fd_sc_hd__fill_8
Xhold2025 _5386_/Q VGND VGND VPWR VPWR _3228_/B sky130_fd_sc_hd__dlygate4sd3_1
Xhold2036 _5344_/Q VGND VGND VPWR VPWR _2703_/A sky130_fd_sc_hd__dlygate4sd3_1
X_6096_ _6098_/CLK _6096_/D VGND VGND VPWR VPWR _6096_/Q sky130_fd_sc_hd__dfxtp_1
XFILLER_85_623 VGND VGND VPWR VPWR sky130_fd_sc_hd__fill_1
Xhold1324 _3600_/X VGND VGND VPWR VPWR _5633_/D sky130_fd_sc_hd__dlygate4sd3_1
XFILLER_58_837 VGND VGND VPWR VPWR sky130_fd_sc_hd__fill_4
Xhold1302 _2712_/X VGND VGND VPWR VPWR _5260_/D sky130_fd_sc_hd__dlygate4sd3_1
X_5116_ _5029_/B _5011_/C _3983_/Y VGND VGND VPWR VPWR _5116_/X sky130_fd_sc_hd__o21ba_1
Xhold1313 _3723_/X VGND VGND VPWR VPWR _5741_/D sky130_fd_sc_hd__dlygate4sd3_1
Xhold2069 _3357_/X VGND VGND VPWR VPWR _5432_/D sky130_fd_sc_hd__dlygate4sd3_1
XANTENNA__4129__S1 _4212_/A VGND VGND VPWR VPWR sky130_fd_sc_hd__diode_2
Xhold2047 _5431_/Q VGND VGND VPWR VPWR _5214_/A0 sky130_fd_sc_hd__dlygate4sd3_1
Xhold2058 _5435_/Q VGND VGND VPWR VPWR _5210_/A0 sky130_fd_sc_hd__dlygate4sd3_1
Xhold1368 _4819_/X VGND VGND VPWR VPWR _6173_/D sky130_fd_sc_hd__dlygate4sd3_1
Xhold1346 _5875_/Q VGND VGND VPWR VPWR _3896_/A0 sky130_fd_sc_hd__dlygate4sd3_1
X_5047_ hold791/X _5047_/A1 _5047_/S VGND VGND VPWR VPWR _5047_/X sky130_fd_sc_hd__mux2_1
XFILLER_57_369 VGND VGND VPWR VPWR sky130_fd_sc_hd__fill_2
Xhold1335 _4365_/X VGND VGND VPWR VPWR _6007_/D sky130_fd_sc_hd__dlygate4sd3_1
Xhold1357 _5942_/Q VGND VGND VPWR VPWR _4291_/A0 sky130_fd_sc_hd__dlygate4sd3_1
Xhold1379 _6244_/Q VGND VGND VPWR VPWR _4896_/A1 sky130_fd_sc_hd__dlygate4sd3_1
XTAP_TAPCELL_ROW_123_2138 VGND VPWR sky130_fd_sc_hd__tapvpwrvgnd_1
XTAP_TAPCELL_ROW_28_718 VGND VPWR sky130_fd_sc_hd__tapvpwrvgnd_1
XTAP_TAPCELL_ROW_123_2149 VGND VPWR sky130_fd_sc_hd__tapvpwrvgnd_1
XPHY_EDGE_ROW_40_Left_179 VGND VGND VPWR VPWR sky130_fd_sc_hd__decap_3
XTAP_TAPCELL_ROW_105_1882 VGND VPWR sky130_fd_sc_hd__tapvpwrvgnd_1
XTAP_TAPCELL_ROW_105_1871 VGND VPWR sky130_fd_sc_hd__tapvpwrvgnd_1
XFILLER_80_394 VGND VGND VPWR VPWR sky130_fd_sc_hd__fill_2
X_5949_ _6404_/CLK _5949_/D VGND VGND VPWR VPWR _5949_/Q sky130_fd_sc_hd__dfxtp_1
XFILLER_13_417 VPWR VGND VPWR VGND sky130_ef_sc_hd__decap_40_12
XFILLER_41_737 VGND VGND VPWR VPWR sky130_fd_sc_hd__fill_2
XFILLER_40_269 VGND VGND VPWR VPWR sky130_fd_sc_hd__fill_4
XFILLER_138_113 VGND VGND VPWR VPWR sky130_fd_sc_hd__fill_2
XFILLER_21_461 VPWR VGND VPWR VGND sky130_ef_sc_hd__decap_40_12
XTAP_TAPCELL_ROW_138_2392 VGND VPWR sky130_fd_sc_hd__tapvpwrvgnd_1
XTAP_TAPCELL_ROW_138_2381 VGND VPWR sky130_fd_sc_hd__tapvpwrvgnd_1
XTAP_TAPCELL_ROW_138_2370 VGND VPWR sky130_fd_sc_hd__tapvpwrvgnd_1
XFILLER_127_809 VPWR VGND VPWR VGND sky130_ef_sc_hd__decap_40_12
XFILLER_104_3 VPWR VGND VPWR VGND sky130_ef_sc_hd__decap_40_12
XANTENNA__3193__A1 _5237_/A0 VGND VGND VPWR VPWR sky130_fd_sc_hd__diode_2
XANTENNA__4390__A0 _4978_/A1 VGND VGND VPWR VPWR sky130_fd_sc_hd__diode_2
XTAP_TAPCELL_ROW_8_421 VGND VPWR sky130_fd_sc_hd__tapvpwrvgnd_1
XFILLER_0_321 VGND VGND VPWR VPWR sky130_fd_sc_hd__fill_8
XFILLER_1_833 VGND VGND VPWR VPWR sky130_fd_sc_hd__fill_4
XFILLER_122_569 VPWR VGND VPWR VGND sky130_ef_sc_hd__decap_40_12
XFILLER_103_783 VGND VGND VPWR VPWR sky130_fd_sc_hd__fill_1
XFILLER_49_837 VGND VGND VPWR VPWR sky130_fd_sc_hd__fill_2
XFILLER_0_365 VGND VGND VPWR VPWR sky130_fd_sc_hd__fill_2
XFILLER_124_83 VGND VGND VPWR VPWR sky130_fd_sc_hd__fill_1
XFILLER_84_21 VGND VGND VPWR VPWR sky130_fd_sc_hd__fill_4
XANTENNA_input24_A s_axil_wdata[6] VGND VGND VPWR VPWR sky130_fd_sc_hd__diode_2
XFILLER_91_615 VGND VGND VPWR VPWR sky130_fd_sc_hd__fill_1
XFILLER_75_166 VGND VGND VPWR VPWR sky130_fd_sc_hd__fill_2
XTAP_TAPCELL_ROW_67_1310 VGND VPWR sky130_fd_sc_hd__tapvpwrvgnd_1
Xhold1880 _4408_/X VGND VGND VPWR VPWR _6045_/D sky130_fd_sc_hd__dlygate4sd3_1
XFILLER_29_561 VGND VGND VPWR VPWR sky130_fd_sc_hd__fill_1
Xhold1891 _4820_/X VGND VGND VPWR VPWR _6174_/D sky130_fd_sc_hd__dlygate4sd3_1
XFILLER_56_380 VGND VGND VPWR VPWR sky130_fd_sc_hd__fill_8
XFILLER_44_531 VGND VGND VPWR VPWR sky130_fd_sc_hd__fill_1
XFILLER_31_203 VGND VGND VPWR VPWR sky130_fd_sc_hd__fill_1
XANTENNA__2759__A1 _3076_/A1 VGND VGND VPWR VPWR sky130_fd_sc_hd__diode_2
XFILLER_129_113 VGND VGND VPWR VPWR sky130_fd_sc_hd__fill_2
XFILLER_83_8 VGND VGND VPWR VPWR sky130_fd_sc_hd__fill_2
XFILLER_8_421 VPWR VGND VPWR VGND sky130_ef_sc_hd__decap_40_12
XFILLER_129_135 VGND VGND VPWR VPWR sky130_fd_sc_hd__fill_2
XFILLER_118_809 VGND VGND VPWR VPWR sky130_fd_sc_hd__fill_2
XFILLER_117_319 VGND VGND VPWR VPWR sky130_fd_sc_hd__fill_1
XANTENNA__3184__A1 _5228_/A0 VGND VGND VPWR VPWR sky130_fd_sc_hd__diode_2
XTAP_TAPCELL_ROW_78_1472 VGND VPWR sky130_fd_sc_hd__tapvpwrvgnd_1
XANTENNA__2931__A1 _3076_/A1 VGND VGND VPWR VPWR sky130_fd_sc_hd__diode_2
X_3300_ hold216/X _4846_/A0 _3308_/S VGND VGND VPWR VPWR _3300_/X sky130_fd_sc_hd__mux2_1
X_4280_ hold528/X _5043_/A1 _4284_/S VGND VGND VPWR VPWR _4280_/X sky130_fd_sc_hd__mux2_1
XFILLER_4_693 VGND VGND VPWR VPWR sky130_fd_sc_hd__fill_4
XANTENNA__3490__S _3490_/S VGND VGND VPWR VPWR sky130_fd_sc_hd__diode_2
XFILLER_101_709 VPWR VGND VPWR VGND sky130_ef_sc_hd__decap_40_12
XTAP_TAPCELL_ROW_91_1672 VGND VPWR sky130_fd_sc_hd__tapvpwrvgnd_1
XTAP_TAPCELL_ROW_91_1661 VGND VPWR sky130_fd_sc_hd__tapvpwrvgnd_1
X_3231_ _5216_/A _3231_/B VGND VGND VPWR VPWR _3553_/C sky130_fd_sc_hd__nand2_2
XFILLER_67_634 VPWR VGND VPWR VGND sky130_ef_sc_hd__decap_40_12
XANTENNA_hold2226_A _5824_/Q VGND VGND VPWR VPWR sky130_fd_sc_hd__diode_2
X_3162_ _3162_/A _3259_/S VGND VGND VPWR VPWR _4189_/S sky130_fd_sc_hd__nand2_1
X_3093_ _3033_/S _6230_/Q _3034_/A VGND VGND VPWR VPWR _3093_/X sky130_fd_sc_hd__a21bo_1
XFILLER_94_475 VGND VGND VPWR VPWR sky130_fd_sc_hd__fill_1
XANTENNA__4436__A1 _5234_/A0 VGND VGND VPWR VPWR sky130_fd_sc_hd__diode_2
XFILLER_81_136 VGND VGND VPWR VPWR sky130_fd_sc_hd__fill_4
XFILLER_47_391 VGND VGND VPWR VPWR sky130_fd_sc_hd__fill_1
XANTENNA__2834__S _3077_/S VGND VGND VPWR VPWR sky130_fd_sc_hd__diode_2
XFILLER_81_169 VGND VGND VPWR VPWR sky130_fd_sc_hd__fill_1
XFILLER_90_681 VPWR VGND VPWR VGND sky130_ef_sc_hd__decap_40_12
XFILLER_62_383 VPWR VGND VPWR VGND sky130_ef_sc_hd__decap_40_12
X_5803_ _5803_/CLK _5803_/D VGND VGND VPWR VPWR _5803_/Q sky130_fd_sc_hd__dfxtp_1
X_3995_ _5917_/Q _5916_/Q _5117_/B VGND VGND VPWR VPWR _3997_/S sky130_fd_sc_hd__a21o_1
X_2946_ _6237_/Q _6213_/Q _3062_/S VGND VGND VPWR VPWR _2947_/B sky130_fd_sc_hd__mux2_1
XFILLER_50_589 VGND VGND VPWR VPWR sky130_fd_sc_hd__fill_1
X_5734_ clkload7/A _5734_/D VGND VGND VPWR VPWR _5734_/Q sky130_fd_sc_hd__dfxtp_1
XFILLER_31_781 VGND VGND VPWR VPWR sky130_fd_sc_hd__fill_2
XTAP_TAPCELL_ROW_33_798 VGND VPWR sky130_fd_sc_hd__tapvpwrvgnd_1
X_2877_ _5517_/Q _5529_/Q _3051_/S VGND VGND VPWR VPWR _2877_/X sky130_fd_sc_hd__mux2_1
XFILLER_129_39 VGND VGND VPWR VPWR sky130_fd_sc_hd__fill_1
XFILLER_109_809 VPWR VGND VPWR VGND sky130_ef_sc_hd__decap_40_12
XANTENNA__3665__S _3667_/S VGND VGND VPWR VPWR sky130_fd_sc_hd__diode_2
X_5665_ _5681_/CLK _5665_/D VGND VGND VPWR VPWR _5665_/Q sky130_fd_sc_hd__dfxtp_1
XFILLER_30_280 VGND VGND VPWR VPWR sky130_fd_sc_hd__fill_4
X_4616_ _4597_/X _4603_/X _4615_/X _4609_/X _4799_/A _4785_/S VGND VGND VPWR VPWR
+ _4616_/X sky130_fd_sc_hd__mux4_1
XPHY_EDGE_ROW_111_Right_111 VGND VGND VPWR VPWR sky130_fd_sc_hd__decap_3
X_5596_ _6292_/CLK _5596_/D VGND VGND VPWR VPWR _5596_/Q sky130_fd_sc_hd__dfxtp_1
XANTENNA__4598__S1 _4600_/A VGND VGND VPWR VPWR sky130_fd_sc_hd__diode_2
XANTENNA__4372__A0 _4980_/A1 VGND VGND VPWR VPWR sky130_fd_sc_hd__diode_2
Xhold410 _4981_/X VGND VGND VPWR VPWR _6313_/D sky130_fd_sc_hd__dlygate4sd3_1
X_4547_ hold451/X _5816_/Q _4547_/S VGND VGND VPWR VPWR _4547_/X sky130_fd_sc_hd__mux2_1
Xhold454 _3533_/X VGND VGND VPWR VPWR _5576_/D sky130_fd_sc_hd__dlygate4sd3_1
Xhold443 _5641_/Q VGND VGND VPWR VPWR hold443/X sky130_fd_sc_hd__dlygate4sd3_1
Xhold421 _5898_/Q VGND VGND VPWR VPWR hold421/X sky130_fd_sc_hd__dlygate4sd3_1
Xhold432 _3656_/X VGND VGND VPWR VPWR _5682_/D sky130_fd_sc_hd__dlygate4sd3_1
Xhold487 _5528_/Q VGND VGND VPWR VPWR hold487/X sky130_fd_sc_hd__dlygate4sd3_1
XANTENNA__2922__B2 _3096_/A1 VGND VGND VPWR VPWR sky130_fd_sc_hd__diode_2
XFILLER_104_525 VGND VGND VPWR VPWR sky130_fd_sc_hd__fill_4
XFILLER_89_225 VGND VGND VPWR VPWR sky130_fd_sc_hd__fill_1
Xhold476 _3439_/X VGND VGND VPWR VPWR _5489_/D sky130_fd_sc_hd__dlygate4sd3_1
Xhold465 _5883_/Q VGND VGND VPWR VPWR hold465/X sky130_fd_sc_hd__dlygate4sd3_1
X_4478_ hold305/X _5212_/A1 _4482_/S VGND VGND VPWR VPWR _4478_/X sky130_fd_sc_hd__mux2_1
XFILLER_104_569 VPWR VGND VPWR VGND sky130_ef_sc_hd__decap_40_12
X_6217_ _6241_/CLK _6217_/D VGND VGND VPWR VPWR _6217_/Q sky130_fd_sc_hd__dfxtp_1
X_3429_ hold926/X _4846_/A0 _3437_/S VGND VGND VPWR VPWR _3429_/X sky130_fd_sc_hd__mux2_1
Xhold498 _4366_/X VGND VGND VPWR VPWR _6008_/D sky130_fd_sc_hd__dlygate4sd3_1
XANTENNA__4124__B1 _4272_/S VGND VGND VPWR VPWR sky130_fd_sc_hd__diode_2
X_6148_ _6148_/CLK _6148_/D VGND VGND VPWR VPWR _6148_/Q sky130_fd_sc_hd__dfxtp_1
XFILLER_98_781 VPWR VGND VPWR VGND sky130_ef_sc_hd__decap_40_12
XFILLER_85_420 VGND VGND VPWR VPWR sky130_fd_sc_hd__fill_1
XFILLER_38_25 VGND VGND VPWR VPWR sky130_fd_sc_hd__fill_1
Xhold1121 _3125_/X VGND VGND VPWR VPWR _5318_/D sky130_fd_sc_hd__dlygate4sd3_1
XANTENNA__2686__B1 _5222_/A VGND VGND VPWR VPWR sky130_fd_sc_hd__diode_2
XFILLER_100_753 VGND VGND VPWR VPWR sky130_fd_sc_hd__fill_2
Xhold1110 _5877_/Q VGND VGND VPWR VPWR _3898_/A0 sky130_fd_sc_hd__dlygate4sd3_1
Xhold1132 _5924_/Q VGND VGND VPWR VPWR _4189_/A0 sky130_fd_sc_hd__dlygate4sd3_1
X_6079_ _6429_/CLK _6079_/D VGND VGND VPWR VPWR _6079_/Q sky130_fd_sc_hd__dfxtp_1
Xhold1143 _3487_/X VGND VGND VPWR VPWR _5533_/D sky130_fd_sc_hd__dlygate4sd3_1
XTAP_TAPCELL_ROW_107_1911 VGND VPWR sky130_fd_sc_hd__tapvpwrvgnd_1
XTAP_TAPCELL_ROW_107_1900 VGND VPWR sky130_fd_sc_hd__tapvpwrvgnd_1
Xhold1154 _6194_/Q VGND VGND VPWR VPWR _4841_/A1 sky130_fd_sc_hd__dlygate4sd3_1
Xhold1176 _3589_/X VGND VGND VPWR VPWR _5623_/D sky130_fd_sc_hd__dlygate4sd3_1
Xhold1165 _5737_/Q VGND VGND VPWR VPWR _3717_/A0 sky130_fd_sc_hd__dlygate4sd3_1
Xhold1198 _5726_/Q VGND VGND VPWR VPWR _4730_/A3 sky130_fd_sc_hd__dlygate4sd3_1
Xhold1187 _6009_/Q VGND VGND VPWR VPWR _4368_/A1 sky130_fd_sc_hd__dlygate4sd3_1
XTAP_TAPCELL_ROW_49_1040 VGND VPWR sky130_fd_sc_hd__tapvpwrvgnd_1
XFILLER_14_737 VPWR VGND VPWR VGND sky130_ef_sc_hd__decap_40_12
XFILLER_110_41 VGND VGND VPWR VPWR sky130_fd_sc_hd__fill_4
XANTENNA__3938__A0 _4984_/A1 VGND VGND VPWR VPWR sky130_fd_sc_hd__diode_2
XFILLER_13_269 VGND VGND VPWR VPWR sky130_fd_sc_hd__fill_8
XFILLER_22_781 VPWR VGND VPWR VGND sky130_ef_sc_hd__decap_40_12
XFILLER_127_617 VPWR VGND VPWR VGND sky130_ef_sc_hd__decap_40_12
XTAP_TAPCELL_ROW_11_459 VGND VPWR sky130_fd_sc_hd__tapvpwrvgnd_1
XFILLER_126_149 VGND VGND VPWR VPWR sky130_fd_sc_hd__fill_1
XFILLER_5_446 VGND VGND VPWR VPWR sky130_fd_sc_hd__fill_2
XANTENNA__3166__A1 _4257_/S VGND VGND VPWR VPWR sky130_fd_sc_hd__diode_2
XFILLER_119_83 VGND VGND VPWR VPWR sky130_fd_sc_hd__fill_4
XFILLER_79_32 VPWR VGND VPWR VGND sky130_ef_sc_hd__decap_40_12
XFILLER_122_333 VGND VGND VPWR VPWR sky130_fd_sc_hd__fill_1
XFILLER_122_311 VGND VGND VPWR VPWR sky130_fd_sc_hd__fill_1
XANTENNA__2919__S _3077_/S VGND VGND VPWR VPWR sky130_fd_sc_hd__diode_2
XFILLER_1_641 VPWR VGND VPWR VGND sky130_ef_sc_hd__decap_40_12
XFILLER_89_781 VGND VGND VPWR VPWR sky130_fd_sc_hd__fill_2
XTAP_TAPCELL_ROW_73_1391 VGND VPWR sky130_fd_sc_hd__tapvpwrvgnd_1
XFILLER_49_612 VGND VGND VPWR VPWR sky130_fd_sc_hd__fill_4
XFILLER_1_685 VPWR VGND VPWR VGND sky130_ef_sc_hd__decap_40_12
XANTENNA_clkbuf_leaf_76_clk_A clkload2/A VGND VGND VPWR VPWR sky130_fd_sc_hd__diode_2
XFILLER_48_133 VGND VGND VPWR VPWR sky130_fd_sc_hd__fill_1
XFILLER_0_195 VGND VGND VPWR VPWR sky130_fd_sc_hd__fill_1
XFILLER_0_184 VGND VGND VPWR VPWR sky130_fd_sc_hd__fill_1
XFILLER_0_173 VGND VGND VPWR VPWR sky130_fd_sc_hd__fill_2
XFILLER_29_391 VGND VGND VPWR VPWR sky130_fd_sc_hd__fill_1
XFILLER_17_553 VGND VGND VPWR VPWR sky130_fd_sc_hd__fill_4
XFILLER_17_597 VPWR VGND VPWR VGND sky130_ef_sc_hd__decap_40_12
X_2800_ _5749_/Q _5273_/Q _3030_/S VGND VGND VPWR VPWR _2800_/X sky130_fd_sc_hd__mux2_1
X_3780_ _4599_/A1 _5209_/A1 _3787_/S VGND VGND VPWR VPWR _3780_/X sky130_fd_sc_hd__mux2_1
X_2731_ _3085_/A _2732_/C _2730_/Y VGND VGND VPWR VPWR _5268_/D sky130_fd_sc_hd__o21a_1
XANTENNA_clkbuf_leaf_14_clk_A clkbuf_leaf_9_clk/A VGND VGND VPWR VPWR sky130_fd_sc_hd__diode_2
XFILLER_9_741 VPWR VGND VPWR VGND sky130_ef_sc_hd__decap_40_12
XFILLER_13_781 VGND VGND VPWR VPWR sky130_fd_sc_hd__fill_2
XTAP_TAPCELL_ROW_30_746 VGND VPWR sky130_fd_sc_hd__tapvpwrvgnd_1
XANTENNA__3485__S _3490_/S VGND VGND VPWR VPWR sky130_fd_sc_hd__diode_2
XANTENNA__4029__S0 _4262_/S VGND VGND VPWR VPWR sky130_fd_sc_hd__diode_2
XFILLER_9_785 VPWR VGND VPWR VGND sky130_ef_sc_hd__decap_40_12
X_5450_ _5908_/CLK _5450_/D VGND VGND VPWR VPWR _5450_/Q sky130_fd_sc_hd__dfxtp_1
XFILLER_8_251 VGND VGND VPWR VPWR sky130_fd_sc_hd__fill_1
XTAP_TAPCELL_ROW_30_757 VGND VPWR sky130_fd_sc_hd__tapvpwrvgnd_1
XFILLER_133_609 VGND VGND VPWR VPWR sky130_fd_sc_hd__fill_4
X_2662_ _2981_/S _2688_/A _3113_/B _2967_/S _2658_/X VGND VGND VPWR VPWR _2722_/C
+ sky130_fd_sc_hd__a221o_1
XTAP_TAPCELL_ROW_93_1701 VGND VPWR sky130_fd_sc_hd__tapvpwrvgnd_1
X_4401_ _5042_/A1 _4401_/A1 _4406_/S VGND VGND VPWR VPWR _4401_/X sky130_fd_sc_hd__mux2_1
XANTENNA_clkbuf_leaf_29_clk_A clkload3/A VGND VGND VPWR VPWR sky130_fd_sc_hd__diode_2
X_5381_ _6294_/CLK _5381_/D VGND VGND VPWR VPWR _5381_/Q sky130_fd_sc_hd__dfxtp_1
XFILLER_5_51 VGND VGND VPWR VPWR sky130_fd_sc_hd__fill_4
X_4332_ _5044_/A1 _4332_/A1 _4335_/S VGND VGND VPWR VPWR _4332_/X sky130_fd_sc_hd__mux2_1
XANTENNA__2829__S _3086_/S VGND VGND VPWR VPWR sky130_fd_sc_hd__diode_2
X_4263_ _4263_/A _4263_/B VGND VGND VPWR VPWR _4263_/X sky130_fd_sc_hd__or2_1
X_3214_ _5075_/A0 _3214_/A1 _3220_/S VGND VGND VPWR VPWR _3214_/X sky130_fd_sc_hd__mux2_1
XFILLER_101_517 VPWR VGND VPWR VGND sky130_ef_sc_hd__decap_40_12
XANTENNA__4657__A1 _4791_/A1 VGND VGND VPWR VPWR sky130_fd_sc_hd__diode_2
X_6002_ _6347_/CLK _6002_/D VGND VGND VPWR VPWR _6002_/Q sky130_fd_sc_hd__dfxtp_1
XPHY_EDGE_ROW_105_Left_244 VGND VGND VPWR VPWR sky130_fd_sc_hd__decap_3
X_4194_ _4252_/A1 _4193_/X _4252_/B1 VGND VGND VPWR VPWR _4194_/X sky130_fd_sc_hd__o21a_1
XFILLER_39_111 VGND VGND VPWR VPWR sky130_fd_sc_hd__fill_1
X_3145_ _3967_/B hold2/X _3156_/S VGND VGND VPWR VPWR _3145_/X sky130_fd_sc_hd__mux2_1
XFILLER_67_464 VGND VGND VPWR VPWR sky130_fd_sc_hd__fill_2
X_3076_ _3076_/A1 _3071_/X _3075_/X VGND VGND VPWR VPWR _3076_/X sky130_fd_sc_hd__a21o_1
XFILLER_27_339 VGND VGND VPWR VPWR sky130_fd_sc_hd__fill_1
XFILLER_70_618 VGND VGND VPWR VPWR sky130_fd_sc_hd__fill_2
XTAP_TAPCELL_ROW_38_868 VGND VPWR sky130_fd_sc_hd__tapvpwrvgnd_1
XFILLER_63_670 VGND VGND VPWR VPWR sky130_fd_sc_hd__fill_2
XFILLER_51_821 VPWR VGND VPWR VGND sky130_ef_sc_hd__decap_40_12
XTAP_TAPCELL_ROW_18_570 VGND VPWR sky130_fd_sc_hd__tapvpwrvgnd_1
XANTENNA_fanout161_A _4178_/A VGND VGND VPWR VPWR sky130_fd_sc_hd__diode_2
XTAP_TAPCELL_ROW_102_1830 VGND VPWR sky130_fd_sc_hd__tapvpwrvgnd_1
XFILLER_24_27 VGND VGND VPWR VPWR sky130_fd_sc_hd__fill_1
XPHY_EDGE_ROW_114_Left_253 VGND VGND VPWR VPWR sky130_fd_sc_hd__decap_3
X_3978_ _5060_/A _3337_/B _3974_/Y _3977_/Y VGND VGND VPWR VPWR _3993_/C sky130_fd_sc_hd__a31oi_2
XFILLER_11_729 VPWR VGND VPWR VGND sky130_ef_sc_hd__decap_40_12
X_2929_ _6429_/Q _5314_/Q _3072_/S VGND VGND VPWR VPWR _2929_/X sky130_fd_sc_hd__mux2_1
X_5717_ _6120_/CLK _5717_/D VGND VGND VPWR VPWR _5717_/Q sky130_fd_sc_hd__dfxtp_1
XANTENNA__3396__A1 _4929_/A1 VGND VGND VPWR VPWR sky130_fd_sc_hd__diode_2
XFILLER_109_617 VGND VGND VPWR VPWR sky130_fd_sc_hd__fill_4
XANTENNA__5176__A _5176_/A VGND VGND VPWR VPWR sky130_fd_sc_hd__diode_2
XANTENNA__4080__A _4251_/A VGND VGND VPWR VPWR sky130_fd_sc_hd__diode_2
X_5648_ _5714_/CLK hold30/X VGND VGND VPWR VPWR hold29/A sky130_fd_sc_hd__dfxtp_1
X_5579_ _5820_/CLK _5579_/D VGND VGND VPWR VPWR _5579_/Q sky130_fd_sc_hd__dfxtp_1
Xhold251 _4538_/X VGND VGND VPWR VPWR _6140_/D sky130_fd_sc_hd__dlygate4sd3_1
XTAP_TAPCELL_ROW_131_2259 VGND VPWR sky130_fd_sc_hd__tapvpwrvgnd_1
Xhold240 _6349_/Q VGND VGND VPWR VPWR hold240/X sky130_fd_sc_hd__dlygate4sd3_1
Xhold262 _6003_/Q VGND VGND VPWR VPWR hold262/X sky130_fd_sc_hd__dlygate4sd3_1
Xhold273 _3288_/X VGND VGND VPWR VPWR _5407_/D sky130_fd_sc_hd__dlygate4sd3_1
Xhold284 _5365_/Q VGND VGND VPWR VPWR hold284/X sky130_fd_sc_hd__dlygate4sd3_1
Xhold295 _6226_/Q VGND VGND VPWR VPWR hold295/X sky130_fd_sc_hd__dlygate4sd3_1
XFILLER_132_697 VGND VGND VPWR VPWR sky130_fd_sc_hd__fill_2
XPHY_EDGE_ROW_123_Left_262 VGND VGND VPWR VPWR sky130_fd_sc_hd__decap_3
XFILLER_120_837 VGND VGND VPWR VPWR sky130_fd_sc_hd__fill_4
XTAP_TAPCELL_ROW_113_1992 VGND VPWR sky130_fd_sc_hd__tapvpwrvgnd_1
XFILLER_49_57 VGND VGND VPWR VPWR sky130_fd_sc_hd__fill_4
XFILLER_131_185 VGND VGND VPWR VPWR sky130_fd_sc_hd__fill_1
XANTENNA__3856__C1 _5222_/A VGND VGND VPWR VPWR sky130_fd_sc_hd__diode_2
XANTENNA__2754__S0 _3016_/S VGND VGND VPWR VPWR sky130_fd_sc_hd__diode_2
XANTENNA__4954__S _4954_/S VGND VGND VPWR VPWR sky130_fd_sc_hd__diode_2
XFILLER_45_169 VGND VGND VPWR VPWR sky130_fd_sc_hd__fill_1
XFILLER_54_681 VGND VGND VPWR VPWR sky130_fd_sc_hd__fill_1
XFILLER_14_501 VPWR VGND VPWR VGND sky130_ef_sc_hd__decap_40_12
XPHY_EDGE_ROW_132_Left_271 VGND VGND VPWR VPWR sky130_fd_sc_hd__decap_3
XANTENNA__2831__B1 _2995_/A VGND VGND VPWR VPWR sky130_fd_sc_hd__diode_2
XFILLER_81_22 VPWR VGND VPWR VGND sky130_ef_sc_hd__decap_40_12
XFILLER_14_545 VPWR VGND VPWR VGND sky130_ef_sc_hd__decap_40_12
XANTENNA__4259__S0 _2636_/Y VGND VGND VPWR VPWR sky130_fd_sc_hd__diode_2
XFILLER_41_320 VGND VGND VPWR VPWR sky130_fd_sc_hd__fill_1
XFILLER_14_589 VPWR VGND VPWR VGND sky130_ef_sc_hd__decap_40_12
XANTENNA__3387__A1 _5044_/A1 VGND VGND VPWR VPWR sky130_fd_sc_hd__diode_2
XFILLER_127_447 VGND VGND VPWR VPWR sky130_fd_sc_hd__fill_1
XANTENNA__4421__C input4/X VGND VGND VPWR VPWR sky130_fd_sc_hd__diode_2
XFILLER_115_609 VGND VGND VPWR VPWR sky130_fd_sc_hd__fill_4
XTAP_TAPCELL_ROW_75_1420 VGND VPWR sky130_fd_sc_hd__tapvpwrvgnd_1
XFILLER_6_755 VGND VGND VPWR VPWR sky130_fd_sc_hd__fill_1
XANTENNA__4887__A1 _4887_/A1 VGND VGND VPWR VPWR sky130_fd_sc_hd__diode_2
XTAP_TAPCELL_ROW_75_1431 VGND VPWR sky130_fd_sc_hd__tapvpwrvgnd_1
XFILLER_123_653 VPWR VGND VPWR VGND sky130_ef_sc_hd__decap_40_12
XFILLER_122_141 VGND VGND VPWR VPWR sky130_fd_sc_hd__fill_2
XANTENNA__2993__S0 _3077_/S VGND VGND VPWR VPWR sky130_fd_sc_hd__diode_2
XFILLER_123_697 VPWR VGND VPWR VGND sky130_ef_sc_hd__decap_40_12
XFILLER_111_837 VGND VGND VPWR VPWR sky130_fd_sc_hd__fill_2
XFILLER_110_358 VGND VGND VPWR VPWR sky130_fd_sc_hd__fill_4
XANTENNA__3847__C1 _5176_/A VGND VGND VPWR VPWR sky130_fd_sc_hd__diode_2
XANTENNA__4864__S _4867_/S VGND VGND VPWR VPWR sky130_fd_sc_hd__diode_2
XFILLER_76_250 VGND VGND VPWR VPWR sky130_fd_sc_hd__fill_2
Xinput8 s_axil_awaddr[3] VGND VGND VPWR VPWR input8/X sky130_fd_sc_hd__clkbuf_2
XFILLER_91_253 VGND VGND VPWR VPWR sky130_fd_sc_hd__fill_4
XFILLER_52_618 VGND VGND VPWR VPWR sky130_fd_sc_hd__fill_8
XFILLER_91_264 VGND VGND VPWR VPWR sky130_fd_sc_hd__fill_1
X_4950_ _4980_/A1 _4950_/A1 _4954_/S VGND VGND VPWR VPWR _4950_/X sky130_fd_sc_hd__mux2_1
XANTENNA__4165__A _4212_/A VGND VGND VPWR VPWR sky130_fd_sc_hd__diode_2
XFILLER_33_821 VPWR VGND VPWR VGND sky130_ef_sc_hd__decap_40_12
XTAP_TAPCELL_ROW_35_827 VGND VPWR sky130_fd_sc_hd__tapvpwrvgnd_1
XANTENNA__4811__A1 _4811_/A1 VGND VGND VPWR VPWR sky130_fd_sc_hd__diode_2
X_4881_ _4881_/A _4881_/B VGND VGND VPWR VPWR _4893_/S sky130_fd_sc_hd__nor2_8
XTAP_TAPCELL_ROW_86_1593 VGND VPWR sky130_fd_sc_hd__tapvpwrvgnd_1
X_3901_ hold246/X _5209_/A1 _3908_/S VGND VGND VPWR VPWR _3901_/X sky130_fd_sc_hd__mux2_1
X_3832_ _2654_/Y _4451_/A _3835_/S VGND VGND VPWR VPWR _3832_/X sky130_fd_sc_hd__o21a_1
XANTENNA__3378__B2 _3377_/X VGND VGND VPWR VPWR sky130_fd_sc_hd__diode_2
X_5502_ _6432_/CLK _5502_/D VGND VGND VPWR VPWR _5502_/Q sky130_fd_sc_hd__dfxtp_1
X_3763_ _3763_/A0 _4981_/A1 _3766_/S VGND VGND VPWR VPWR _3763_/X sky130_fd_sc_hd__mux2_1
X_2714_ _5045_/A1 _2714_/A1 _2716_/S VGND VGND VPWR VPWR _2714_/X sky130_fd_sc_hd__mux2_1
X_3694_ hold459/X _4488_/A0 _3698_/S VGND VGND VPWR VPWR _3694_/X sky130_fd_sc_hd__mux2_1
XANTENNA__4327__A0 _5051_/A1 VGND VGND VPWR VPWR sky130_fd_sc_hd__diode_2
X_2645_ _2645_/A VGND VGND VPWR VPWR _3113_/B sky130_fd_sc_hd__inv_2
X_5433_ _6420_/CLK _5433_/D VGND VGND VPWR VPWR _5433_/Q sky130_fd_sc_hd__dfxtp_1
X_5364_ _6148_/CLK _5364_/D VGND VGND VPWR VPWR _5364_/Q sky130_fd_sc_hd__dfxtp_1
XANTENNA__4878__A1 _4904_/A0 VGND VGND VPWR VPWR sky130_fd_sc_hd__diode_2
XFILLER_126_29 VPWR VGND VPWR VGND sky130_ef_sc_hd__decap_40_12
XANTENNA__3550__A1 _3926_/A1 VGND VGND VPWR VPWR sky130_fd_sc_hd__diode_2
X_4315_ hold865/X _5047_/A1 _4315_/S VGND VGND VPWR VPWR _4315_/X sky130_fd_sc_hd__mux2_1
XFILLER_114_697 VGND VGND VPWR VPWR sky130_fd_sc_hd__fill_2
XFILLER_102_837 VGND VGND VPWR VPWR sky130_fd_sc_hd__fill_4
X_5295_ _6172_/CLK hold82/X VGND VGND VPWR VPWR hold81/A sky130_fd_sc_hd__dfxtp_1
X_4246_ _4245_/X _4239_/X _4260_/S VGND VGND VPWR VPWR _4246_/X sky130_fd_sc_hd__mux2_1
XANTENNA__3302__A1 _5075_/A0 VGND VGND VPWR VPWR sky130_fd_sc_hd__diode_2
XFILLER_68_773 VPWR VGND VPWR VGND sky130_ef_sc_hd__decap_40_12
X_4177_ _5783_/Q _5911_/Q _4250_/S VGND VGND VPWR VPWR _4178_/B sky130_fd_sc_hd__mux2_1
X_3128_ _3128_/A _3128_/B _4451_/A VGND VGND VPWR VPWR _3402_/B sky130_fd_sc_hd__and3_2
X_3059_ _3029_/A _3056_/X _3089_/C1 VGND VGND VPWR VPWR _3059_/X sky130_fd_sc_hd__o21a_1
XANTENNA_fanout164_X _4178_/A VGND VGND VPWR VPWR sky130_fd_sc_hd__diode_2
XFILLER_23_331 VGND VGND VPWR VPWR sky130_fd_sc_hd__fill_4
XANTENNA__4566__B1 _4791_/B1 VGND VGND VPWR VPWR sky130_fd_sc_hd__diode_2
XFILLER_51_695 VGND VGND VPWR VPWR sky130_fd_sc_hd__fill_1
XFILLER_11_559 VGND VGND VPWR VPWR sky130_fd_sc_hd__fill_1
XFILLER_136_222 VGND VGND VPWR VPWR sky130_fd_sc_hd__fill_1
XANTENNA__4949__S _4954_/S VGND VGND VPWR VPWR sky130_fd_sc_hd__diode_2
XFILLER_124_428 VGND VGND VPWR VPWR sky130_fd_sc_hd__fill_1
XANTENNA__4869__A1 _4882_/A1 VGND VGND VPWR VPWR sky130_fd_sc_hd__diode_2
XFILLER_3_725 VGND VGND VPWR VPWR sky130_fd_sc_hd__fill_2
XFILLER_105_653 VPWR VGND VPWR VGND sky130_ef_sc_hd__decap_40_12
XANTENNA__3425__Y _3437_/S VGND VGND VPWR VPWR sky130_fd_sc_hd__diode_2
XANTENNA__3541__A1 _5237_/A0 VGND VGND VPWR VPWR sky130_fd_sc_hd__diode_2
XTAP_TAPCELL_ROW_57_1161 VGND VPWR sky130_fd_sc_hd__tapvpwrvgnd_1
XTAP_TAPCELL_ROW_57_1150 VGND VPWR sky130_fd_sc_hd__tapvpwrvgnd_1
XFILLER_2_235 VGND VGND VPWR VPWR sky130_fd_sc_hd__fill_1
XFILLER_120_601 VPWR VGND VPWR VGND sky130_ef_sc_hd__decap_40_12
XFILLER_105_697 VPWR VGND VPWR VGND sky130_ef_sc_hd__decap_40_12
XFILLER_104_141 VGND VGND VPWR VPWR sky130_fd_sc_hd__fill_1
XFILLER_120_645 VPWR VGND VPWR VGND sky130_ef_sc_hd__decap_40_12
XTAP_TAPCELL_ROW_70_1350 VGND VPWR sky130_fd_sc_hd__tapvpwrvgnd_1
XANTENNA_fanout77_X _5215_/A1 VGND VGND VPWR VPWR sky130_fd_sc_hd__diode_2
XFILLER_93_507 VGND VGND VPWR VPWR sky130_fd_sc_hd__fill_1
XFILLER_65_209 VGND VGND VPWR VPWR sky130_fd_sc_hd__fill_1
XANTENNA__4684__S _4778_/S VGND VGND VPWR VPWR sky130_fd_sc_hd__diode_2
XFILLER_19_615 VGND VGND VPWR VPWR sky130_fd_sc_hd__fill_1
XFILLER_74_710 VGND VGND VPWR VPWR sky130_fd_sc_hd__fill_1
XFILLER_18_125 VGND VGND VPWR VPWR sky130_fd_sc_hd__fill_4
XANTENNA__5046__A1 _5046_/A1 VGND VGND VPWR VPWR sky130_fd_sc_hd__diode_2
XFILLER_15_821 VPWR VGND VPWR VGND sky130_ef_sc_hd__decap_40_12
XANTENNA__2932__S _3077_/S VGND VGND VPWR VPWR sky130_fd_sc_hd__diode_2
XFILLER_30_813 VPWR VGND VPWR VGND sky130_ef_sc_hd__decap_40_12
XFILLER_128_701 VPWR VGND VPWR VGND sky130_ef_sc_hd__decap_40_12
XFILLER_10_581 VGND VGND VPWR VPWR sky130_fd_sc_hd__fill_4
XTAP_TAPCELL_ROW_40_896 VGND VPWR sky130_fd_sc_hd__tapvpwrvgnd_1
XANTENNA__4859__S _4867_/S VGND VGND VPWR VPWR sky130_fd_sc_hd__diode_2
XANTENNA__3780__A1 _5209_/A1 VGND VGND VPWR VPWR sky130_fd_sc_hd__diode_2
XFILLER_6_585 VGND VGND VPWR VPWR sky130_fd_sc_hd__fill_2
XANTENNA__3763__S _3766_/S VGND VGND VPWR VPWR sky130_fd_sc_hd__diode_2
XANTENNA__3532__A1 _5228_/A0 VGND VGND VPWR VPWR sky130_fd_sc_hd__diode_2
X_5080_ _5080_/A0 _5080_/A1 _5081_/S VGND VGND VPWR VPWR _5080_/X sky130_fd_sc_hd__mux2_1
XFILLER_96_323 VGND VGND VPWR VPWR sky130_fd_sc_hd__fill_1
XFILLER_69_559 VGND VGND VPWR VPWR sky130_fd_sc_hd__fill_1
X_4100_ _4097_/X _4098_/X _4099_/X _4149_/A VGND VGND VPWR VPWR _4100_/X sky130_fd_sc_hd__a22o_1
Xhold1709 _5569_/Q VGND VGND VPWR VPWR _3526_/A1 sky130_fd_sc_hd__dlygate4sd3_1
XANTENNA__4594__S _4810_/S VGND VGND VPWR VPWR sky130_fd_sc_hd__diode_2
X_4031_ _4272_/S _4031_/B VGND VGND VPWR VPWR _4031_/Y sky130_fd_sc_hd__nand2_1
XFILLER_1_290 VGND VGND VPWR VPWR sky130_fd_sc_hd__fill_2
XFILLER_2_41 VPWR VGND VPWR VGND sky130_ef_sc_hd__decap_40_12
XTAP_TAPCELL_ROW_88_1622 VGND VPWR sky130_fd_sc_hd__tapvpwrvgnd_1
XFILLER_2_85 VGND VGND VPWR VPWR sky130_fd_sc_hd__fill_8
XFILLER_65_765 VPWR VGND VPWR VGND sky130_ef_sc_hd__decap_40_12
XFILLER_52_404 VGND VGND VPWR VPWR sky130_fd_sc_hd__fill_4
X_5982_ _6334_/CLK _5982_/D VGND VGND VPWR VPWR _5982_/Q sky130_fd_sc_hd__dfxtp_1
XFILLER_18_681 VPWR VGND VPWR VGND sky130_ef_sc_hd__decap_40_12
XANTENNA__4796__B1 _2628_/A VGND VGND VPWR VPWR sky130_fd_sc_hd__diode_2
XFILLER_80_757 VGND VGND VPWR VPWR sky130_fd_sc_hd__fill_1
XANTENNA__3599__A1 _5210_/A1 VGND VGND VPWR VPWR sky130_fd_sc_hd__diode_2
XFILLER_52_459 VGND VGND VPWR VPWR sky130_fd_sc_hd__fill_2
X_4933_ _4933_/A0 _4983_/A1 _4934_/S VGND VGND VPWR VPWR _4933_/X sky130_fd_sc_hd__mux2_1
XANTENNA__2842__S _3091_/S VGND VGND VPWR VPWR sky130_fd_sc_hd__diode_2
X_4864_ _4903_/A0 _4864_/A1 _4867_/S VGND VGND VPWR VPWR _4864_/X sky130_fd_sc_hd__mux2_1
XFILLER_20_312 VGND VGND VPWR VPWR sky130_fd_sc_hd__fill_1
X_4795_ _5851_/Q _5629_/Q _4795_/S VGND VGND VPWR VPWR _4795_/X sky130_fd_sc_hd__mux2_1
X_3815_ _4910_/A _4846_/A0 _3818_/S VGND VGND VPWR VPWR _5818_/D sky130_fd_sc_hd__mux2_1
XTAP_TAPCELL_ROW_115_2018 VGND VPWR sky130_fd_sc_hd__tapvpwrvgnd_1
XANTENNA__3220__A0 _5237_/A0 VGND VGND VPWR VPWR sky130_fd_sc_hd__diode_2
XFILLER_20_389 VPWR VGND VPWR VGND sky130_ef_sc_hd__decap_40_12
X_3746_ _4935_/A _3767_/B VGND VGND VPWR VPWR _3755_/S sky130_fd_sc_hd__or2_4
XTAP_TAPCELL_ROW_115_2029 VGND VPWR sky130_fd_sc_hd__tapvpwrvgnd_1
XTAP_TAPCELL_ROW_99_1784 VGND VPWR sky130_fd_sc_hd__tapvpwrvgnd_1
XFILLER_137_39 VPWR VGND VPWR VGND sky130_ef_sc_hd__decap_40_12
XFILLER_134_737 VPWR VGND VPWR VGND sky130_ef_sc_hd__decap_40_12
X_5416_ _5583_/CLK _5416_/D VGND VGND VPWR VPWR _5416_/Q sky130_fd_sc_hd__dfxtp_1
X_3677_ _4521_/A1 _3677_/A1 _3678_/S VGND VGND VPWR VPWR _3677_/X sky130_fd_sc_hd__mux2_1
X_6396_ _6398_/CLK _6396_/D VGND VGND VPWR VPWR _6396_/Q sky130_fd_sc_hd__dfxtp_1
X_2628_ _2628_/A VGND VGND VPWR VPWR _2628_/Y sky130_fd_sc_hd__inv_2
X_5347_ _6369_/CLK _5347_/D VGND VGND VPWR VPWR _5347_/Q sky130_fd_sc_hd__dfxtp_1
XFILLER_102_601 VPWR VGND VPWR VGND sky130_ef_sc_hd__decap_40_12
XFILLER_88_813 VPWR VGND VPWR VGND sky130_ef_sc_hd__decap_40_12
XTAP_TAPCELL_ROW_110_1951 VGND VPWR sky130_fd_sc_hd__tapvpwrvgnd_1
XFILLER_102_645 VPWR VGND VPWR VGND sky130_ef_sc_hd__decap_40_12
XFILLER_101_111 VGND VGND VPWR VPWR sky130_fd_sc_hd__fill_1
XFILLER_87_345 VGND VGND VPWR VPWR sky130_fd_sc_hd__fill_1
X_5278_ _6137_/CLK _5278_/D VGND VGND VPWR VPWR _5278_/Q sky130_fd_sc_hd__dfxtp_1
XANTENNA__6058__Q _6058_/Q VGND VGND VPWR VPWR sky130_fd_sc_hd__diode_2
X_4229_ _4264_/A1 _4228_/X _4205_/A VGND VGND VPWR VPWR _4229_/X sky130_fd_sc_hd__o21a_1
XTAP_TAPCELL_ROW_52_1080 VGND VPWR sky130_fd_sc_hd__tapvpwrvgnd_1
XFILLER_56_765 VPWR VGND VPWR VGND sky130_ef_sc_hd__decap_40_12
XFILLER_56_754 VGND VGND VPWR VPWR sky130_fd_sc_hd__fill_2
XFILLER_55_242 VGND VGND VPWR VPWR sky130_fd_sc_hd__fill_1
XFILLER_28_445 VGND VGND VPWR VPWR sky130_fd_sc_hd__fill_4
XFILLER_71_724 VGND VGND VPWR VPWR sky130_fd_sc_hd__fill_4
XFILLER_12_813 VPWR VGND VPWR VGND sky130_ef_sc_hd__decap_40_12
XFILLER_134_3 VPWR VGND VPWR VGND sky130_ef_sc_hd__decap_40_12
XFILLER_11_334 VGND VGND VPWR VPWR sky130_fd_sc_hd__fill_2
XANTENNA__3211__A0 _5228_/A0 VGND VGND VPWR VPWR sky130_fd_sc_hd__diode_2
XFILLER_137_553 VGND VGND VPWR VPWR sky130_fd_sc_hd__fill_4
XANTENNA__4679__S _4773_/S VGND VGND VPWR VPWR sky130_fd_sc_hd__diode_2
XFILLER_7_349 VPWR VGND VPWR VGND sky130_ef_sc_hd__decap_40_12
XANTENNA__3762__A1 _4980_/A1 VGND VGND VPWR VPWR sky130_fd_sc_hd__diode_2
XFILLER_137_597 VPWR VGND VPWR VGND sky130_ef_sc_hd__decap_40_12
XFILLER_124_203 VGND VGND VPWR VPWR sky130_fd_sc_hd__fill_1
XFILLER_11_72 VGND VGND VPWR VPWR sky130_fd_sc_hd__fill_2
XFILLER_133_781 VGND VGND VPWR VPWR sky130_fd_sc_hd__fill_2
XFILLER_132_280 VGND VGND VPWR VPWR sky130_fd_sc_hd__fill_1
XANTENNA__2927__S _2984_/S VGND VGND VPWR VPWR sky130_fd_sc_hd__diode_2
XFILLER_94_805 VGND VGND VPWR VPWR sky130_fd_sc_hd__fill_4
XTAP_TAPCELL_ROW_6_393 VGND VPWR sky130_fd_sc_hd__tapvpwrvgnd_1
XANTENNA__4427__B _4427_/B VGND VGND VPWR VPWR sky130_fd_sc_hd__diode_2
XFILLER_19_445 VGND VGND VPWR VPWR sky130_fd_sc_hd__fill_2
XFILLER_46_253 VGND VGND VPWR VPWR sky130_fd_sc_hd__fill_2
XTAP_TAPCELL_ROW_83_1552 VGND VPWR sky130_fd_sc_hd__tapvpwrvgnd_1
XTAP_TAPCELL_ROW_83_1541 VGND VPWR sky130_fd_sc_hd__tapvpwrvgnd_1
XTAP_TAPCELL_ROW_45_977 VGND VPWR sky130_fd_sc_hd__tapvpwrvgnd_1
XANTENNA__3758__S _3766_/S VGND VGND VPWR VPWR sky130_fd_sc_hd__diode_2
XFILLER_15_673 VPWR VGND VPWR VGND sky130_ef_sc_hd__decap_40_12
XFILLER_30_643 VGND VGND VPWR VPWR sky130_fd_sc_hd__fill_1
XFILLER_128_531 VGND VGND VPWR VPWR sky130_fd_sc_hd__fill_1
X_3600_ _4648_/A2 _5211_/A1 _3605_/S VGND VGND VPWR VPWR _3600_/X sky130_fd_sc_hd__mux2_1
Xinput22 s_axil_wdata[4] VGND VGND VPWR VPWR input22/X sky130_fd_sc_hd__buf_1
Xinput11 s_axil_rready VGND VGND VPWR VPWR _2655_/A sky130_fd_sc_hd__clkbuf_1
XFILLER_30_698 VGND VGND VPWR VPWR sky130_fd_sc_hd__fill_2
X_4580_ hold643/X _4580_/A1 _4801_/S VGND VGND VPWR VPWR _4580_/X sky130_fd_sc_hd__mux2_1
XANTENNA_hold2089_A _6413_/Q VGND VGND VPWR VPWR sky130_fd_sc_hd__diode_2
X_3531_ _3531_/A0 _4883_/A1 _3541_/S VGND VGND VPWR VPWR _3531_/X sky130_fd_sc_hd__mux2_1
XANTENNA__4950__A0 _4980_/A1 VGND VGND VPWR VPWR sky130_fd_sc_hd__diode_2
XANTENNA__3493__S _3503_/S VGND VGND VPWR VPWR sky130_fd_sc_hd__diode_2
XFILLER_116_737 VPWR VGND VPWR VGND sky130_ef_sc_hd__decap_40_12
Xhold806 _4352_/X VGND VGND VPWR VPWR _5995_/D sky130_fd_sc_hd__dlygate4sd3_1
Xhold817 _5997_/Q VGND VGND VPWR VPWR hold817/X sky130_fd_sc_hd__dlygate4sd3_1
Xhold828 _4934_/X VGND VGND VPWR VPWR _6271_/D sky130_fd_sc_hd__dlygate4sd3_1
X_3462_ _3462_/A0 _4905_/A0 _3463_/S VGND VGND VPWR VPWR _3462_/X sky130_fd_sc_hd__mux2_1
X_6250_ _6435_/CLK _6250_/D VGND VGND VPWR VPWR _6250_/Q sky130_fd_sc_hd__dfxtp_1
Xhold839 _6265_/Q VGND VGND VPWR VPWR hold839/X sky130_fd_sc_hd__dlygate4sd3_1
XFILLER_131_729 VPWR VGND VPWR VGND sky130_ef_sc_hd__decap_40_12
XFILLER_124_781 VPWR VGND VPWR VGND sky130_ef_sc_hd__decap_40_12
X_6181_ _6241_/CLK _6181_/D VGND VGND VPWR VPWR _6181_/Q sky130_fd_sc_hd__dfxtp_1
XANTENNA__2939__S0 _2963_/S VGND VGND VPWR VPWR sky130_fd_sc_hd__diode_2
XFILLER_88_109 VGND VGND VPWR VPWR sky130_fd_sc_hd__fill_8
X_5201_ _5201_/A _5201_/B _5201_/C VGND VGND VPWR VPWR _5215_/S sky130_fd_sc_hd__nand3_4
X_3393_ hold712/X _4976_/A1 _3401_/S VGND VGND VPWR VPWR _3393_/X sky130_fd_sc_hd__mux2_1
X_5132_ _5835_/Q _5834_/Q _5194_/S VGND VGND VPWR VPWR _5132_/X sky130_fd_sc_hd__mux2_1
Xhold2218 _5832_/Q VGND VGND VPWR VPWR hold2218/X sky130_fd_sc_hd__dlygate4sd3_1
Xhold2207 _5382_/Q VGND VGND VPWR VPWR _3236_/A sky130_fd_sc_hd__dlygate4sd3_1
XFILLER_111_442 VGND VGND VPWR VPWR sky130_fd_sc_hd__fill_1
XFILLER_97_665 VGND VGND VPWR VPWR sky130_fd_sc_hd__fill_4
Xhold1517 _5550_/Q VGND VGND VPWR VPWR _3506_/A1 sky130_fd_sc_hd__dlygate4sd3_1
Xhold1506 _5855_/Q VGND VGND VPWR VPWR _3874_/A1 sky130_fd_sc_hd__dlygate4sd3_1
Xhold2229 _5339_/Q VGND VGND VPWR VPWR hold2229/X sky130_fd_sc_hd__dlygate4sd3_1
XFILLER_96_197 VGND VGND VPWR VPWR sky130_fd_sc_hd__fill_4
X_5063_ _5333_/Q _3320_/B _5207_/S VGND VGND VPWR VPWR _5063_/X sky130_fd_sc_hd__mux2_1
Xhold1528 _3568_/X VGND VGND VPWR VPWR _5605_/D sky130_fd_sc_hd__dlygate4sd3_1
Xhold1539 _5738_/Q VGND VGND VPWR VPWR _3720_/A0 sky130_fd_sc_hd__dlygate4sd3_1
X_4014_ _5117_/B _4014_/B VGND VGND VPWR VPWR _5218_/A sky130_fd_sc_hd__nor2_1
XTAP_TAPCELL_ROW_125_2180 VGND VPWR sky130_fd_sc_hd__tapvpwrvgnd_1
XFILLER_53_735 VGND VGND VPWR VPWR sky130_fd_sc_hd__fill_1
XANTENNA__4769__B1 _4811_/C1 VGND VGND VPWR VPWR sky130_fd_sc_hd__diode_2
XFILLER_37_297 VGND VGND VPWR VPWR sky130_fd_sc_hd__fill_1
XFILLER_52_267 VGND VGND VPWR VPWR sky130_fd_sc_hd__fill_1
XFILLER_12_109 VGND VGND VPWR VPWR sky130_fd_sc_hd__fill_4
XFILLER_25_459 VGND VGND VPWR VPWR sky130_fd_sc_hd__fill_1
X_5965_ _5990_/CLK _5965_/D VGND VGND VPWR VPWR _5965_/Q sky130_fd_sc_hd__dfxtp_1
XFILLER_40_407 VGND VGND VPWR VPWR sky130_fd_sc_hd__fill_1
XFILLER_40_418 VGND VGND VPWR VPWR sky130_fd_sc_hd__fill_2
XFILLER_80_587 VGND VGND VPWR VPWR sky130_fd_sc_hd__fill_1
X_4916_ _4916_/A _4922_/B _4922_/C VGND VGND VPWR VPWR _4916_/X sky130_fd_sc_hd__or3_1
XFILLER_21_621 VPWR VGND VPWR VGND sky130_ef_sc_hd__decap_40_12
XTAP_TAPCELL_ROW_23_638 VGND VPWR sky130_fd_sc_hd__tapvpwrvgnd_1
X_5896_ _6114_/CLK _5896_/D VGND VGND VPWR VPWR _5896_/Q sky130_fd_sc_hd__dfxtp_1
X_4847_ _4899_/A0 _4847_/A1 _4854_/S VGND VGND VPWR VPWR _4847_/X sky130_fd_sc_hd__mux2_1
XTAP_TAPCELL_ROW_23_649 VGND VPWR sky130_fd_sc_hd__tapvpwrvgnd_1
XFILLER_32_27 VGND VGND VPWR VPWR sky130_fd_sc_hd__fill_1
XANTENNA__5194__A0 _6262_/Q VGND VGND VPWR VPWR sky130_fd_sc_hd__diode_2
XANTENNA__3744__A1 _5080_/A0 VGND VGND VPWR VPWR sky130_fd_sc_hd__diode_2
XANTENNA_fanout127_X _4904_/A0 VGND VGND VPWR VPWR sky130_fd_sc_hd__diode_2
X_4778_ _5868_/Q _5859_/Q _4778_/S VGND VGND VPWR VPWR _4779_/B sky130_fd_sc_hd__mux2_1
XFILLER_5_809 VPWR VGND VPWR VGND sky130_ef_sc_hd__decap_40_12
XANTENNA__4941__A0 _4981_/A1 VGND VGND VPWR VPWR sky130_fd_sc_hd__diode_2
XFILLER_134_501 VPWR VGND VPWR VGND sky130_ef_sc_hd__decap_40_12
XFILLER_119_597 VPWR VGND VPWR VGND sky130_ef_sc_hd__decap_40_12
X_3729_ _3800_/A2 input9/X _3729_/C VGND VGND VPWR VPWR _3811_/B sky130_fd_sc_hd__and3b_1
XFILLER_4_319 VPWR VGND VPWR VGND sky130_ef_sc_hd__decap_40_12
XFILLER_134_545 VPWR VGND VPWR VGND sky130_ef_sc_hd__decap_40_12
XFILLER_134_589 VPWR VGND VPWR VGND sky130_ef_sc_hd__decap_40_12
X_6379_ _6382_/CLK _6379_/D VGND VGND VPWR VPWR _6379_/Q sky130_fd_sc_hd__dfxtp_1
XFILLER_0_503 VGND VGND VPWR VPWR sky130_fd_sc_hd__fill_1
XFILLER_115_781 VGND VGND VPWR VPWR sky130_fd_sc_hd__fill_2
XFILLER_88_643 VGND VGND VPWR VPWR sky130_fd_sc_hd__fill_1
XFILLER_88_676 VGND VGND VPWR VPWR sky130_fd_sc_hd__fill_4
XTAP_TAPCELL_ROW_3_352 VGND VPWR sky130_fd_sc_hd__tapvpwrvgnd_1
XTAP_TAPCELL_ROW_3_341 VGND VPWR sky130_fd_sc_hd__tapvpwrvgnd_1
XFILLER_90_307 VGND VGND VPWR VPWR sky130_fd_sc_hd__fill_1
XANTENNA__3680__A0 _4484_/A0 VGND VGND VPWR VPWR sky130_fd_sc_hd__diode_2
XFILLER_113_74 VGND VGND VPWR VPWR sky130_fd_sc_hd__fill_1
XFILLER_44_757 VPWR VGND VPWR VGND sky130_ef_sc_hd__decap_40_12
XANTENNA__4209__C1 _4271_/S1 VGND VGND VPWR VPWR sky130_fd_sc_hd__diode_2
XFILLER_71_565 VGND VGND VPWR VPWR sky130_fd_sc_hd__fill_2
XFILLER_43_245 VGND VGND VPWR VPWR sky130_fd_sc_hd__fill_1
XPHY_EDGE_ROW_125_Right_125 VGND VGND VPWR VPWR sky130_fd_sc_hd__decap_3
XTAP_TAPCELL_ROW_65_1282 VGND VPWR sky130_fd_sc_hd__tapvpwrvgnd_1
XTAP_TAPCELL_ROW_65_1271 VGND VPWR sky130_fd_sc_hd__tapvpwrvgnd_1
XTAP_TAPCELL_ROW_42_936 VGND VPWR sky130_fd_sc_hd__tapvpwrvgnd_1
XTAP_TAPCELL_ROW_42_925 VGND VPWR sky130_fd_sc_hd__tapvpwrvgnd_1
XANTENNA__4263__A _4263_/A VGND VGND VPWR VPWR sky130_fd_sc_hd__diode_2
XFILLER_12_643 VGND VGND VPWR VPWR sky130_fd_sc_hd__fill_1
XFILLER_8_625 VPWR VGND VPWR VGND sky130_ef_sc_hd__decap_40_12
XANTENNA__3735__A1 _4883_/A1 VGND VGND VPWR VPWR sky130_fd_sc_hd__diode_2
XFILLER_8_669 VPWR VGND VPWR VGND sky130_ef_sc_hd__decap_40_12
XFILLER_7_157 VGND VGND VPWR VPWR sky130_fd_sc_hd__fill_1
XFILLER_138_93 VGND VGND VPWR VPWR sky130_fd_sc_hd__fill_2
Xclkbuf_leaf_100_clk clkload0/A VGND VGND VPWR VPWR _6300_/CLK sky130_fd_sc_hd__clkbuf_8
XANTENNA__3499__A0 _4889_/A1 VGND VGND VPWR VPWR sky130_fd_sc_hd__diode_2
XFILLER_113_729 VPWR VGND VPWR VGND sky130_ef_sc_hd__decap_40_12
XFILLER_106_781 VPWR VGND VPWR VGND sky130_ef_sc_hd__decap_40_12
XFILLER_78_120 VGND VGND VPWR VPWR sky130_fd_sc_hd__fill_4
XFILLER_3_385 VGND VGND VPWR VPWR sky130_fd_sc_hd__fill_4
XFILLER_94_613 VPWR VGND VPWR VGND sky130_ef_sc_hd__decap_40_12
XANTENNA__3342__A _5085_/A VGND VGND VPWR VPWR sky130_fd_sc_hd__diode_2
XFILLER_94_657 VPWR VGND VPWR VGND sky130_ef_sc_hd__decap_40_12
XFILLER_82_808 VGND VGND VPWR VPWR sky130_fd_sc_hd__fill_4
XANTENNA__4872__S _4880_/S VGND VGND VPWR VPWR sky130_fd_sc_hd__diode_2
XFILLER_47_551 VGND VGND VPWR VPWR sky130_fd_sc_hd__fill_8
XFILLER_47_90 VGND VGND VPWR VPWR sky130_fd_sc_hd__fill_1
XFILLER_35_713 VGND VGND VPWR VPWR sky130_fd_sc_hd__fill_4
XFILLER_90_841 VGND VGND VPWR VPWR sky130_fd_sc_hd__fill_1
XANTENNA__3671__A0 _5209_/A1 VGND VGND VPWR VPWR sky130_fd_sc_hd__diode_2
XANTENNA__3488__S _3490_/S VGND VGND VPWR VPWR sky130_fd_sc_hd__diode_2
XFILLER_62_576 VGND VGND VPWR VPWR sky130_fd_sc_hd__fill_1
XFILLER_35_779 VGND VGND VPWR VPWR sky130_fd_sc_hd__fill_4
X_5750_ _6129_/CLK _5750_/D VGND VGND VPWR VPWR _5750_/Q sky130_fd_sc_hd__dfxtp_1
XFILLER_97_3 VPWR VGND VPWR VGND sky130_ef_sc_hd__decap_40_12
X_2962_ _2962_/A _2962_/B VGND VGND VPWR VPWR _2962_/X sky130_fd_sc_hd__or2_1
X_5681_ _5681_/CLK _5681_/D VGND VGND VPWR VPWR _5681_/Q sky130_fd_sc_hd__dfxtp_1
X_4701_ _4700_/X _4694_/X _4813_/S VGND VGND VPWR VPWR _4701_/X sky130_fd_sc_hd__mux2_1
XANTENNA__4460__X _4472_/S VGND VGND VPWR VPWR sky130_fd_sc_hd__diode_2
X_2893_ _6175_/Q _6199_/Q _6187_/Q _5481_/Q _3091_/S _3005_/A VGND VGND VPWR VPWR
+ _2893_/X sky130_fd_sc_hd__mux4_1
X_4632_ _6101_/Q _5890_/Q _6083_/Q _5881_/Q _4801_/S _4802_/A VGND VGND VPWR VPWR
+ _4633_/B sky130_fd_sc_hd__mux4_1
XANTENNA__3726__A1 _4982_/A1 VGND VGND VPWR VPWR sky130_fd_sc_hd__diode_2
XFILLER_128_361 VGND VGND VPWR VPWR sky130_fd_sc_hd__fill_2
XFILLER_116_501 VPWR VGND VPWR VGND sky130_ef_sc_hd__decap_40_12
XTAP_TAPCELL_ROW_96_1743 VGND VPWR sky130_fd_sc_hd__tapvpwrvgnd_1
X_4563_ hold948/X _4956_/A1 _4790_/S VGND VGND VPWR VPWR _4564_/B sky130_fd_sc_hd__mux2_1
Xhold603 _4378_/X VGND VGND VPWR VPWR _6018_/D sky130_fd_sc_hd__dlygate4sd3_1
XFILLER_116_545 VPWR VGND VPWR VGND sky130_ef_sc_hd__decap_40_12
XANTENNA__3517__A _5069_/B VGND VGND VPWR VPWR sky130_fd_sc_hd__diode_2
Xhold625 _5583_/Q VGND VGND VPWR VPWR hold625/X sky130_fd_sc_hd__dlygate4sd3_1
X_3514_ _5235_/A0 _3514_/A1 _3516_/S VGND VGND VPWR VPWR _3514_/X sky130_fd_sc_hd__mux2_1
X_6302_ _6302_/CLK _6302_/D VGND VGND VPWR VPWR _6302_/Q sky130_fd_sc_hd__dfxtp_1
Xhold636 _3710_/X VGND VGND VPWR VPWR _5730_/D sky130_fd_sc_hd__dlygate4sd3_1
Xhold614 _6088_/Q VGND VGND VPWR VPWR hold614/X sky130_fd_sc_hd__dlygate4sd3_1
X_4494_ hold932/X _5208_/A1 _4502_/S VGND VGND VPWR VPWR _4494_/X sky130_fd_sc_hd__mux2_1
Xhold669 _5359_/Q VGND VGND VPWR VPWR hold669/X sky130_fd_sc_hd__dlygate4sd3_1
XFILLER_116_589 VPWR VGND VPWR VGND sky130_ef_sc_hd__decap_40_12
X_6233_ _6233_/CLK _6233_/D VGND VGND VPWR VPWR _6233_/Q sky130_fd_sc_hd__dfxtp_1
XFILLER_89_429 VGND VGND VPWR VPWR sky130_fd_sc_hd__fill_1
X_3445_ hold467/X _5232_/A0 _3450_/S VGND VGND VPWR VPWR _3445_/X sky130_fd_sc_hd__mux2_1
Xhold658 _5053_/X VGND VGND VPWR VPWR _6346_/D sky130_fd_sc_hd__dlygate4sd3_1
Xhold647 _6347_/Q VGND VGND VPWR VPWR hold647/X sky130_fd_sc_hd__dlygate4sd3_1
XFILLER_134_29 VPWR VGND VPWR VGND sky130_ef_sc_hd__decap_40_12
XFILLER_131_559 VGND VGND VPWR VPWR sky130_fd_sc_hd__fill_1
Xhold2015 _5255_/Q VGND VGND VPWR VPWR _2663_/B sky130_fd_sc_hd__dlygate4sd3_1
Xhold2004 _6354_/Q VGND VGND VPWR VPWR _3318_/B sky130_fd_sc_hd__dlygate4sd3_1
X_3376_ _5838_/Q input5/X input4/X VGND VGND VPWR VPWR _3376_/X sky130_fd_sc_hd__and3_2
X_6164_ _6292_/CLK _6164_/D VGND VGND VPWR VPWR _6164_/Q sky130_fd_sc_hd__dfxtp_1
Xhold2026 _3250_/X VGND VGND VPWR VPWR _5386_/D sky130_fd_sc_hd__dlygate4sd3_1
Xhold1303 _5609_/Q VGND VGND VPWR VPWR _3572_/A0 sky130_fd_sc_hd__dlygate4sd3_1
X_6095_ _6095_/CLK _6095_/D VGND VGND VPWR VPWR _6095_/Q sky130_fd_sc_hd__dfxtp_1
X_5115_ _3975_/A _5099_/B _5113_/X _5114_/X _3237_/A VGND VGND VPWR VPWR _5115_/X
+ sky130_fd_sc_hd__o221a_1
XFILLER_57_326 VGND VGND VPWR VPWR sky130_fd_sc_hd__fill_8
Xhold1314 _6384_/Q VGND VGND VPWR VPWR _5206_/A1 sky130_fd_sc_hd__dlygate4sd3_1
Xhold1325 _5698_/Q VGND VGND VPWR VPWR _3675_/A1 sky130_fd_sc_hd__dlygate4sd3_1
Xhold2037 _3179_/X VGND VGND VPWR VPWR _5344_/D sky130_fd_sc_hd__dlygate4sd3_1
Xhold2048 _3355_/X VGND VGND VPWR VPWR _5431_/D sky130_fd_sc_hd__dlygate4sd3_1
Xhold2059 _3363_/X VGND VGND VPWR VPWR _5435_/D sky130_fd_sc_hd__dlygate4sd3_1
Xhold1347 _3896_/X VGND VGND VPWR VPWR _5875_/D sky130_fd_sc_hd__dlygate4sd3_1
Xhold1336 _6097_/Q VGND VGND VPWR VPWR _4491_/A1 sky130_fd_sc_hd__dlygate4sd3_1
XFILLER_57_337 VGND VGND VPWR VPWR sky130_fd_sc_hd__fill_4
X_5046_ hold489/X _5046_/A1 _5047_/S VGND VGND VPWR VPWR _5046_/X sky130_fd_sc_hd__mux2_1
Xhold1358 _4291_/X VGND VGND VPWR VPWR _5942_/D sky130_fd_sc_hd__dlygate4sd3_1
Xhold1369 _6171_/Q VGND VGND VPWR VPWR _4817_/A1 sky130_fd_sc_hd__dlygate4sd3_1
XANTENNA__4454__A2 _3366_/X VGND VGND VPWR VPWR sky130_fd_sc_hd__diode_2
XTAP_TAPCELL_ROW_0_300 VGND VPWR sky130_fd_sc_hd__tapvpwrvgnd_1
XTAP_TAPCELL_ROW_28_719 VGND VPWR sky130_fd_sc_hd__tapvpwrvgnd_1
XTAP_TAPCELL_ROW_123_2139 VGND VPWR sky130_fd_sc_hd__tapvpwrvgnd_1
XANTENNA__3662__A0 _4517_/A1 VGND VGND VPWR VPWR sky130_fd_sc_hd__diode_2
XFILLER_81_841 VGND VGND VPWR VPWR sky130_fd_sc_hd__fill_1
XFILLER_26_757 VPWR VGND VPWR VGND sky130_ef_sc_hd__decap_40_12
XTAP_TAPCELL_ROW_105_1872 VGND VPWR sky130_fd_sc_hd__tapvpwrvgnd_1
XFILLER_80_373 VGND VGND VPWR VPWR sky130_fd_sc_hd__fill_4
XFILLER_53_598 VGND VGND VPWR VPWR sky130_fd_sc_hd__fill_1
X_5948_ _6341_/CLK _5948_/D VGND VGND VPWR VPWR _5948_/Q sky130_fd_sc_hd__dfxtp_1
XFILLER_13_429 VPWR VGND VPWR VGND sky130_ef_sc_hd__decap_40_12
XFILLER_21_473 VPWR VGND VPWR VGND sky130_ef_sc_hd__decap_40_12
X_5879_ _6417_/CLK _5879_/D VGND VGND VPWR VPWR _5879_/Q sky130_fd_sc_hd__dfxtp_1
XTAP_TAPCELL_ROW_138_2382 VGND VPWR sky130_fd_sc_hd__tapvpwrvgnd_1
XTAP_TAPCELL_ROW_138_2371 VGND VPWR sky130_fd_sc_hd__tapvpwrvgnd_1
XFILLER_138_169 VPWR VGND VPWR VGND sky130_ef_sc_hd__decap_40_12
XFILLER_135_821 VPWR VGND VPWR VGND sky130_ef_sc_hd__decap_40_12
XFILLER_5_617 VPWR VGND VPWR VGND sky130_ef_sc_hd__decap_40_12
XANTENNA__3717__A1 _4984_/A1 VGND VGND VPWR VPWR sky130_fd_sc_hd__diode_2
XANTENNA__4022__S _4213_/S VGND VGND VPWR VPWR sky130_fd_sc_hd__diode_2
XFILLER_108_41 VGND VGND VPWR VPWR sky130_fd_sc_hd__fill_2
XFILLER_108_85 VGND VGND VPWR VPWR sky130_fd_sc_hd__fill_4
XANTENNA__3861__S _3869_/S VGND VGND VPWR VPWR sky130_fd_sc_hd__diode_2
XTAP_TAPCELL_ROW_8_422 VGND VPWR sky130_fd_sc_hd__tapvpwrvgnd_1
XFILLER_130_581 VGND VGND VPWR VPWR sky130_fd_sc_hd__fill_4
XFILLER_102_250 VGND VGND VPWR VPWR sky130_fd_sc_hd__fill_2
XFILLER_76_613 VGND VGND VPWR VPWR sky130_fd_sc_hd__fill_2
XFILLER_48_315 VGND VGND VPWR VPWR sky130_fd_sc_hd__fill_1
Xhold1870 _3527_/X VGND VGND VPWR VPWR _5570_/D sky130_fd_sc_hd__dlygate4sd3_1
XFILLER_124_95 VGND VGND VPWR VPWR sky130_fd_sc_hd__fill_1
XFILLER_84_55 VGND VGND VPWR VPWR sky130_fd_sc_hd__fill_1
XANTENNA_input17_A s_axil_wdata[14] VGND VGND VPWR VPWR sky130_fd_sc_hd__diode_2
XTAP_TAPCELL_ROW_67_1300 VGND VPWR sky130_fd_sc_hd__tapvpwrvgnd_1
Xhold1881 _5774_/Q VGND VGND VPWR VPWR _3763_/A0 sky130_fd_sc_hd__dlygate4sd3_1
Xhold1892 _5559_/Q VGND VGND VPWR VPWR _3515_/A1 sky130_fd_sc_hd__dlygate4sd3_1
XTAP_TAPCELL_ROW_67_1311 VGND VPWR sky130_fd_sc_hd__tapvpwrvgnd_1
XFILLER_17_82 VGND VGND VPWR VPWR sky130_fd_sc_hd__fill_2
XTAP_TAPCELL_ROW_80_1500 VGND VPWR sky130_fd_sc_hd__tapvpwrvgnd_1
XFILLER_44_587 VGND VGND VPWR VPWR sky130_fd_sc_hd__fill_1
XANTENNA__3405__A0 _5040_/A1 VGND VGND VPWR VPWR sky130_fd_sc_hd__diode_2
XFILLER_16_289 VGND VGND VPWR VPWR sky130_fd_sc_hd__fill_4
XFILLER_32_738 VPWR VGND VPWR VGND sky130_ef_sc_hd__decap_40_12
XANTENNA__5158__A0 _5840_/Q VGND VGND VPWR VPWR sky130_fd_sc_hd__diode_2
XFILLER_12_473 VGND VGND VPWR VPWR sky130_fd_sc_hd__fill_2
XFILLER_129_158 VGND VGND VPWR VPWR sky130_fd_sc_hd__fill_1
XFILLER_76_8 VGND VGND VPWR VPWR sky130_fd_sc_hd__fill_2
XFILLER_8_433 VPWR VGND VPWR VGND sky130_ef_sc_hd__decap_40_12
XANTENNA__4905__A0 _4905_/A0 VGND VGND VPWR VPWR sky130_fd_sc_hd__diode_2
XFILLER_8_477 VPWR VGND VPWR VGND sky130_ef_sc_hd__decap_40_12
XTAP_TAPCELL_ROW_78_1473 VGND VPWR sky130_fd_sc_hd__tapvpwrvgnd_1
XANTENNA__4381__A1 _4929_/A1 VGND VGND VPWR VPWR sky130_fd_sc_hd__diode_2
XFILLER_99_727 VGND VGND VPWR VPWR sky130_fd_sc_hd__fill_1
XANTENNA__4867__S _4867_/S VGND VGND VPWR VPWR sky130_fd_sc_hd__diode_2
XFILLER_113_559 VGND VGND VPWR VPWR sky130_fd_sc_hd__fill_1
XTAP_TAPCELL_ROW_91_1662 VGND VPWR sky130_fd_sc_hd__tapvpwrvgnd_1
X_3230_ _3231_/B VGND VGND VPWR VPWR _5216_/B sky130_fd_sc_hd__inv_2
X_3161_ _3162_/A _3161_/B VGND VGND VPWR VPWR _4218_/A sky130_fd_sc_hd__and2_4
XFILLER_67_646 VGND VGND VPWR VPWR sky130_fd_sc_hd__fill_2
XFILLER_67_657 VGND VGND VPWR VPWR sky130_fd_sc_hd__fill_2
XFILLER_66_123 VGND VGND VPWR VPWR sky130_fd_sc_hd__fill_1
XANTENNA_hold2219_A _5823_/Q VGND VGND VPWR VPWR sky130_fd_sc_hd__diode_2
XFILLER_12_3 VPWR VGND VPWR VGND sky130_ef_sc_hd__decap_40_12
XFILLER_39_359 VGND VGND VPWR VPWR sky130_fd_sc_hd__fill_1
X_3092_ _3092_/A hold51/X VGND VGND VPWR VPWR _3092_/X sky130_fd_sc_hd__and2_1
XANTENNA__4436__A2 _4445_/B VGND VGND VPWR VPWR sky130_fd_sc_hd__diode_2
XFILLER_67_679 VGND VGND VPWR VPWR sky130_fd_sc_hd__fill_4
XFILLER_63_841 VGND VGND VPWR VPWR sky130_fd_sc_hd__fill_1
XFILLER_62_340 VGND VGND VPWR VPWR sky130_fd_sc_hd__fill_2
XFILLER_35_554 VGND VGND VPWR VPWR sky130_fd_sc_hd__fill_4
XFILLER_90_693 VGND VGND VPWR VPWR sky130_fd_sc_hd__fill_4
X_5802_ _6120_/CLK _5802_/D VGND VGND VPWR VPWR _5802_/Q sky130_fd_sc_hd__dfxtp_1
XANTENNA__4107__S _4237_/S VGND VGND VPWR VPWR sky130_fd_sc_hd__diode_2
XFILLER_23_716 VGND VGND VPWR VPWR sky130_fd_sc_hd__fill_1
XFILLER_23_727 VGND VGND VPWR VPWR sky130_fd_sc_hd__fill_1
XFILLER_23_738 VPWR VGND VPWR VGND sky130_ef_sc_hd__decap_40_12
XFILLER_62_395 VGND VGND VPWR VPWR sky130_fd_sc_hd__fill_4
X_3994_ _5918_/Q _5917_/Q VGND VGND VPWR VPWR _5117_/B sky130_fd_sc_hd__and2b_1
XFILLER_50_535 VGND VGND VPWR VPWR sky130_fd_sc_hd__fill_8
XFILLER_22_237 VGND VGND VPWR VPWR sky130_fd_sc_hd__fill_1
X_2945_ _2940_/X _2944_/X _2995_/A VGND VGND VPWR VPWR _2945_/Y sky130_fd_sc_hd__o21ai_1
X_5733_ clkload8/A _5733_/D VGND VGND VPWR VPWR _5733_/Q sky130_fd_sc_hd__dfxtp_1
XTAP_TAPCELL_ROW_33_788 VGND VPWR sky130_fd_sc_hd__tapvpwrvgnd_1
X_2876_ _3050_/A _2876_/B VGND VGND VPWR VPWR _2876_/X sky130_fd_sc_hd__or2_1
X_5664_ _5682_/CLK _5664_/D VGND VGND VPWR VPWR _5664_/Q sky130_fd_sc_hd__dfxtp_1
XTAP_TAPCELL_ROW_33_799 VGND VPWR sky130_fd_sc_hd__tapvpwrvgnd_1
XFILLER_117_821 VPWR VGND VPWR VGND sky130_ef_sc_hd__decap_40_12
X_4615_ _4611_/X _4613_/X _4614_/X _4791_/B1 VGND VGND VPWR VPWR _4615_/X sky130_fd_sc_hd__a22o_1
X_5595_ _6297_/CLK _5595_/D VGND VGND VPWR VPWR _5595_/Q sky130_fd_sc_hd__dfxtp_1
XTAP_TAPCELL_ROW_13_490 VGND VPWR sky130_fd_sc_hd__tapvpwrvgnd_1
X_4546_ hold540/X _5080_/A0 _4547_/S VGND VGND VPWR VPWR _4546_/X sky130_fd_sc_hd__mux2_1
Xhold411 _6229_/Q VGND VGND VPWR VPWR hold411/X sky130_fd_sc_hd__dlygate4sd3_1
Xhold400 _3615_/X VGND VGND VPWR VPWR _5646_/D sky130_fd_sc_hd__dlygate4sd3_1
XFILLER_132_813 VPWR VGND VPWR VGND sky130_ef_sc_hd__decap_40_12
XTAP_TAPCELL_ROW_133_2290 VGND VPWR sky130_fd_sc_hd__tapvpwrvgnd_1
XANTENNA_fanout204_A _3237_/A VGND VGND VPWR VPWR sky130_fd_sc_hd__diode_2
Xhold444 _3610_/X VGND VGND VPWR VPWR _5641_/D sky130_fd_sc_hd__dlygate4sd3_1
Xhold422 _3921_/X VGND VGND VPWR VPWR _5898_/D sky130_fd_sc_hd__dlygate4sd3_1
Xhold433 _6116_/Q VGND VGND VPWR VPWR hold433/X sky130_fd_sc_hd__dlygate4sd3_1
Xhold477 _6132_/Q VGND VGND VPWR VPWR hold477/X sky130_fd_sc_hd__dlygate4sd3_1
Xhold455 _5290_/Q VGND VGND VPWR VPWR hold455/X sky130_fd_sc_hd__dlygate4sd3_1
X_4477_ hold726/X _5211_/A1 _4482_/S VGND VGND VPWR VPWR _4477_/X sky130_fd_sc_hd__mux2_1
Xhold466 _3904_/X VGND VGND VPWR VPWR _5883_/D sky130_fd_sc_hd__dlygate4sd3_1
Xhold488 _3482_/X VGND VGND VPWR VPWR _5528_/D sky130_fd_sc_hd__dlygate4sd3_1
X_3428_ hold649/X _4445_/A _3437_/S VGND VGND VPWR VPWR _3428_/X sky130_fd_sc_hd__mux2_1
X_6216_ _6241_/CLK _6216_/D VGND VGND VPWR VPWR _6216_/Q sky130_fd_sc_hd__dfxtp_1
Xhold499 _5422_/Q VGND VGND VPWR VPWR hold499/X sky130_fd_sc_hd__dlygate4sd3_1
X_6147_ _6366_/CLK _6147_/D VGND VGND VPWR VPWR _6147_/Q sky130_fd_sc_hd__dfxtp_1
XFILLER_98_793 VPWR VGND VPWR VGND sky130_ef_sc_hd__decap_40_12
Xhold1100 _5757_/Q VGND VGND VPWR VPWR _3743_/A0 sky130_fd_sc_hd__dlygate4sd3_1
XANTENNA_input9_A s_axil_awvalid VGND VGND VPWR VPWR sky130_fd_sc_hd__diode_2
X_3359_ _5212_/A0 _3358_/X _3365_/S VGND VGND VPWR VPWR _3359_/X sky130_fd_sc_hd__mux2_1
XFILLER_38_15 VGND VGND VPWR VPWR sky130_fd_sc_hd__fill_8
Xhold1122 _6079_/Q VGND VGND VPWR VPWR _4471_/A1 sky130_fd_sc_hd__dlygate4sd3_1
XFILLER_112_581 VGND VGND VPWR VPWR sky130_fd_sc_hd__fill_4
XANTENNA_fanout194_X _3016_/S VGND VGND VPWR VPWR sky130_fd_sc_hd__diode_2
XFILLER_97_281 VGND VGND VPWR VPWR sky130_fd_sc_hd__fill_4
Xhold1111 _3898_/X VGND VGND VPWR VPWR _5877_/D sky130_fd_sc_hd__dlygate4sd3_1
Xhold1133 _4189_/X VGND VGND VPWR VPWR _5924_/D sky130_fd_sc_hd__dlygate4sd3_1
X_6078_ _6428_/CLK _6078_/D VGND VGND VPWR VPWR _6078_/Q sky130_fd_sc_hd__dfxtp_1
Xhold1144 _6234_/Q VGND VGND VPWR VPWR _4885_/A0 sky130_fd_sc_hd__dlygate4sd3_1
XTAP_TAPCELL_ROW_107_1901 VGND VPWR sky130_fd_sc_hd__tapvpwrvgnd_1
Xhold1155 _4841_/X VGND VGND VPWR VPWR _6194_/D sky130_fd_sc_hd__dlygate4sd3_1
Xhold1166 _3717_/X VGND VGND VPWR VPWR _5737_/D sky130_fd_sc_hd__dlygate4sd3_1
Xhold1177 _6432_/Q VGND VGND VPWR VPWR _5235_/A1 sky130_fd_sc_hd__dlygate4sd3_1
XTAP_TAPCELL_ROW_107_1912 VGND VPWR sky130_fd_sc_hd__tapvpwrvgnd_1
Xhold1199 _3705_/X VGND VGND VPWR VPWR _5726_/D sky130_fd_sc_hd__dlygate4sd3_1
X_5029_ _3965_/X _5029_/B _5029_/C _5029_/D VGND VGND VPWR VPWR _5029_/X sky130_fd_sc_hd__and4b_1
XFILLER_54_841 VGND VGND VPWR VPWR sky130_fd_sc_hd__fill_1
Xhold1188 _4368_/X VGND VGND VPWR VPWR _6009_/D sky130_fd_sc_hd__dlygate4sd3_1
XTAP_TAPCELL_ROW_49_1041 VGND VPWR sky130_fd_sc_hd__tapvpwrvgnd_1
XTAP_TAPCELL_ROW_49_1030 VGND VPWR sky130_fd_sc_hd__tapvpwrvgnd_1
XFILLER_38_392 VGND VGND VPWR VPWR sky130_fd_sc_hd__fill_2
XFILLER_26_587 VGND VGND VPWR VPWR sky130_fd_sc_hd__fill_1
XFILLER_80_192 VGND VGND VPWR VPWR sky130_fd_sc_hd__fill_2
XTAP_TAPCELL_ROW_62_1230 VGND VPWR sky130_fd_sc_hd__tapvpwrvgnd_1
XFILLER_14_749 VGND VGND VPWR VPWR sky130_fd_sc_hd__fill_4
XFILLER_110_64 VGND VGND VPWR VPWR sky130_fd_sc_hd__fill_4
XFILLER_22_793 VPWR VGND VPWR VGND sky130_ef_sc_hd__decap_40_12
XFILLER_127_629 VPWR VGND VPWR VGND sky130_ef_sc_hd__decap_40_12
XANTENNA__4363__A1 _4981_/A1 VGND VGND VPWR VPWR sky130_fd_sc_hd__diode_2
XFILLER_135_673 VPWR VGND VPWR VGND sky130_ef_sc_hd__decap_40_12
XFILLER_79_44 VPWR VGND VPWR VGND sky130_ef_sc_hd__decap_40_12
XANTENNA__4687__S _4778_/S VGND VGND VPWR VPWR sky130_fd_sc_hd__diode_2
XANTENNA__3591__S _3595_/S VGND VGND VPWR VPWR sky130_fd_sc_hd__diode_2
XFILLER_1_653 VPWR VGND VPWR VGND sky130_ef_sc_hd__decap_40_12
XFILLER_110_529 VGND VGND VPWR VPWR sky130_fd_sc_hd__fill_2
XTAP_TAPCELL_ROW_73_1392 VGND VPWR sky130_fd_sc_hd__tapvpwrvgnd_1
XFILLER_0_141 VGND VGND VPWR VPWR sky130_fd_sc_hd__fill_4
XANTENNA__3874__A0 _5211_/A1 VGND VGND VPWR VPWR sky130_fd_sc_hd__diode_2
XFILLER_1_697 VPWR VGND VPWR VGND sky130_ef_sc_hd__decap_40_12
XFILLER_91_468 VGND VGND VPWR VPWR sky130_fd_sc_hd__fill_1
XFILLER_45_841 VGND VGND VPWR VPWR sky130_fd_sc_hd__fill_1
XANTENNA__4435__B input5/X VGND VGND VPWR VPWR sky130_fd_sc_hd__diode_2
XFILLER_60_811 VGND VGND VPWR VPWR sky130_fd_sc_hd__fill_1
XFILLER_32_513 VGND VGND VPWR VPWR sky130_fd_sc_hd__fill_2
XANTENNA__3766__S _3766_/S VGND VGND VPWR VPWR sky130_fd_sc_hd__diode_2
XFILLER_32_568 VGND VGND VPWR VPWR sky130_fd_sc_hd__fill_1
XANTENNA__2670__S _5241_/S VGND VGND VPWR VPWR sky130_fd_sc_hd__diode_2
X_2730_ _5222_/A _2730_/B VGND VGND VPWR VPWR _2730_/Y sky130_fd_sc_hd__nor2_1
XANTENNA__4451__A _4451_/A VGND VGND VPWR VPWR sky130_fd_sc_hd__diode_2
XFILLER_9_753 VPWR VGND VPWR VGND sky130_ef_sc_hd__decap_40_12
XTAP_TAPCELL_ROW_30_747 VGND VPWR sky130_fd_sc_hd__tapvpwrvgnd_1
XFILLER_117_117 VGND VGND VPWR VPWR sky130_fd_sc_hd__fill_1
X_2661_ _2661_/A1 _4548_/A _2647_/A _3092_/A _2660_/X VGND VGND VPWR VPWR _2722_/B
+ sky130_fd_sc_hd__a221o_1
XANTENNA__4029__S1 _4263_/A VGND VGND VPWR VPWR sky130_fd_sc_hd__diode_2
XTAP_TAPCELL_ROW_93_1702 VGND VPWR sky130_fd_sc_hd__tapvpwrvgnd_1
XANTENNA__4354__A1 _5045_/A1 VGND VGND VPWR VPWR sky130_fd_sc_hd__diode_2
X_4400_ _5825_/Q hold781/X _4406_/S VGND VGND VPWR VPWR _4400_/X sky130_fd_sc_hd__mux2_1
XFILLER_9_797 VPWR VGND VPWR VGND sky130_ef_sc_hd__decap_40_12
XFILLER_8_296 VGND VGND VPWR VPWR sky130_fd_sc_hd__fill_1
X_5380_ _6369_/CLK _5380_/D VGND VGND VPWR VPWR _5380_/Q sky130_fd_sc_hd__dfxtp_1
XFILLER_114_813 VPWR VGND VPWR VGND sky130_ef_sc_hd__decap_40_12
XFILLER_99_513 VPWR VGND VPWR VGND sky130_ef_sc_hd__decap_40_12
X_4331_ _5043_/A1 _4331_/A1 _4335_/S VGND VGND VPWR VPWR _5977_/D sky130_fd_sc_hd__mux2_1
XFILLER_125_194 VGND VGND VPWR VPWR sky130_fd_sc_hd__fill_1
XFILLER_99_557 VGND VGND VPWR VPWR sky130_fd_sc_hd__fill_2
X_4262_ _5990_/Q _5981_/Q _4262_/S VGND VGND VPWR VPWR _4263_/B sky130_fd_sc_hd__mux2_1
X_3213_ _4899_/A0 _3213_/A1 _3220_/S VGND VGND VPWR VPWR _3213_/X sky130_fd_sc_hd__mux2_1
XFILLER_101_529 VPWR VGND VPWR VGND sky130_ef_sc_hd__decap_40_12
X_6001_ _6345_/CLK _6001_/D VGND VGND VPWR VPWR _6001_/Q sky130_fd_sc_hd__dfxtp_1
XFILLER_95_741 VPWR VGND VPWR VGND sky130_ef_sc_hd__decap_40_12
XANTENNA__3006__S _3062_/S VGND VGND VPWR VPWR sky130_fd_sc_hd__diode_2
XANTENNA__3865__A0 _4488_/A0 VGND VGND VPWR VPWR sky130_fd_sc_hd__diode_2
X_4193_ _4193_/A0 _4193_/A1 _4250_/S VGND VGND VPWR VPWR _4193_/X sky130_fd_sc_hd__mux2_1
XFILLER_95_785 VPWR VGND VPWR VGND sky130_ef_sc_hd__decap_40_12
XFILLER_94_251 VGND VGND VPWR VPWR sky130_fd_sc_hd__fill_1
X_3144_ _2703_/B _4993_/S _3143_/Y VGND VGND VPWR VPWR _3144_/X sky130_fd_sc_hd__o21a_1
X_3075_ _3044_/A _3072_/X _3073_/X _3074_/X _3075_/C1 VGND VGND VPWR VPWR _3075_/X
+ sky130_fd_sc_hd__o221a_1
XANTENNA__3801__Y _5808_/D VGND VGND VPWR VPWR sky130_fd_sc_hd__diode_2
XANTENNA__3093__A1 _3033_/S VGND VGND VPWR VPWR sky130_fd_sc_hd__diode_2
XFILLER_36_841 VGND VGND VPWR VPWR sky130_fd_sc_hd__fill_1
XTAP_TAPCELL_ROW_38_869 VGND VPWR sky130_fd_sc_hd__tapvpwrvgnd_1
XFILLER_51_833 VGND VGND VPWR VPWR sky130_fd_sc_hd__fill_4
XTAP_TAPCELL_ROW_18_571 VGND VPWR sky130_fd_sc_hd__tapvpwrvgnd_1
XFILLER_23_502 VGND VGND VPWR VPWR sky130_fd_sc_hd__fill_2
XTAP_TAPCELL_ROW_102_1831 VGND VPWR sky130_fd_sc_hd__tapvpwrvgnd_1
XFILLER_62_192 VGND VGND VPWR VPWR sky130_fd_sc_hd__fill_4
X_3977_ _6408_/Q _3976_/C _5099_/D VGND VGND VPWR VPWR _3977_/Y sky130_fd_sc_hd__o21ai_1
XANTENNA__4042__B1 _3172_/B VGND VGND VPWR VPWR sky130_fd_sc_hd__diode_2
X_2928_ _2985_/A _2928_/B VGND VGND VPWR VPWR _2928_/X sky130_fd_sc_hd__or2_1
X_5716_ _6122_/CLK _5716_/D VGND VGND VPWR VPWR _5716_/Q sky130_fd_sc_hd__dfxtp_1
XFILLER_31_590 VGND VGND VPWR VPWR sky130_fd_sc_hd__fill_2
XTAP_TAPCELL_ROW_135_2330 VGND VPWR sky130_fd_sc_hd__tapvpwrvgnd_1
X_2859_ _3076_/A1 _2854_/X _2856_/X _2858_/X VGND VGND VPWR VPWR _2859_/X sky130_fd_sc_hd__a22o_1
X_5647_ _6290_/CLK _5647_/D VGND VGND VPWR VPWR _5647_/Q sky130_fd_sc_hd__dfxtp_1
XANTENNA__4345__A1 _5047_/A1 VGND VGND VPWR VPWR sky130_fd_sc_hd__diode_2
XANTENNA_fanout207_X _3801_/A VGND VGND VPWR VPWR sky130_fd_sc_hd__diode_2
X_5578_ _5753_/CLK _5578_/D VGND VGND VPWR VPWR _5578_/Q sky130_fd_sc_hd__dfxtp_1
XFILLER_117_673 VPWR VGND VPWR VGND sky130_ef_sc_hd__decap_40_12
XFILLER_104_323 VGND VGND VPWR VPWR sky130_fd_sc_hd__fill_2
X_4529_ hold379/X _5075_/A0 _4535_/S VGND VGND VPWR VPWR _4529_/X sky130_fd_sc_hd__mux2_1
Xhold252 _5866_/Q VGND VGND VPWR VPWR hold252/X sky130_fd_sc_hd__dlygate4sd3_1
Xhold241 _5056_/X VGND VGND VPWR VPWR _6349_/D sky130_fd_sc_hd__dlygate4sd3_1
Xhold230 _6125_/Q VGND VGND VPWR VPWR hold230/X sky130_fd_sc_hd__dlygate4sd3_1
XFILLER_132_643 VGND VGND VPWR VPWR sky130_fd_sc_hd__fill_1
Xhold274 _5308_/Q VGND VGND VPWR VPWR hold274/X sky130_fd_sc_hd__dlygate4sd3_1
XFILLER_120_805 VGND VGND VPWR VPWR sky130_fd_sc_hd__fill_4
XFILLER_116_183 VGND VGND VPWR VPWR sky130_fd_sc_hd__fill_1
Xhold296 _4876_/X VGND VGND VPWR VPWR _6226_/D sky130_fd_sc_hd__dlygate4sd3_1
Xhold285 _5442_/Q VGND VGND VPWR VPWR hold285/X sky130_fd_sc_hd__dlygate4sd3_1
Xhold263 _4361_/X VGND VGND VPWR VPWR _6003_/D sky130_fd_sc_hd__dlygate4sd3_1
XTAP_TAPCELL_ROW_113_1993 VGND VPWR sky130_fd_sc_hd__tapvpwrvgnd_1
XANTENNA__2659__B2 _3030_/S VGND VGND VPWR VPWR sky130_fd_sc_hd__diode_2
XFILLER_86_752 VGND VGND VPWR VPWR sky130_fd_sc_hd__fill_4
XFILLER_58_421 VGND VGND VPWR VPWR sky130_fd_sc_hd__fill_4
XANTENNA_fanout67_A _2641_/Y VGND VGND VPWR VPWR sky130_fd_sc_hd__diode_2
XANTENNA__2754__S1 _3044_/A VGND VGND VPWR VPWR sky130_fd_sc_hd__diode_2
XANTENNA__2755__S _3016_/S VGND VGND VPWR VPWR sky130_fd_sc_hd__diode_2
XFILLER_27_841 VGND VGND VPWR VPWR sky130_fd_sc_hd__fill_1
XFILLER_42_811 VGND VGND VPWR VPWR sky130_fd_sc_hd__fill_1
XFILLER_14_513 VPWR VGND VPWR VGND sky130_ef_sc_hd__decap_40_12
XANTENNA__4970__S _4974_/S VGND VGND VPWR VPWR sky130_fd_sc_hd__diode_2
XFILLER_81_34 VPWR VGND VPWR VGND sky130_ef_sc_hd__decap_40_12
XFILLER_14_557 VPWR VGND VPWR VGND sky130_ef_sc_hd__decap_40_12
Xclkbuf_leaf_80_clk clkload1/A VGND VGND VPWR VPWR _5681_/CLK sky130_fd_sc_hd__clkbuf_8
XANTENNA__4259__S1 _3172_/B VGND VGND VPWR VPWR sky130_fd_sc_hd__diode_2
XFILLER_6_701 VPWR VGND VPWR VGND sky130_ef_sc_hd__decap_40_12
XFILLER_108_640 VGND VGND VPWR VPWR sky130_fd_sc_hd__fill_4
XTAP_TAPCELL_ROW_75_1432 VGND VPWR sky130_fd_sc_hd__tapvpwrvgnd_1
XTAP_TAPCELL_ROW_75_1421 VGND VPWR sky130_fd_sc_hd__tapvpwrvgnd_1
XFILLER_123_665 VGND VGND VPWR VPWR sky130_fd_sc_hd__fill_4
XFILLER_122_120 VGND VGND VPWR VPWR sky130_fd_sc_hd__fill_8
XANTENNA__2993__S1 _3020_/A VGND VGND VPWR VPWR sky130_fd_sc_hd__diode_2
XFILLER_1_461 VPWR VGND VPWR VGND sky130_ef_sc_hd__decap_40_12
XFILLER_77_785 VPWR VGND VPWR VGND sky130_ef_sc_hd__decap_40_12
XANTENNA_output48_A _5440_/Q VGND VGND VPWR VPWR sky130_fd_sc_hd__diode_2
Xinput9 s_axil_awvalid VGND VGND VPWR VPWR input9/X sky130_fd_sc_hd__clkbuf_1
XFILLER_36_104 VGND VGND VPWR VPWR sky130_fd_sc_hd__fill_4
XFILLER_92_755 VGND VGND VPWR VPWR sky130_fd_sc_hd__fill_1
XFILLER_18_841 VGND VGND VPWR VPWR sky130_fd_sc_hd__fill_1
XANTENNA__3075__A1 _3044_/A VGND VGND VPWR VPWR sky130_fd_sc_hd__diode_2
XTAP_TAPCELL_ROW_86_1583 VGND VPWR sky130_fd_sc_hd__tapvpwrvgnd_1
XFILLER_51_118 VGND VGND VPWR VPWR sky130_fd_sc_hd__fill_1
XTAP_TAPCELL_ROW_35_828 VGND VPWR sky130_fd_sc_hd__tapvpwrvgnd_1
X_4880_ _4880_/A0 _4906_/A0 _4880_/S VGND VGND VPWR VPWR _4880_/X sky130_fd_sc_hd__mux2_1
XANTENNA__4880__S _4880_/S VGND VGND VPWR VPWR sky130_fd_sc_hd__diode_2
XTAP_TAPCELL_ROW_86_1594 VGND VPWR sky130_fd_sc_hd__tapvpwrvgnd_1
Xclkbuf_leaf_71_clk clkload2/A VGND VGND VPWR VPWR _6294_/CLK sky130_fd_sc_hd__clkbuf_8
XFILLER_33_833 VGND VGND VPWR VPWR sky130_fd_sc_hd__fill_4
X_3900_ _3900_/A0 _5208_/A1 _3908_/S VGND VGND VPWR VPWR _3900_/X sky130_fd_sc_hd__mux2_1
X_3831_ input25/X _5046_/A1 _3835_/S VGND VGND VPWR VPWR _5830_/D sky130_fd_sc_hd__mux2_1
XTAP_TAPCELL_ROW_15_530 VGND VPWR sky130_fd_sc_hd__tapvpwrvgnd_1
XANTENNA__3496__S _3503_/S VGND VGND VPWR VPWR sky130_fd_sc_hd__diode_2
XANTENNA__3378__A2 _4457_/S VGND VGND VPWR VPWR sky130_fd_sc_hd__diode_2
XANTENNA__3349__X _5201_/B VGND VGND VPWR VPWR sky130_fd_sc_hd__diode_2
X_3762_ hold952/X _4980_/A1 _3766_/S VGND VGND VPWR VPWR _3762_/X sky130_fd_sc_hd__mux2_1
X_5501_ _6435_/CLK _5501_/D VGND VGND VPWR VPWR _5501_/Q sky130_fd_sc_hd__dfxtp_1
XFILLER_118_415 VGND VGND VPWR VPWR sky130_fd_sc_hd__fill_1
XFILLER_9_561 VPWR VGND VPWR VGND sky130_ef_sc_hd__decap_40_12
XTAP_TAPCELL_ROW_117_2060 VGND VPWR sky130_fd_sc_hd__tapvpwrvgnd_1
X_3693_ hold690/X _4517_/A1 _3698_/S VGND VGND VPWR VPWR _3693_/X sky130_fd_sc_hd__mux2_1
X_2713_ _4981_/A1 _2713_/A1 _2716_/S VGND VGND VPWR VPWR _2713_/X sky130_fd_sc_hd__mux2_1
X_2644_ _2688_/A VGND VGND VPWR VPWR _4548_/A sky130_fd_sc_hd__inv_2
X_5432_ _6420_/CLK _5432_/D VGND VGND VPWR VPWR _5432_/Q sky130_fd_sc_hd__dfxtp_1
XFILLER_126_470 VGND VGND VPWR VPWR sky130_fd_sc_hd__fill_4
X_5363_ _6148_/CLK _5363_/D VGND VGND VPWR VPWR _5363_/Q sky130_fd_sc_hd__dfxtp_1
XFILLER_114_643 VGND VGND VPWR VPWR sky130_fd_sc_hd__fill_1
XANTENNA__4120__S _4237_/S VGND VGND VPWR VPWR sky130_fd_sc_hd__diode_2
X_4314_ hold401/X _5046_/A1 _4315_/S VGND VGND VPWR VPWR _4314_/X sky130_fd_sc_hd__mux2_1
XFILLER_102_805 VGND VGND VPWR VPWR sky130_fd_sc_hd__fill_4
XFILLER_87_516 VGND VGND VPWR VPWR sky130_fd_sc_hd__fill_1
X_5294_ _6172_/CLK hold7/X VGND VGND VPWR VPWR hold6/A sky130_fd_sc_hd__dfxtp_1
XFILLER_101_337 VGND VGND VPWR VPWR sky130_fd_sc_hd__fill_4
XFILLER_101_315 VGND VGND VPWR VPWR sky130_fd_sc_hd__fill_4
X_4245_ _4252_/B1 _4244_/X _4241_/Y _4243_/Y VGND VGND VPWR VPWR _4245_/X sky130_fd_sc_hd__o2bb2a_1
XANTENNA__4186__S0 _4257_/S VGND VGND VPWR VPWR sky130_fd_sc_hd__diode_2
X_4176_ _5734_/Q _5464_/Q _5455_/Q _5446_/Q _4250_/S _4178_/A VGND VGND VPWR VPWR
+ _4176_/X sky130_fd_sc_hd__mux4_1
XFILLER_68_785 VGND VGND VPWR VPWR sky130_fd_sc_hd__fill_1
XFILLER_28_627 VGND VGND VPWR VPWR sky130_fd_sc_hd__fill_1
X_3127_ _5831_/Q _4451_/A _3128_/A VGND VGND VPWR VPWR _3127_/Y sky130_fd_sc_hd__a21oi_1
X_3058_ _3092_/A _5758_/Q _3057_/X VGND VGND VPWR VPWR _3058_/X sky130_fd_sc_hd__a21o_1
XFILLER_70_427 VGND VGND VPWR VPWR sky130_fd_sc_hd__fill_1
XFILLER_43_619 VGND VGND VPWR VPWR sky130_fd_sc_hd__fill_1
XFILLER_24_811 VGND VGND VPWR VPWR sky130_fd_sc_hd__fill_1
XANTENNA_clkbuf_leaf_60_clk_A clkload6/A VGND VGND VPWR VPWR sky130_fd_sc_hd__diode_2
Xclkbuf_leaf_62_clk clkload5/A VGND VGND VPWR VPWR _5849_/CLK sky130_fd_sc_hd__clkbuf_8
XANTENNA_fanout157_X _4149_/A VGND VGND VPWR VPWR sky130_fd_sc_hd__diode_2
XFILLER_35_192 VGND VGND VPWR VPWR sky130_fd_sc_hd__fill_1
XFILLER_11_505 VPWR VGND VPWR VGND sky130_ef_sc_hd__decap_40_12
XANTENNA__4566__A1 _4791_/A1 VGND VGND VPWR VPWR sky130_fd_sc_hd__diode_2
XANTENNA_clkbuf_leaf_75_clk_A clkload2/A VGND VGND VPWR VPWR sky130_fd_sc_hd__diode_2
XANTENNA__4318__A1 _5040_/A1 VGND VGND VPWR VPWR sky130_fd_sc_hd__diode_2
XTAP_TAPCELL_ROW_57_1162 VGND VPWR sky130_fd_sc_hd__tapvpwrvgnd_1
XTAP_TAPCELL_ROW_57_1151 VGND VPWR sky130_fd_sc_hd__tapvpwrvgnd_1
XFILLER_120_613 VPWR VGND VPWR VGND sky130_ef_sc_hd__decap_40_12
XFILLER_116_41 VGND VGND VPWR VPWR sky130_fd_sc_hd__fill_2
XFILLER_105_665 VGND VGND VPWR VPWR sky130_fd_sc_hd__fill_4
XFILLER_104_197 VGND VGND VPWR VPWR sky130_fd_sc_hd__fill_2
XFILLER_120_657 VPWR VGND VPWR VGND sky130_ef_sc_hd__decap_40_12
XTAP_TAPCELL_ROW_70_1351 VGND VPWR sky130_fd_sc_hd__tapvpwrvgnd_1
XANTENNA_clkbuf_leaf_13_clk_A clkbuf_leaf_9_clk/A VGND VGND VPWR VPWR sky130_fd_sc_hd__diode_2
XFILLER_59_785 VPWR VGND VPWR VGND sky130_ef_sc_hd__decap_40_12
XFILLER_46_402 VGND VGND VPWR VPWR sky130_fd_sc_hd__fill_1
XFILLER_100_392 VGND VGND VPWR VPWR sky130_fd_sc_hd__fill_1
XFILLER_74_766 VPWR VGND VPWR VGND sky130_ef_sc_hd__decap_40_12
XFILLER_74_755 VGND VGND VPWR VPWR sky130_fd_sc_hd__fill_1
XFILLER_46_435 VGND VGND VPWR VPWR sky130_fd_sc_hd__fill_2
XFILLER_18_137 VGND VGND VPWR VPWR sky130_fd_sc_hd__fill_2
XANTENNA__3057__A1 _3086_/S VGND VGND VPWR VPWR sky130_fd_sc_hd__diode_2
XANTENNA_clkbuf_leaf_28_clk_A clkload3/A VGND VGND VPWR VPWR sky130_fd_sc_hd__diode_2
Xclkbuf_leaf_53_clk clkload6/A VGND VGND VPWR VPWR _6239_/CLK sky130_fd_sc_hd__clkbuf_8
XFILLER_15_833 VGND VGND VPWR VPWR sky130_fd_sc_hd__fill_4
XFILLER_26_181 VGND VGND VPWR VPWR sky130_fd_sc_hd__fill_4
XANTENNA__4006__B1 _3959_/A VGND VGND VPWR VPWR sky130_fd_sc_hd__diode_2
XFILLER_14_365 VPWR VGND VPWR VGND sky130_ef_sc_hd__decap_40_12
XANTENNA__4557__A1 _4889_/A1 VGND VGND VPWR VPWR sky130_fd_sc_hd__diode_2
XFILLER_30_825 VPWR VGND VPWR VGND sky130_ef_sc_hd__decap_40_12
XFILLER_128_713 VPWR VGND VPWR VGND sky130_ef_sc_hd__decap_40_12
XFILLER_128_757 VPWR VGND VPWR VGND sky130_ef_sc_hd__decap_40_12
XFILLER_127_223 VGND VGND VPWR VPWR sky130_fd_sc_hd__fill_1
XTAP_TAPCELL_ROW_40_897 VGND VPWR sky130_fd_sc_hd__tapvpwrvgnd_1
XANTENNA__4309__A1 _5053_/A1 VGND VGND VPWR VPWR sky130_fd_sc_hd__diode_2
XFILLER_6_531 VGND VGND VPWR VPWR sky130_fd_sc_hd__fill_1
XFILLER_123_462 VGND VGND VPWR VPWR sky130_fd_sc_hd__fill_1
XFILLER_111_613 VGND VGND VPWR VPWR sky130_fd_sc_hd__fill_2
XFILLER_69_505 VGND VGND VPWR VPWR sky130_fd_sc_hd__fill_2
XANTENNA__4875__S _4880_/S VGND VGND VPWR VPWR sky130_fd_sc_hd__diode_2
XFILLER_2_781 VPWR VGND VPWR VGND sky130_ef_sc_hd__decap_40_12
XANTENNA__4168__S0 _4213_/S VGND VGND VPWR VPWR sky130_fd_sc_hd__diode_2
X_4030_ _4026_/X _4028_/X _4029_/X _4271_/S1 VGND VGND VPWR VPWR _4031_/B sky130_fd_sc_hd__a22o_1
XFILLER_2_53 VPWR VGND VPWR VGND sky130_ef_sc_hd__decap_40_12
XPHY_EDGE_ROW_10_Right_10 VGND VGND VPWR VPWR sky130_fd_sc_hd__decap_3
XTAP_TAPCELL_ROW_88_1623 VGND VPWR sky130_fd_sc_hd__tapvpwrvgnd_1
XFILLER_37_402 VGND VGND VPWR VPWR sky130_fd_sc_hd__fill_4
XFILLER_92_585 VGND VGND VPWR VPWR sky130_fd_sc_hd__fill_2
XFILLER_80_725 VGND VGND VPWR VPWR sky130_fd_sc_hd__fill_4
XFILLER_65_777 VGND VGND VPWR VPWR sky130_fd_sc_hd__fill_4
X_5981_ _5990_/CLK _5981_/D VGND VGND VPWR VPWR _5981_/Q sky130_fd_sc_hd__dfxtp_1
Xclkbuf_leaf_44_clk clkload4/A VGND VGND VPWR VPWR _5565_/CLK sky130_fd_sc_hd__clkbuf_8
XANTENNA__4796__A1 _2629_/Y VGND VGND VPWR VPWR sky130_fd_sc_hd__diode_2
XFILLER_18_693 VGND VGND VPWR VPWR sky130_fd_sc_hd__fill_4
X_4932_ hold185/X _4982_/A1 _4934_/S VGND VGND VPWR VPWR _4932_/X sky130_fd_sc_hd__mux2_1
X_4863_ _4889_/A1 hold819/X _4867_/S VGND VGND VPWR VPWR _4863_/X sky130_fd_sc_hd__mux2_1
XFILLER_32_151 VGND VGND VPWR VPWR sky130_fd_sc_hd__fill_1
X_4794_ _4794_/A _4794_/B VGND VGND VPWR VPWR _4794_/Y sky130_fd_sc_hd__nor2_1
X_3814_ _4908_/A _4886_/A1 _3818_/S VGND VGND VPWR VPWR _5817_/D sky130_fd_sc_hd__mux2_1
XFILLER_60_493 VGND VGND VPWR VPWR sky130_fd_sc_hd__fill_1
XTAP_TAPCELL_ROW_115_2019 VGND VPWR sky130_fd_sc_hd__tapvpwrvgnd_1
X_3745_ hold242/X _5237_/A0 _3745_/S VGND VGND VPWR VPWR _3745_/X sky130_fd_sc_hd__mux2_1
XANTENNA__4643__S1 _4809_/A VGND VGND VPWR VPWR sky130_fd_sc_hd__diode_2
XTAP_TAPCELL_ROW_99_1785 VGND VPWR sky130_fd_sc_hd__tapvpwrvgnd_1
XFILLER_9_391 VGND VGND VPWR VPWR sky130_fd_sc_hd__fill_1
XFILLER_134_749 VGND VGND VPWR VPWR sky130_fd_sc_hd__fill_4
XFILLER_106_429 VGND VGND VPWR VPWR sky130_fd_sc_hd__fill_4
X_5415_ _6399_/CLK _5415_/D VGND VGND VPWR VPWR _5415_/Q sky130_fd_sc_hd__dfxtp_1
XANTENNA_fanout117_A _5819_/Q VGND VGND VPWR VPWR sky130_fd_sc_hd__diode_2
X_3676_ _3926_/A1 _3676_/A1 _3678_/S VGND VGND VPWR VPWR _3676_/X sky130_fd_sc_hd__mux2_1
X_6395_ _6398_/CLK _6395_/D VGND VGND VPWR VPWR _6395_/Q sky130_fd_sc_hd__dfxtp_1
X_2627_ _3278_/A VGND VGND VPWR VPWR _4785_/S sky130_fd_sc_hd__inv_2
XFILLER_102_613 VPWR VGND VPWR VGND sky130_ef_sc_hd__decap_40_12
XFILLER_99_151 VGND VGND VPWR VPWR sky130_fd_sc_hd__fill_1
X_5346_ _5820_/CLK _5346_/D VGND VGND VPWR VPWR _5346_/Q sky130_fd_sc_hd__dfxtp_1
XFILLER_88_825 VPWR VGND VPWR VGND sky130_ef_sc_hd__decap_40_12
XFILLER_0_729 VGND VGND VPWR VPWR sky130_fd_sc_hd__fill_8
X_5277_ _5753_/CLK _5277_/D VGND VGND VPWR VPWR _5277_/Q sky130_fd_sc_hd__dfxtp_1
XANTENNA__4159__S0 _4213_/S VGND VGND VPWR VPWR sky130_fd_sc_hd__diode_2
XTAP_TAPCELL_ROW_110_1952 VGND VPWR sky130_fd_sc_hd__tapvpwrvgnd_1
XFILLER_102_657 VPWR VGND VPWR VGND sky130_ef_sc_hd__decap_40_12
X_4228_ _5935_/Q _6324_/Q _4228_/S VGND VGND VPWR VPWR _4228_/X sky130_fd_sc_hd__mux2_1
XANTENNA__3287__A1 _5241_/A1 VGND VGND VPWR VPWR sky130_fd_sc_hd__diode_2
XANTENNA__4484__A0 _4484_/A0 VGND VGND VPWR VPWR sky130_fd_sc_hd__diode_2
XTAP_TAPCELL_ROW_52_1081 VGND VPWR sky130_fd_sc_hd__tapvpwrvgnd_1
XPHY_EDGE_ROW_106_Right_106 VGND VGND VPWR VPWR sky130_fd_sc_hd__decap_3
X_4159_ _5260_/Q _6049_/Q _6040_/Q hold16/A _4213_/S _4178_/A VGND VGND VPWR VPWR
+ _4159_/X sky130_fd_sc_hd__mux4_1
XFILLER_56_777 VPWR VGND VPWR VGND sky130_ef_sc_hd__decap_40_12
XFILLER_43_427 VGND VGND VPWR VPWR sky130_fd_sc_hd__fill_4
Xclkbuf_leaf_35_clk clkload4/A VGND VGND VPWR VPWR _6143_/CLK sky130_fd_sc_hd__clkbuf_8
XFILLER_70_268 VGND VGND VPWR VPWR sky130_fd_sc_hd__fill_1
XANTENNA__2893__S0 _3091_/S VGND VGND VPWR VPWR sky130_fd_sc_hd__diode_2
XFILLER_12_825 VPWR VGND VPWR VGND sky130_ef_sc_hd__decap_40_12
XFILLER_23_173 VGND VGND VPWR VPWR sky130_fd_sc_hd__fill_1
XANTENNA__4539__A1 _5241_/A1 VGND VGND VPWR VPWR sky130_fd_sc_hd__diode_2
XANTENNA__4025__S _4228_/S VGND VGND VPWR VPWR sky130_fd_sc_hd__diode_2
XFILLER_127_3 VPWR VGND VPWR VGND sky130_ef_sc_hd__decap_40_12
XANTENNA__3864__S _3869_/S VGND VGND VPWR VPWR sky130_fd_sc_hd__diode_2
XFILLER_125_727 VGND VGND VPWR VPWR sky130_fd_sc_hd__fill_1
XFILLER_109_289 VGND VGND VPWR VPWR sky130_fd_sc_hd__fill_1
XFILLER_3_501 VGND VGND VPWR VPWR sky130_fd_sc_hd__fill_2
XFILLER_87_11 VPWR VGND VPWR VGND sky130_ef_sc_hd__decap_40_12
XFILLER_120_421 VGND VGND VPWR VPWR sky130_fd_sc_hd__fill_1
XFILLER_87_88 VGND VGND VPWR VPWR sky130_fd_sc_hd__fill_1
XFILLER_93_327 VGND VGND VPWR VPWR sky130_fd_sc_hd__fill_1
XTAP_TAPCELL_ROW_6_394 VGND VPWR sky130_fd_sc_hd__tapvpwrvgnd_1
XTAP_TAPCELL_ROW_6_383 VGND VPWR sky130_fd_sc_hd__tapvpwrvgnd_1
XANTENNA__2943__S _3030_/S VGND VGND VPWR VPWR sky130_fd_sc_hd__diode_2
XFILLER_61_213 VGND VGND VPWR VPWR sky130_fd_sc_hd__fill_2
XFILLER_46_287 VGND VGND VPWR VPWR sky130_fd_sc_hd__fill_8
XTAP_TAPCELL_ROW_83_1542 VGND VPWR sky130_fd_sc_hd__tapvpwrvgnd_1
Xclkbuf_leaf_26_clk clkload3/A VGND VGND VPWR VPWR _5841_/CLK sky130_fd_sc_hd__clkbuf_8
XANTENNA__3986__C1 _5034_/B VGND VGND VPWR VPWR sky130_fd_sc_hd__diode_2
XTAP_TAPCELL_ROW_45_978 VGND VPWR sky130_fd_sc_hd__tapvpwrvgnd_1
XFILLER_15_641 VPWR VGND VPWR VGND sky130_ef_sc_hd__decap_40_12
XANTENNA__3450__A1 _5237_/A0 VGND VGND VPWR VPWR sky130_fd_sc_hd__diode_2
XFILLER_61_279 VGND VGND VPWR VPWR sky130_fd_sc_hd__fill_1
XFILLER_15_685 VPWR VGND VPWR VGND sky130_ef_sc_hd__decap_40_12
XFILLER_30_611 VGND VGND VPWR VPWR sky130_fd_sc_hd__fill_4
XFILLER_14_195 VGND VGND VPWR VPWR sky130_fd_sc_hd__fill_1
XTAP_TAPCELL_ROW_25_680 VGND VPWR sky130_fd_sc_hd__tapvpwrvgnd_1
XANTENNA__3202__A1 _5233_/A0 VGND VGND VPWR VPWR sky130_fd_sc_hd__diode_2
Xinput12 s_axil_wdata[0] VGND VGND VPWR VPWR input12/X sky130_fd_sc_hd__buf_1
X_3530_ hold524/X _4882_/A1 _3541_/S VGND VGND VPWR VPWR _3530_/X sky130_fd_sc_hd__mux2_1
Xinput23 s_axil_wdata[5] VGND VGND VPWR VPWR input23/X sky130_fd_sc_hd__buf_1
XFILLER_128_587 VGND VGND VPWR VPWR sky130_fd_sc_hd__fill_1
Xhold807 _5288_/Q VGND VGND VPWR VPWR hold807/X sky130_fd_sc_hd__dlygate4sd3_1
Xhold818 _4354_/X VGND VGND VPWR VPWR _5997_/D sky130_fd_sc_hd__dlygate4sd3_1
X_3461_ hold692/X _4904_/A0 _3463_/S VGND VGND VPWR VPWR _3461_/X sky130_fd_sc_hd__mux2_1
XFILLER_116_749 VGND VGND VPWR VPWR sky130_fd_sc_hd__fill_4
Xhold829 _6263_/Q VGND VGND VPWR VPWR hold829/X sky130_fd_sc_hd__dlygate4sd3_1
XANTENNA__3061__S0 _3033_/S VGND VGND VPWR VPWR sky130_fd_sc_hd__diode_2
X_6180_ _6241_/CLK _6180_/D VGND VGND VPWR VPWR _6180_/Q sky130_fd_sc_hd__dfxtp_1
XANTENNA__2939__S1 _2962_/A VGND VGND VPWR VPWR sky130_fd_sc_hd__diode_2
X_5200_ _5200_/A _5200_/B VGND VGND VPWR VPWR _6405_/D sky130_fd_sc_hd__and2_1
XFILLER_42_3 VGND VGND VPWR VPWR sky130_fd_sc_hd__fill_4
X_3392_ _3708_/B _4935_/A VGND VGND VPWR VPWR _3401_/S sky130_fd_sc_hd__nor2_4
XANTENNA__2713__A0 _4981_/A1 VGND VGND VPWR VPWR sky130_fd_sc_hd__diode_2
XFILLER_124_793 VPWR VGND VPWR VGND sky130_ef_sc_hd__decap_40_12
Xhold2208 _5251_/Q VGND VGND VPWR VPWR _2660_/B sky130_fd_sc_hd__dlygate4sd3_1
X_5131_ _5127_/A _5160_/A _5130_/Y _5034_/B VGND VGND VPWR VPWR _5131_/X sky130_fd_sc_hd__o211a_1
Xhold2219 _5823_/Q VGND VGND VPWR VPWR hold2219/X sky130_fd_sc_hd__dlygate4sd3_1
XANTENNA__4458__X _4458_/X VGND VGND VPWR VPWR sky130_fd_sc_hd__diode_2
Xhold1507 _3874_/X VGND VGND VPWR VPWR _5855_/D sky130_fd_sc_hd__dlygate4sd3_1
X_5062_ _5062_/A0 _3318_/B _5207_/S VGND VGND VPWR VPWR _5062_/X sky130_fd_sc_hd__mux2_1
XANTENNA__4466__A0 _5075_/A0 VGND VGND VPWR VPWR sky130_fd_sc_hd__diode_2
Xhold1518 _5375_/Q VGND VGND VPWR VPWR _3215_/A1 sky130_fd_sc_hd__dlygate4sd3_1
Xhold1529 _5494_/Q VGND VGND VPWR VPWR _3444_/A0 sky130_fd_sc_hd__dlygate4sd3_1
XFILLER_85_839 VGND VGND VPWR VPWR sky130_fd_sc_hd__fill_1
XANTENNA_clkbuf_3_6__f_clk_A clkbuf_0_clk/X VGND VGND VPWR VPWR sky130_fd_sc_hd__diode_2
X_4013_ _5123_/A _4013_/B VGND VGND VPWR VPWR _4014_/B sky130_fd_sc_hd__and2b_1
XFILLER_38_711 VGND VGND VPWR VPWR sky130_fd_sc_hd__fill_1
XANTENNA__3014__S _3016_/S VGND VGND VPWR VPWR sky130_fd_sc_hd__diode_2
XFILLER_38_744 VGND VGND VPWR VPWR sky130_fd_sc_hd__fill_1
XFILLER_38_766 VPWR VGND VPWR VGND sky130_ef_sc_hd__decap_40_12
XTAP_TAPCELL_ROW_125_2170 VGND VPWR sky130_fd_sc_hd__tapvpwrvgnd_1
XFILLER_92_360 VGND VGND VPWR VPWR sky130_fd_sc_hd__fill_4
XFILLER_25_405 VPWR VGND VPWR VGND sky130_ef_sc_hd__decap_40_12
XTAP_TAPCELL_ROW_125_2181 VGND VPWR sky130_fd_sc_hd__tapvpwrvgnd_1
XFILLER_25_449 VGND VGND VPWR VPWR sky130_fd_sc_hd__fill_8
XANTENNA__4769__A1 _4811_/A1 VGND VGND VPWR VPWR sky130_fd_sc_hd__diode_2
Xclkbuf_leaf_17_clk clkload6/A VGND VGND VPWR VPWR _6386_/CLK sky130_fd_sc_hd__clkbuf_8
X_5964_ _6334_/CLK _5964_/D VGND VGND VPWR VPWR _5964_/Q sky130_fd_sc_hd__dfxtp_1
XANTENNA__5534__CLK clkload6/A VGND VGND VPWR VPWR sky130_fd_sc_hd__diode_2
XANTENNA__3441__A1 _5228_/A0 VGND VGND VPWR VPWR sky130_fd_sc_hd__diode_2
X_4915_ _4915_/A1 _4907_/Y _4914_/X _5176_/A VGND VGND VPWR VPWR _6258_/D sky130_fd_sc_hd__o211a_1
XFILLER_21_611 VGND VGND VPWR VPWR sky130_fd_sc_hd__fill_4
XTAP_TAPCELL_ROW_23_639 VGND VPWR sky130_fd_sc_hd__tapvpwrvgnd_1
X_5895_ _6414_/CLK hold76/X VGND VGND VPWR VPWR hold75/A sky130_fd_sc_hd__dfxtp_1
X_4846_ _4846_/A0 _4846_/A1 _4854_/S VGND VGND VPWR VPWR _4846_/X sky130_fd_sc_hd__mux2_1
XFILLER_21_633 VPWR VGND VPWR VGND sky130_ef_sc_hd__decap_40_12
X_4777_ _4792_/A1 _4772_/X _4774_/X _4776_/X VGND VGND VPWR VPWR _4777_/X sky130_fd_sc_hd__a22o_1
XFILLER_20_187 VGND VGND VPWR VPWR sky130_fd_sc_hd__fill_1
XFILLER_134_513 VPWR VGND VPWR VGND sky130_ef_sc_hd__decap_40_12
XFILLER_107_727 VGND VGND VPWR VPWR sky130_fd_sc_hd__fill_1
X_3728_ _3728_/A0 _4984_/A1 _3728_/S VGND VGND VPWR VPWR _3728_/X sky130_fd_sc_hd__mux2_1
XFILLER_134_557 VPWR VGND VPWR VGND sky130_ef_sc_hd__decap_40_12
X_3659_ _6410_/Q _3659_/A1 _3667_/S VGND VGND VPWR VPWR _3659_/X sky130_fd_sc_hd__mux2_1
X_6378_ _6380_/CLK _6378_/D VGND VGND VPWR VPWR _6378_/Q sky130_fd_sc_hd__dfxtp_1
XTAP_TAPCELL_ROW_54_1110 VGND VPWR sky130_fd_sc_hd__tapvpwrvgnd_1
X_5329_ _6394_/CLK _5329_/D VGND VGND VPWR VPWR _5329_/Q sky130_fd_sc_hd__dfxtp_1
XFILLER_87_121 VGND VGND VPWR VPWR sky130_fd_sc_hd__fill_1
XFILLER_0_559 VGND VGND VPWR VPWR sky130_fd_sc_hd__fill_1
XANTENNA__4809__A _4809_/A VGND VGND VPWR VPWR sky130_fd_sc_hd__diode_2
XFILLER_91_809 VPWR VGND VPWR VGND sky130_ef_sc_hd__decap_40_12
XTAP_TAPCELL_ROW_3_342 VGND VPWR sky130_fd_sc_hd__tapvpwrvgnd_1
XFILLER_29_755 VPWR VGND VPWR VGND sky130_ef_sc_hd__decap_40_12
XFILLER_73_57 VGND VGND VPWR VPWR sky130_fd_sc_hd__fill_1
XFILLER_44_769 VPWR VGND VPWR VGND sky130_ef_sc_hd__decap_40_12
XANTENNA__3432__A1 _4901_/A0 VGND VGND VPWR VPWR sky130_fd_sc_hd__diode_2
XFILLER_71_588 VGND VGND VPWR VPWR sky130_fd_sc_hd__fill_1
XTAP_TAPCELL_ROW_65_1272 VGND VPWR sky130_fd_sc_hd__tapvpwrvgnd_1
XFILLER_43_279 VGND VGND VPWR VPWR sky130_fd_sc_hd__fill_1
XTAP_TAPCELL_ROW_42_937 VGND VPWR sky130_fd_sc_hd__tapvpwrvgnd_1
XTAP_TAPCELL_ROW_42_926 VGND VPWR sky130_fd_sc_hd__tapvpwrvgnd_1
XFILLER_8_637 VGND VGND VPWR VPWR sky130_fd_sc_hd__fill_4
XFILLER_138_841 VGND VGND VPWR VPWR sky130_fd_sc_hd__fill_1
XANTENNA__3594__S _3595_/S VGND VGND VPWR VPWR sky130_fd_sc_hd__diode_2
XFILLER_12_699 VGND VGND VPWR VPWR sky130_fd_sc_hd__fill_1
XFILLER_7_169 VGND VGND VPWR VPWR sky130_fd_sc_hd__fill_1
XANTENNA__4932__A1 _4982_/A1 VGND VGND VPWR VPWR sky130_fd_sc_hd__diode_2
XFILLER_138_83 VGND VGND VPWR VPWR sky130_fd_sc_hd__fill_1
XFILLER_125_557 VGND VGND VPWR VPWR sky130_fd_sc_hd__fill_2
XFILLER_106_793 VPWR VGND VPWR VGND sky130_ef_sc_hd__decap_40_12
XFILLER_79_611 VGND VGND VPWR VPWR sky130_fd_sc_hd__fill_2
XFILLER_121_741 VPWR VGND VPWR VGND sky130_ef_sc_hd__decap_40_12
XFILLER_79_655 VGND VGND VPWR VPWR sky130_fd_sc_hd__fill_1
XFILLER_121_785 VPWR VGND VPWR VGND sky130_ef_sc_hd__decap_40_12
XFILLER_94_625 VPWR VGND VPWR VGND sky130_ef_sc_hd__decap_40_12
XFILLER_79_699 VGND VGND VPWR VPWR sky130_fd_sc_hd__fill_1
XFILLER_67_839 VGND VGND VPWR VPWR sky130_fd_sc_hd__fill_1
XFILLER_94_669 VPWR VGND VPWR VGND sky130_ef_sc_hd__decap_40_12
XFILLER_47_541 VGND VGND VPWR VPWR sky130_fd_sc_hd__fill_1
XFILLER_81_319 VGND VGND VPWR VPWR sky130_fd_sc_hd__fill_1
XFILLER_74_360 VGND VGND VPWR VPWR sky130_fd_sc_hd__fill_4
XANTENNA__2673__S _5241_/S VGND VGND VPWR VPWR sky130_fd_sc_hd__diode_2
XFILLER_34_224 VGND VGND VPWR VPWR sky130_fd_sc_hd__fill_1
XFILLER_34_235 VGND VGND VPWR VPWR sky130_fd_sc_hd__fill_1
X_2961_ _5422_/Q _5496_/Q _2963_/S VGND VGND VPWR VPWR _2962_/B sky130_fd_sc_hd__mux2_1
XANTENNA__3423__A1 _4964_/A0 VGND VGND VPWR VPWR sky130_fd_sc_hd__diode_2
XFILLER_22_419 VGND VGND VPWR VPWR sky130_fd_sc_hd__fill_1
X_5680_ _5682_/CLK hold68/X VGND VGND VPWR VPWR hold67/A sky130_fd_sc_hd__dfxtp_1
X_4700_ _4697_/X _4698_/X _4699_/X _4663_/A VGND VGND VPWR VPWR _4700_/X sky130_fd_sc_hd__a22o_1
X_2892_ _3036_/A1 _2891_/X _3094_/C1 VGND VGND VPWR VPWR _2892_/Y sky130_fd_sc_hd__o21ai_1
X_4631_ _4799_/A _4623_/X _4630_/Y _3278_/A VGND VGND VPWR VPWR _4631_/X sky130_fd_sc_hd__a211o_1
XFILLER_30_474 VGND VGND VPWR VPWR sky130_fd_sc_hd__fill_2
XFILLER_129_841 VGND VGND VPWR VPWR sky130_fd_sc_hd__fill_1
XFILLER_116_513 VPWR VGND VPWR VGND sky130_ef_sc_hd__decap_40_12
XTAP_TAPCELL_ROW_96_1744 VGND VPWR sky130_fd_sc_hd__tapvpwrvgnd_1
XTAP_TAPCELL_ROW_96_1733 VGND VPWR sky130_fd_sc_hd__tapvpwrvgnd_1
X_4562_ hold928/X hold101/X _4562_/A2 _4562_/A3 _4773_/S _4789_/A VGND VGND VPWR VPWR
+ _4562_/X sky130_fd_sc_hd__mux4_1
Xhold626 _3540_/X VGND VGND VPWR VPWR _5583_/D sky130_fd_sc_hd__dlygate4sd3_1
Xhold604 _6160_/Q VGND VGND VPWR VPWR hold604/X sky130_fd_sc_hd__dlygate4sd3_1
X_3513_ _5234_/A0 _3513_/A1 _3516_/S VGND VGND VPWR VPWR _5557_/D sky130_fd_sc_hd__mux2_1
X_4493_ _4493_/A _4493_/B VGND VGND VPWR VPWR _4502_/S sky130_fd_sc_hd__nor2_4
X_6301_ _6315_/CLK _6301_/D VGND VGND VPWR VPWR _6301_/Q sky130_fd_sc_hd__dfxtp_1
Xhold615 _4481_/X VGND VGND VPWR VPWR _6088_/D sky130_fd_sc_hd__dlygate4sd3_1
XFILLER_131_505 VPWR VGND VPWR VGND sky130_ef_sc_hd__decap_40_12
XFILLER_116_557 VPWR VGND VPWR VGND sky130_ef_sc_hd__decap_40_12
X_6232_ _6232_/CLK _6232_/D VGND VGND VPWR VPWR _6232_/Q sky130_fd_sc_hd__dfxtp_1
Xhold637 _5580_/Q VGND VGND VPWR VPWR hold637/X sky130_fd_sc_hd__dlygate4sd3_1
X_3444_ _3444_/A0 _5075_/A0 _3450_/S VGND VGND VPWR VPWR _3444_/X sky130_fd_sc_hd__mux2_1
XFILLER_89_408 VGND VGND VPWR VPWR sky130_fd_sc_hd__fill_1
Xclkbuf_leaf_6_clk clkbuf_leaf_9_clk/A VGND VGND VPWR VPWR _6339_/CLK sky130_fd_sc_hd__clkbuf_8
Xhold659 _5990_/Q VGND VGND VPWR VPWR hold659/X sky130_fd_sc_hd__dlygate4sd3_1
Xhold648 _5054_/X VGND VGND VPWR VPWR _6347_/D sky130_fd_sc_hd__dlygate4sd3_1
Xhold2016 _2694_/X VGND VGND VPWR VPWR _5255_/D sky130_fd_sc_hd__dlygate4sd3_1
Xhold2005 _5062_/X VGND VGND VPWR VPWR _6354_/D sky130_fd_sc_hd__dlygate4sd3_1
Xhold2027 _5841_/Q VGND VGND VPWR VPWR _3854_/B1 sky130_fd_sc_hd__dlygate4sd3_1
X_3375_ _3375_/A1 _4457_/S _3373_/X _3374_/X VGND VGND VPWR VPWR _3375_/X sky130_fd_sc_hd__o22a_1
X_6163_ _6382_/CLK _6163_/D VGND VGND VPWR VPWR _6163_/Q sky130_fd_sc_hd__dfxtp_1
XANTENNA__4782__S0 _4778_/S VGND VGND VPWR VPWR sky130_fd_sc_hd__diode_2
XTAP_TAPCELL_ROW_127_2210 VGND VPWR sky130_fd_sc_hd__tapvpwrvgnd_1
XFILLER_111_273 VGND VGND VPWR VPWR sky130_fd_sc_hd__fill_1
Xhold1304 _3572_/X VGND VGND VPWR VPWR _5609_/D sky130_fd_sc_hd__dlygate4sd3_1
Xhold2038 _6394_/Q VGND VGND VPWR VPWR _3945_/A sky130_fd_sc_hd__dlygate4sd3_1
X_6094_ _6094_/CLK _6094_/D VGND VGND VPWR VPWR _6094_/Q sky130_fd_sc_hd__dfxtp_1
X_5114_ _2649_/A _3312_/Y _3331_/X _3972_/B _5112_/X VGND VGND VPWR VPWR _5114_/X
+ sky130_fd_sc_hd__a221o_1
Xhold1315 _5206_/X VGND VGND VPWR VPWR _6408_/D sky130_fd_sc_hd__dlygate4sd3_1
Xhold2049 _5434_/Q VGND VGND VPWR VPWR _5211_/A0 sky130_fd_sc_hd__dlygate4sd3_1
XFILLER_85_669 VGND VGND VPWR VPWR sky130_fd_sc_hd__fill_2
XFILLER_73_809 VPWR VGND VPWR VGND sky130_ef_sc_hd__decap_40_12
X_5045_ hold299/X _5045_/A1 _5047_/S VGND VGND VPWR VPWR _5045_/X sky130_fd_sc_hd__mux2_1
Xhold1337 _4491_/X VGND VGND VPWR VPWR _6097_/D sky130_fd_sc_hd__dlygate4sd3_1
Xhold1359 _5975_/Q VGND VGND VPWR VPWR _4329_/A1 sky130_fd_sc_hd__dlygate4sd3_1
Xhold1348 _5782_/Q VGND VGND VPWR VPWR _4135_/A0 sky130_fd_sc_hd__dlygate4sd3_1
Xhold1326 _3675_/X VGND VGND VPWR VPWR _5698_/D sky130_fd_sc_hd__dlygate4sd3_1
XANTENNA_fanout184_A _5267_/Q VGND VGND VPWR VPWR sky130_fd_sc_hd__diode_2
XTAP_TAPCELL_ROW_0_301 VGND VPWR sky130_fd_sc_hd__tapvpwrvgnd_1
XFILLER_27_39 VGND VGND VPWR VPWR sky130_fd_sc_hd__fill_1
XFILLER_65_371 VGND VGND VPWR VPWR sky130_fd_sc_hd__fill_2
XFILLER_65_360 VGND VGND VPWR VPWR sky130_fd_sc_hd__fill_2
XFILLER_38_585 VGND VGND VPWR VPWR sky130_fd_sc_hd__fill_2
XFILLER_26_769 VPWR VGND VPWR VGND sky130_ef_sc_hd__decap_40_12
XTAP_TAPCELL_ROW_105_1873 VGND VPWR sky130_fd_sc_hd__tapvpwrvgnd_1
XFILLER_80_363 VGND VGND VPWR VPWR sky130_fd_sc_hd__fill_1
X_5947_ _6339_/CLK _5947_/D VGND VGND VPWR VPWR _5947_/Q sky130_fd_sc_hd__dfxtp_1
XFILLER_43_38 VGND VGND VPWR VPWR sky130_fd_sc_hd__fill_1
XFILLER_138_115 VGND VGND VPWR VPWR sky130_fd_sc_hd__fill_1
X_5878_ _6098_/CLK _5878_/D VGND VGND VPWR VPWR _5878_/Q sky130_fd_sc_hd__dfxtp_1
XFILLER_21_441 VGND VGND VPWR VPWR sky130_fd_sc_hd__fill_4
XTAP_TAPCELL_ROW_138_2383 VGND VPWR sky130_fd_sc_hd__tapvpwrvgnd_1
XTAP_TAPCELL_ROW_138_2372 VGND VPWR sky130_fd_sc_hd__tapvpwrvgnd_1
X_4829_ _5225_/B _4842_/B VGND VGND VPWR VPWR _4841_/S sky130_fd_sc_hd__or2_4
XFILLER_21_485 VPWR VGND VPWR VGND sky130_ef_sc_hd__decap_40_12
XANTENNA__3178__B1 _5085_/A VGND VGND VPWR VPWR sky130_fd_sc_hd__diode_2
XFILLER_107_513 VPWR VGND VPWR VGND sky130_ef_sc_hd__decap_40_12
XFILLER_5_629 VPWR VGND VPWR VGND sky130_ef_sc_hd__decap_40_12
XFILLER_135_833 VGND VGND VPWR VPWR sky130_fd_sc_hd__fill_4
XFILLER_4_128 VGND VGND VPWR VPWR sky130_fd_sc_hd__fill_1
XFILLER_107_557 VGND VGND VPWR VPWR sky130_fd_sc_hd__fill_2
XTAP_TAPCELL_ROW_8_423 VGND VPWR sky130_fd_sc_hd__tapvpwrvgnd_1
XANTENNA_fanout97_A _5830_/Q VGND VGND VPWR VPWR sky130_fd_sc_hd__diode_2
XFILLER_103_741 VPWR VGND VPWR VGND sky130_ef_sc_hd__decap_40_12
XFILLER_68_57 VGND VGND VPWR VPWR sky130_fd_sc_hd__fill_1
XFILLER_0_345 VGND VGND VPWR VPWR sky130_fd_sc_hd__fill_1
XFILLER_103_785 VPWR VGND VPWR VGND sky130_ef_sc_hd__decap_40_12
XFILLER_49_839 VGND VGND VPWR VPWR sky130_fd_sc_hd__fill_1
XANTENNA__3350__B1 _5201_/B VGND VGND VPWR VPWR sky130_fd_sc_hd__diode_2
XFILLER_124_41 VGND VGND VPWR VPWR sky130_fd_sc_hd__fill_2
XFILLER_102_295 VPWR VGND VPWR VGND sky130_ef_sc_hd__decap_40_12
XFILLER_75_124 VPWR VGND VPWR VGND sky130_ef_sc_hd__decap_40_12
XFILLER_64_809 VGND VGND VPWR VPWR sky130_fd_sc_hd__fill_2
XANTENNA__4973__S _4974_/S VGND VGND VPWR VPWR sky130_fd_sc_hd__diode_2
XFILLER_124_85 VGND VGND VPWR VPWR sky130_fd_sc_hd__fill_2
Xhold1871 _5571_/Q VGND VGND VPWR VPWR _3528_/A1 sky130_fd_sc_hd__dlygate4sd3_1
Xhold1860 _4858_/X VGND VGND VPWR VPWR _6209_/D sky130_fd_sc_hd__dlygate4sd3_1
XFILLER_91_617 VPWR VGND VPWR VGND sky130_ef_sc_hd__decap_40_12
XTAP_TAPCELL_ROW_67_1301 VGND VPWR sky130_fd_sc_hd__tapvpwrvgnd_1
Xhold1893 _3515_/X VGND VGND VPWR VPWR _5559_/D sky130_fd_sc_hd__dlygate4sd3_1
XANTENNA__4850__A0 _4889_/A1 VGND VGND VPWR VPWR sky130_fd_sc_hd__diode_2
XANTENNA__3589__S _3595_/S VGND VGND VPWR VPWR sky130_fd_sc_hd__diode_2
XTAP_TAPCELL_ROW_67_1312 VGND VPWR sky130_fd_sc_hd__tapvpwrvgnd_1
XFILLER_17_725 VGND VGND VPWR VPWR sky130_fd_sc_hd__fill_2
Xhold1882 _3763_/X VGND VGND VPWR VPWR _5774_/D sky130_fd_sc_hd__dlygate4sd3_1
XANTENNA__3653__A1 _4488_/A0 VGND VGND VPWR VPWR sky130_fd_sc_hd__diode_2
XFILLER_17_61 VGND VGND VPWR VPWR sky130_fd_sc_hd__fill_2
XTAP_TAPCELL_ROW_80_1501 VGND VPWR sky130_fd_sc_hd__tapvpwrvgnd_1
XFILLER_25_780 VGND VGND VPWR VPWR sky130_fd_sc_hd__fill_4
XANTENNA__6262__Q _6262_/Q VGND VGND VPWR VPWR sky130_fd_sc_hd__diode_2
XANTENNA__4602__B1 _4811_/C1 VGND VGND VPWR VPWR sky130_fd_sc_hd__diode_2
XFILLER_8_401 VPWR VGND VPWR VGND sky130_ef_sc_hd__decap_40_12
XFILLER_8_445 VPWR VGND VPWR VGND sky130_ef_sc_hd__decap_40_12
XFILLER_138_671 VGND VGND VPWR VPWR sky130_fd_sc_hd__fill_1
XFILLER_126_811 VGND VGND VPWR VPWR sky130_fd_sc_hd__fill_1
XFILLER_69_8 VGND VGND VPWR VPWR sky130_fd_sc_hd__fill_1
XANTENNA__4213__S _4213_/S VGND VGND VPWR VPWR sky130_fd_sc_hd__diode_2
XFILLER_8_489 VPWR VGND VPWR VGND sky130_ef_sc_hd__decap_40_12
XFILLER_125_310 VGND VGND VPWR VPWR sky130_fd_sc_hd__fill_4
XTAP_TAPCELL_ROW_78_1463 VGND VPWR sky130_fd_sc_hd__tapvpwrvgnd_1
XFILLER_113_505 VPWR VGND VPWR VGND sky130_ef_sc_hd__decap_40_12
XTAP_TAPCELL_ROW_78_1474 VGND VPWR sky130_fd_sc_hd__tapvpwrvgnd_1
XTAP_TAPCELL_ROW_91_1663 VGND VPWR sky130_fd_sc_hd__tapvpwrvgnd_1
XFILLER_3_194 VGND VGND VPWR VPWR sky130_fd_sc_hd__fill_1
X_3160_ _3160_/A _3160_/B _3160_/C _3160_/D VGND VGND VPWR VPWR _3160_/Y sky130_fd_sc_hd__nor4_1
X_3091_ _6242_/Q _6218_/Q _3091_/S VGND VGND VPWR VPWR _3091_/X sky130_fd_sc_hd__mux2_1
XANTENNA__4883__S _4893_/S VGND VGND VPWR VPWR sky130_fd_sc_hd__diode_2
XFILLER_66_113 VGND VGND VPWR VPWR sky130_fd_sc_hd__fill_8
XFILLER_55_809 VPWR VGND VPWR VGND sky130_ef_sc_hd__decap_40_12
Xhold1 hold1/A VGND VGND VPWR VPWR hold1/X sky130_fd_sc_hd__dlygate4sd3_1
XFILLER_39_327 VGND VGND VPWR VPWR sky130_fd_sc_hd__fill_1
XANTENNA__3499__S _3503_/S VGND VGND VPWR VPWR sky130_fd_sc_hd__diode_2
XANTENNA__4841__A0 _4906_/A0 VGND VGND VPWR VPWR sky130_fd_sc_hd__diode_2
XANTENNA__3644__A1 _5213_/A1 VGND VGND VPWR VPWR sky130_fd_sc_hd__diode_2
XFILLER_74_190 VGND VGND VPWR VPWR sky130_fd_sc_hd__fill_2
XFILLER_62_330 VGND VGND VPWR VPWR sky130_fd_sc_hd__fill_2
XPHY_EDGE_ROW_8_Right_8 VGND VGND VPWR VPWR sky130_fd_sc_hd__decap_3
X_5801_ _6122_/CLK _5801_/D VGND VGND VPWR VPWR _5801_/Q sky130_fd_sc_hd__dfxtp_1
X_3993_ _5112_/B _3993_/B _3993_/C VGND VGND VPWR VPWR _3993_/Y sky130_fd_sc_hd__nor3_1
X_5732_ _5908_/CLK _5732_/D VGND VGND VPWR VPWR _5732_/Q sky130_fd_sc_hd__dfxtp_1
X_2944_ _3031_/A1 _2943_/X _2942_/X _3089_/C1 VGND VGND VPWR VPWR _2944_/X sky130_fd_sc_hd__o211a_1
XFILLER_13_19 VGND VGND VPWR VPWR sky130_fd_sc_hd__fill_2
XTAP_TAPCELL_ROW_33_789 VGND VPWR sky130_fd_sc_hd__tapvpwrvgnd_1
X_2875_ _5541_/Q _5565_/Q _3051_/S VGND VGND VPWR VPWR _2876_/B sky130_fd_sc_hd__mux2_1
X_5663_ _5850_/CLK hold15/X VGND VGND VPWR VPWR hold14/A sky130_fd_sc_hd__dfxtp_1
XFILLER_31_783 VGND VGND VPWR VPWR sky130_fd_sc_hd__fill_1
XFILLER_129_671 VGND VGND VPWR VPWR sky130_fd_sc_hd__fill_1
X_5594_ _6292_/CLK _5594_/D VGND VGND VPWR VPWR _5594_/Q sky130_fd_sc_hd__dfxtp_1
X_4614_ _5604_/Q _5685_/Q _6091_/Q _5871_/Q _4778_/S _4794_/A VGND VGND VPWR VPWR
+ _4614_/X sky130_fd_sc_hd__mux4_1
XTAP_TAPCELL_ROW_13_491 VGND VPWR sky130_fd_sc_hd__tapvpwrvgnd_1
XFILLER_135_129 VGND VGND VPWR VPWR sky130_fd_sc_hd__fill_1
XFILLER_128_170 VGND VGND VPWR VPWR sky130_fd_sc_hd__fill_1
X_4545_ hold779/X _5814_/Q _4547_/S VGND VGND VPWR VPWR _4545_/X sky130_fd_sc_hd__mux2_1
XFILLER_117_833 VGND VGND VPWR VPWR sky130_fd_sc_hd__fill_4
XANTENNA__2907__B1 _3085_/A VGND VGND VPWR VPWR sky130_fd_sc_hd__diode_2
Xhold401 _5962_/Q VGND VGND VPWR VPWR hold401/X sky130_fd_sc_hd__dlygate4sd3_1
XFILLER_116_365 VGND VGND VPWR VPWR sky130_fd_sc_hd__fill_1
Xhold412 _4879_/X VGND VGND VPWR VPWR _6229_/D sky130_fd_sc_hd__dlygate4sd3_1
Xhold423 _5865_/Q VGND VGND VPWR VPWR hold423/X sky130_fd_sc_hd__dlygate4sd3_1
Xhold445 _5934_/Q VGND VGND VPWR VPWR hold445/X sky130_fd_sc_hd__dlygate4sd3_1
Xhold434 _4512_/X VGND VGND VPWR VPWR _6116_/D sky130_fd_sc_hd__dlygate4sd3_1
XFILLER_132_825 VPWR VGND VPWR VGND sky130_ef_sc_hd__decap_40_12
XTAP_TAPCELL_ROW_133_2291 VGND VPWR sky130_fd_sc_hd__tapvpwrvgnd_1
Xhold467 _5495_/Q VGND VGND VPWR VPWR hold467/X sky130_fd_sc_hd__dlygate4sd3_1
Xhold478 _4530_/X VGND VGND VPWR VPWR _6132_/D sky130_fd_sc_hd__dlygate4sd3_1
Xhold456 _2954_/X VGND VGND VPWR VPWR _5290_/D sky130_fd_sc_hd__dlygate4sd3_1
X_4476_ _4476_/A0 _5210_/A1 _4482_/S VGND VGND VPWR VPWR _4476_/X sky130_fd_sc_hd__mux2_1
X_6215_ _6237_/CLK _6215_/D VGND VGND VPWR VPWR _6215_/Q sky130_fd_sc_hd__dfxtp_1
X_3427_ hold552/X _4883_/A1 _3437_/S VGND VGND VPWR VPWR _3427_/X sky130_fd_sc_hd__mux2_1
Xhold489 _6341_/Q VGND VGND VPWR VPWR hold489/X sky130_fd_sc_hd__dlygate4sd3_1
XPHY_EDGE_ROW_39_Right_39 VGND VGND VPWR VPWR sky130_fd_sc_hd__decap_3
X_6146_ _6146_/CLK _6146_/D VGND VGND VPWR VPWR _6146_/Q sky130_fd_sc_hd__dfxtp_1
X_3358_ _3358_/A1 _5035_/C _5201_/B _5434_/Q VGND VGND VPWR VPWR _3358_/X sky130_fd_sc_hd__a22o_1
Xhold1123 _4471_/X VGND VGND VPWR VPWR _6079_/D sky130_fd_sc_hd__dlygate4sd3_1
Xhold1101 _3743_/X VGND VGND VPWR VPWR _5757_/D sky130_fd_sc_hd__dlygate4sd3_1
XFILLER_85_444 VGND VGND VPWR VPWR sky130_fd_sc_hd__fill_4
Xhold1112 _6203_/Q VGND VGND VPWR VPWR _4851_/A1 sky130_fd_sc_hd__dlygate4sd3_1
XANTENNA__3883__A1 _4958_/A0 VGND VGND VPWR VPWR sky130_fd_sc_hd__diode_2
XFILLER_57_113 VGND VGND VPWR VPWR sky130_fd_sc_hd__fill_4
X_3289_ hold970/X _4887_/A1 _3295_/S VGND VGND VPWR VPWR _3289_/X sky130_fd_sc_hd__mux2_1
XANTENNA_fanout187_X _3050_/A VGND VGND VPWR VPWR sky130_fd_sc_hd__diode_2
X_6077_ _6429_/CLK _6077_/D VGND VGND VPWR VPWR _6077_/Q sky130_fd_sc_hd__dfxtp_1
Xhold1145 _4885_/X VGND VGND VPWR VPWR _6234_/D sky130_fd_sc_hd__dlygate4sd3_1
XTAP_TAPCELL_ROW_107_1902 VGND VPWR sky130_fd_sc_hd__tapvpwrvgnd_1
Xhold1134 _6217_/Q VGND VGND VPWR VPWR _4866_/A1 sky130_fd_sc_hd__dlygate4sd3_1
XFILLER_100_755 VGND VGND VPWR VPWR sky130_fd_sc_hd__fill_1
XFILLER_73_606 VGND VGND VPWR VPWR sky130_fd_sc_hd__fill_8
Xhold1156 _6109_/Q VGND VGND VPWR VPWR _4505_/A0 sky130_fd_sc_hd__dlygate4sd3_1
Xhold1167 _6027_/Q VGND VGND VPWR VPWR _4388_/A1 sky130_fd_sc_hd__dlygate4sd3_1
Xhold1178 _5235_/X VGND VGND VPWR VPWR _6432_/D sky130_fd_sc_hd__dlygate4sd3_1
XANTENNA__4832__A0 _4445_/A VGND VGND VPWR VPWR sky130_fd_sc_hd__diode_2
X_5028_ _5027_/X _3972_/B _4010_/B _5026_/X VGND VGND VPWR VPWR _5029_/D sky130_fd_sc_hd__o2bb2a_1
XANTENNA__3635__A1 _3926_/A1 VGND VGND VPWR VPWR sky130_fd_sc_hd__diode_2
Xhold1189 _6108_/Q VGND VGND VPWR VPWR _4580_/A1 sky130_fd_sc_hd__dlygate4sd3_1
XFILLER_38_382 VGND VGND VPWR VPWR sky130_fd_sc_hd__fill_2
XTAP_TAPCELL_ROW_49_1042 VGND VPWR sky130_fd_sc_hd__tapvpwrvgnd_1
XTAP_TAPCELL_ROW_49_1031 VGND VPWR sky130_fd_sc_hd__tapvpwrvgnd_1
XFILLER_53_363 VGND VGND VPWR VPWR sky130_fd_sc_hd__fill_2
XFILLER_26_599 VGND VGND VPWR VPWR sky130_fd_sc_hd__fill_1
XFILLER_41_503 VGND VGND VPWR VPWR sky130_fd_sc_hd__fill_1
XTAP_TAPCELL_ROW_62_1231 VGND VPWR sky130_fd_sc_hd__tapvpwrvgnd_1
XPHY_EDGE_ROW_48_Right_48 VGND VGND VPWR VPWR sky130_fd_sc_hd__decap_3
XANTENNA__4899__A0 _4899_/A0 VGND VGND VPWR VPWR sky130_fd_sc_hd__diode_2
XFILLER_108_811 VGND VGND VPWR VPWR sky130_fd_sc_hd__fill_1
XANTENNA__4968__S _4974_/S VGND VGND VPWR VPWR sky130_fd_sc_hd__diode_2
XFILLER_135_641 VPWR VGND VPWR VGND sky130_ef_sc_hd__decap_40_12
XFILLER_119_192 VGND VGND VPWR VPWR sky130_fd_sc_hd__fill_2
XFILLER_135_685 VPWR VGND VPWR VGND sky130_ef_sc_hd__decap_40_12
XFILLER_107_387 VGND VGND VPWR VPWR sky130_fd_sc_hd__fill_4
XPHY_EDGE_ROW_57_Right_57 VGND VGND VPWR VPWR sky130_fd_sc_hd__decap_3
Xhold990 _3307_/X VGND VGND VPWR VPWR _5425_/D sky130_fd_sc_hd__dlygate4sd3_1
XFILLER_135_51 VGND VGND VPWR VPWR sky130_fd_sc_hd__fill_4
XFILLER_89_783 VGND VGND VPWR VPWR sky130_fd_sc_hd__fill_1
XTAP_TAPCELL_ROW_73_1393 VGND VPWR sky130_fd_sc_hd__tapvpwrvgnd_1
XFILLER_1_665 VGND VGND VPWR VPWR sky130_fd_sc_hd__fill_4
XFILLER_48_113 VGND VGND VPWR VPWR sky130_fd_sc_hd__fill_4
XFILLER_0_197 VGND VGND VPWR VPWR sky130_fd_sc_hd__fill_1
XFILLER_0_175 VGND VGND VPWR VPWR sky130_fd_sc_hd__fill_1
XFILLER_0_164 VGND VGND VPWR VPWR sky130_fd_sc_hd__fill_4
XANTENNA__5076__A0 _5232_/A0 VGND VGND VPWR VPWR sky130_fd_sc_hd__diode_2
XFILLER_64_606 VGND VGND VPWR VPWR sky130_fd_sc_hd__fill_8
XFILLER_37_809 VPWR VGND VPWR VGND sky130_ef_sc_hd__decap_40_12
XANTENNA__4823__A0 _4901_/A0 VGND VGND VPWR VPWR sky130_fd_sc_hd__diode_2
XANTENNA__3626__A1 _4521_/A1 VGND VGND VPWR VPWR sky130_fd_sc_hd__diode_2
XFILLER_91_447 VGND VGND VPWR VPWR sky130_fd_sc_hd__fill_1
XANTENNA__4208__S _4262_/S VGND VGND VPWR VPWR sky130_fd_sc_hd__diode_2
Xhold1690 _4969_/X VGND VGND VPWR VPWR _6302_/D sky130_fd_sc_hd__dlygate4sd3_1
XANTENNA__4435__C input4/X VGND VGND VPWR VPWR sky130_fd_sc_hd__diode_2
XPHY_EDGE_ROW_66_Right_66 VGND VGND VPWR VPWR sky130_fd_sc_hd__decap_3
XFILLER_71_182 VGND VGND VPWR VPWR sky130_fd_sc_hd__fill_4
XANTENNA__4732__A _4789_/A VGND VGND VPWR VPWR sky130_fd_sc_hd__diode_2
XFILLER_9_721 VGND VGND VPWR VPWR sky130_fd_sc_hd__fill_4
XFILLER_13_783 VGND VGND VPWR VPWR sky130_fd_sc_hd__fill_1
X_2660_ _3029_/A _2660_/B VGND VGND VPWR VPWR _2660_/X sky130_fd_sc_hd__xor2_1
XFILLER_9_765 VPWR VGND VPWR VGND sky130_ef_sc_hd__decap_40_12
XTAP_TAPCELL_ROW_30_748 VGND VPWR sky130_fd_sc_hd__tapvpwrvgnd_1
XANTENNA__4878__S _4880_/S VGND VGND VPWR VPWR sky130_fd_sc_hd__diode_2
XTAP_TAPCELL_ROW_10_450 VGND VPWR sky130_fd_sc_hd__tapvpwrvgnd_1
XFILLER_126_641 VGND VGND VPWR VPWR sky130_fd_sc_hd__fill_2
XFILLER_99_503 VGND VGND VPWR VPWR sky130_fd_sc_hd__fill_1
XPHY_EDGE_ROW_75_Right_75 VGND VGND VPWR VPWR sky130_fd_sc_hd__decap_3
XANTENNA__3562__A0 _4521_/A1 VGND VGND VPWR VPWR sky130_fd_sc_hd__diode_2
XFILLER_114_825 VPWR VGND VPWR VGND sky130_ef_sc_hd__decap_40_12
XFILLER_99_525 VPWR VGND VPWR VGND sky130_ef_sc_hd__decap_40_12
X_4330_ _4929_/A1 _4330_/A1 _4335_/S VGND VGND VPWR VPWR _5976_/D sky130_fd_sc_hd__mux2_1
XFILLER_113_346 VGND VGND VPWR VPWR sky130_fd_sc_hd__fill_1
X_4261_ hold97/A _5963_/Q _4262_/S VGND VGND VPWR VPWR _4261_/X sky130_fd_sc_hd__mux2_1
X_3212_ _5241_/A1 _3212_/A1 _3220_/S VGND VGND VPWR VPWR _5372_/D sky130_fd_sc_hd__mux2_1
XANTENNA_hold2231_A _5814_/Q VGND VGND VPWR VPWR sky130_fd_sc_hd__diode_2
X_6000_ _6349_/CLK _6000_/D VGND VGND VPWR VPWR _6000_/Q sky130_fd_sc_hd__dfxtp_1
X_4192_ _4251_/A _4192_/B VGND VGND VPWR VPWR _4192_/X sky130_fd_sc_hd__or2_1
XFILLER_39_113 VGND VGND VPWR VPWR sky130_fd_sc_hd__fill_4
XFILLER_95_753 VPWR VGND VPWR VGND sky130_ef_sc_hd__decap_40_12
XANTENNA__3370__X _3370_/X VGND VGND VPWR VPWR sky130_fd_sc_hd__diode_2
XFILLER_67_466 VGND VGND VPWR VPWR sky130_fd_sc_hd__fill_1
XFILLER_28_809 VGND VGND VPWR VPWR sky130_fd_sc_hd__fill_2
X_3143_ _2703_/B _4993_/S _5085_/A VGND VGND VPWR VPWR _3143_/Y sky130_fd_sc_hd__a21oi_1
X_3074_ _3072_/S _5319_/Q _3044_/A VGND VGND VPWR VPWR _3074_/X sky130_fd_sc_hd__a21bo_1
XFILLER_95_797 VPWR VGND VPWR VGND sky130_ef_sc_hd__decap_40_12
XPHY_EDGE_ROW_84_Right_84 VGND VGND VPWR VPWR sky130_fd_sc_hd__decap_3
XPHY_EDGE_ROW_19_Left_158 VGND VGND VPWR VPWR sky130_fd_sc_hd__decap_3
XFILLER_54_138 VGND VGND VPWR VPWR sky130_fd_sc_hd__fill_2
XFILLER_63_683 VGND VGND VPWR VPWR sky130_fd_sc_hd__fill_2
XANTENNA__4290__A1 _4980_/A1 VGND VGND VPWR VPWR sky130_fd_sc_hd__diode_2
XTAP_TAPCELL_ROW_102_1832 VGND VPWR sky130_fd_sc_hd__tapvpwrvgnd_1
XFILLER_50_311 VPWR VGND VPWR VGND sky130_ef_sc_hd__decap_40_12
XTAP_TAPCELL_ROW_18_572 VGND VPWR sky130_fd_sc_hd__tapvpwrvgnd_1
XFILLER_24_29 VGND VGND VPWR VPWR sky130_fd_sc_hd__fill_4
X_3976_ _3976_/A _5099_/D _3976_/C VGND VGND VPWR VPWR _3993_/B sky130_fd_sc_hd__and3_1
XANTENNA_fanout147_A _4713_/S VGND VGND VPWR VPWR sky130_fd_sc_hd__diode_2
XANTENNA__4042__A1 _4252_/A1 VGND VGND VPWR VPWR sky130_fd_sc_hd__diode_2
XFILLER_11_709 VPWR VGND VPWR VGND sky130_ef_sc_hd__decap_40_12
X_2927_ _6075_/Q _6367_/Q _2984_/S VGND VGND VPWR VPWR _2928_/B sky130_fd_sc_hd__mux2_1
XFILLER_50_388 VGND VGND VPWR VPWR sky130_fd_sc_hd__fill_2
X_5715_ _6122_/CLK _5715_/D VGND VGND VPWR VPWR _5715_/Q sky130_fd_sc_hd__dfxtp_1
XTAP_TAPCELL_ROW_135_2331 VGND VPWR sky130_fd_sc_hd__tapvpwrvgnd_1
XTAP_TAPCELL_ROW_135_2320 VGND VPWR sky130_fd_sc_hd__tapvpwrvgnd_1
X_5646_ _6297_/CLK _5646_/D VGND VGND VPWR VPWR _5646_/Q sky130_fd_sc_hd__dfxtp_1
X_2858_ _3031_/A1 _2857_/X _3075_/C1 VGND VGND VPWR VPWR _2858_/X sky130_fd_sc_hd__o21a_1
XPHY_EDGE_ROW_93_Right_93 VGND VGND VPWR VPWR sky130_fd_sc_hd__decap_3
XPHY_EDGE_ROW_28_Left_167 VGND VGND VPWR VPWR sky130_fd_sc_hd__decap_3
XFILLER_129_490 VPWR VGND VPWR VGND sky130_ef_sc_hd__decap_40_12
X_2789_ _5538_/Q _5562_/Q _3051_/S VGND VGND VPWR VPWR _2790_/B sky130_fd_sc_hd__mux2_1
XFILLER_117_641 VPWR VGND VPWR VGND sky130_ef_sc_hd__decap_40_12
Xhold220 _5414_/Q VGND VGND VPWR VPWR hold220/X sky130_fd_sc_hd__dlygate4sd3_1
X_5577_ _6146_/CLK _5577_/D VGND VGND VPWR VPWR _5577_/Q sky130_fd_sc_hd__dfxtp_1
XANTENNA__3002__C1 _3089_/C1 VGND VGND VPWR VPWR sky130_fd_sc_hd__diode_2
XANTENNA__3692__S _3698_/S VGND VGND VPWR VPWR sky130_fd_sc_hd__diode_2
XFILLER_117_685 VPWR VGND VPWR VGND sky130_ef_sc_hd__decap_40_12
XFILLER_104_313 VGND VGND VPWR VPWR sky130_fd_sc_hd__fill_8
Xhold242 _5759_/Q VGND VGND VPWR VPWR hold242/X sky130_fd_sc_hd__dlygate4sd3_1
X_4528_ hold730/X _4886_/A1 _4532_/S VGND VGND VPWR VPWR _6130_/D sky130_fd_sc_hd__mux2_1
Xhold253 _3886_/X VGND VGND VPWR VPWR _5866_/D sky130_fd_sc_hd__dlygate4sd3_1
XANTENNA_fanout102_X _5043_/A1 VGND VGND VPWR VPWR sky130_fd_sc_hd__diode_2
XFILLER_2_418 VGND VGND VPWR VPWR sky130_fd_sc_hd__fill_2
Xhold231 _4522_/X VGND VGND VPWR VPWR _6125_/D sky130_fd_sc_hd__dlygate4sd3_1
Xhold275 _3115_/X VGND VGND VPWR VPWR _5308_/D sky130_fd_sc_hd__dlygate4sd3_1
X_4459_ _4459_/A1 _4457_/S _4458_/X VGND VGND VPWR VPWR _4459_/X sky130_fd_sc_hd__o21a_1
Xhold286 _3383_/X VGND VGND VPWR VPWR _5442_/D sky130_fd_sc_hd__dlygate4sd3_1
Xhold264 _5657_/Q VGND VGND VPWR VPWR hold264/X sky130_fd_sc_hd__dlygate4sd3_1
XFILLER_132_699 VGND VGND VPWR VPWR sky130_fd_sc_hd__fill_1
XTAP_TAPCELL_ROW_113_1994 VGND VPWR sky130_fd_sc_hd__tapvpwrvgnd_1
XFILLER_104_357 VGND VGND VPWR VPWR sky130_fd_sc_hd__fill_2
Xhold297 _5929_/Q VGND VGND VPWR VPWR hold297/X sky130_fd_sc_hd__dlygate4sd3_1
X_6129_ _6129_/CLK _6129_/D VGND VGND VPWR VPWR _6129_/Q sky130_fd_sc_hd__dfxtp_1
XFILLER_58_444 VGND VGND VPWR VPWR sky130_fd_sc_hd__fill_1
XFILLER_19_809 VPWR VGND VPWR VGND sky130_ef_sc_hd__decap_40_12
XPHY_EDGE_ROW_37_Left_176 VGND VGND VPWR VPWR sky130_fd_sc_hd__decap_3
XFILLER_100_585 VGND VGND VPWR VPWR sky130_fd_sc_hd__fill_2
XANTENNA__3608__A1 _5208_/A1 VGND VGND VPWR VPWR sky130_fd_sc_hd__diode_2
XFILLER_54_661 VGND VGND VPWR VPWR sky130_fd_sc_hd__fill_1
XANTENNA__4281__A1 _5044_/A1 VGND VGND VPWR VPWR sky130_fd_sc_hd__diode_2
XFILLER_42_801 VGND VGND VPWR VPWR sky130_fd_sc_hd__fill_8
XANTENNA__3867__S _3869_/S VGND VGND VPWR VPWR sky130_fd_sc_hd__diode_2
XFILLER_14_525 VGND VGND VPWR VPWR sky130_fd_sc_hd__fill_4
XANTENNA__5230__A0 _5817_/Q VGND VGND VPWR VPWR sky130_fd_sc_hd__diode_2
XANTENNA__2771__S _3030_/S VGND VGND VPWR VPWR sky130_fd_sc_hd__diode_2
XFILLER_81_57 VGND VGND VPWR VPWR sky130_fd_sc_hd__fill_4
XFILLER_81_46 VGND VGND VPWR VPWR sky130_fd_sc_hd__fill_8
XFILLER_14_569 VPWR VGND VPWR VGND sky130_ef_sc_hd__decap_40_12
XPHY_EDGE_ROW_46_Left_185 VGND VGND VPWR VPWR sky130_fd_sc_hd__decap_3
XFILLER_10_753 VGND VGND VPWR VPWR sky130_fd_sc_hd__fill_2
XANTENNA__3168__A _5085_/A VGND VGND VPWR VPWR sky130_fd_sc_hd__diode_2
XFILLER_6_713 VPWR VGND VPWR VGND sky130_ef_sc_hd__decap_40_12
XFILLER_6_757 VPWR VGND VPWR VGND sky130_ef_sc_hd__decap_40_12
XTAP_TAPCELL_ROW_75_1422 VGND VPWR sky130_fd_sc_hd__tapvpwrvgnd_1
XFILLER_111_839 VGND VGND VPWR VPWR sky130_fd_sc_hd__fill_1
XFILLER_110_338 VGND VGND VPWR VPWR sky130_fd_sc_hd__fill_1
XPHY_EDGE_ROW_55_Left_194 VGND VGND VPWR VPWR sky130_fd_sc_hd__decap_3
XFILLER_1_473 VPWR VGND VPWR VGND sky130_ef_sc_hd__decap_40_12
XFILLER_92_701 VPWR VGND VPWR VGND sky130_ef_sc_hd__decap_40_12
XANTENNA__2946__S _3062_/S VGND VGND VPWR VPWR sky130_fd_sc_hd__diode_2
XFILLER_77_797 VPWR VGND VPWR VGND sky130_ef_sc_hd__decap_40_12
XFILLER_76_263 VGND VGND VPWR VPWR sky130_fd_sc_hd__fill_2
XFILLER_76_296 VGND VGND VPWR VPWR sky130_fd_sc_hd__fill_2
XFILLER_17_330 VGND VGND VPWR VPWR sky130_fd_sc_hd__fill_4
XFILLER_29_190 VGND VGND VPWR VPWR sky130_fd_sc_hd__fill_4
XTAP_TAPCELL_ROW_35_818 VGND VPWR sky130_fd_sc_hd__tapvpwrvgnd_1
XTAP_TAPCELL_ROW_35_829 VGND VPWR sky130_fd_sc_hd__tapvpwrvgnd_1
XTAP_TAPCELL_ROW_86_1595 VGND VPWR sky130_fd_sc_hd__tapvpwrvgnd_1
XTAP_TAPCELL_ROW_86_1584 VGND VPWR sky130_fd_sc_hd__tapvpwrvgnd_1
XTAP_TAPCELL_ROW_15_520 VGND VPWR sky130_fd_sc_hd__tapvpwrvgnd_1
X_3830_ input24/X _5045_/A1 _3835_/S VGND VGND VPWR VPWR _5829_/D sky130_fd_sc_hd__mux2_1
XANTENNA__4024__A1 _3172_/B VGND VGND VPWR VPWR sky130_fd_sc_hd__diode_2
XTAP_TAPCELL_ROW_15_531 VGND VPWR sky130_fd_sc_hd__tapvpwrvgnd_1
X_3761_ hold694/X _5042_/A1 _3766_/S VGND VGND VPWR VPWR _3761_/X sky130_fd_sc_hd__mux2_1
XANTENNA__3078__A _3092_/A VGND VGND VPWR VPWR sky130_fd_sc_hd__diode_2
X_5500_ _5583_/CLK hold11/X VGND VGND VPWR VPWR hold10/A sky130_fd_sc_hd__dfxtp_1
X_2712_ _4980_/A1 _2712_/A1 _2716_/S VGND VGND VPWR VPWR _2712_/X sky130_fd_sc_hd__mux2_1
XTAP_TAPCELL_ROW_117_2050 VGND VPWR sky130_fd_sc_hd__tapvpwrvgnd_1
XFILLER_72_3 VGND VGND VPWR VPWR sky130_fd_sc_hd__fill_1
XFILLER_9_573 VPWR VGND VPWR VGND sky130_ef_sc_hd__decap_40_12
X_3692_ _3692_/A0 _4958_/A0 _3698_/S VGND VGND VPWR VPWR _3692_/X sky130_fd_sc_hd__mux2_1
XTAP_TAPCELL_ROW_117_2061 VGND VPWR sky130_fd_sc_hd__tapvpwrvgnd_1
X_2643_ _3072_/S VGND VGND VPWR VPWR _3092_/A sky130_fd_sc_hd__inv_2
X_5431_ _6408_/CLK _5431_/D VGND VGND VPWR VPWR _5431_/Q sky130_fd_sc_hd__dfxtp_1
X_5362_ _6143_/CLK hold78/X VGND VGND VPWR VPWR hold77/A sky130_fd_sc_hd__dfxtp_1
XANTENNA__4401__S _4406_/S VGND VGND VPWR VPWR sky130_fd_sc_hd__diode_2
XTAP_TAPCELL_ROW_130_2250 VGND VPWR sky130_fd_sc_hd__tapvpwrvgnd_1
X_4313_ hold558/X _5045_/A1 _4315_/S VGND VGND VPWR VPWR _4313_/X sky130_fd_sc_hd__mux2_1
X_5293_ _6239_/CLK _5293_/D VGND VGND VPWR VPWR _5293_/Q sky130_fd_sc_hd__dfxtp_1
XFILLER_59_219 VGND VGND VPWR VPWR sky130_fd_sc_hd__fill_1
XFILLER_114_699 VGND VGND VPWR VPWR sky130_fd_sc_hd__fill_1
XFILLER_101_327 VGND VGND VPWR VPWR sky130_fd_sc_hd__fill_2
XFILLER_68_742 VGND VGND VPWR VPWR sky130_fd_sc_hd__fill_1
X_4244_ _5776_/Q _6034_/Q _5944_/Q _6315_/Q _4258_/S _4241_/A VGND VGND VPWR VPWR
+ _4244_/X sky130_fd_sc_hd__mux4_1
XANTENNA__4186__S1 _4241_/A VGND VGND VPWR VPWR sky130_fd_sc_hd__diode_2
XFILLER_95_561 VPWR VGND VPWR VGND sky130_ef_sc_hd__decap_40_12
XFILLER_67_252 VGND VGND VPWR VPWR sky130_fd_sc_hd__fill_2
X_4175_ _4205_/A _4170_/X _4172_/X _4174_/X VGND VGND VPWR VPWR _4175_/X sky130_fd_sc_hd__a22o_1
X_3126_ _3126_/A0 _5237_/A0 _3126_/S VGND VGND VPWR VPWR _3126_/X sky130_fd_sc_hd__mux2_1
XFILLER_83_767 VPWR VGND VPWR VGND sky130_ef_sc_hd__decap_40_12
XFILLER_83_745 VGND VGND VPWR VPWR sky130_fd_sc_hd__fill_4
X_3057_ _3086_/S _5282_/Q _3029_/A VGND VGND VPWR VPWR _3057_/X sky130_fd_sc_hd__a21bo_1
XFILLER_70_406 VGND VGND VPWR VPWR sky130_fd_sc_hd__fill_2
XFILLER_82_288 VGND VGND VPWR VPWR sky130_fd_sc_hd__fill_2
XFILLER_35_182 VGND VGND VPWR VPWR sky130_fd_sc_hd__fill_1
XFILLER_50_141 VGND VGND VPWR VPWR sky130_fd_sc_hd__fill_1
XFILLER_11_517 VPWR VGND VPWR VGND sky130_ef_sc_hd__decap_40_12
X_3959_ _3959_/A _4007_/A VGND VGND VPWR VPWR _5048_/A sky130_fd_sc_hd__or2_1
XANTENNA__3774__A0 _4982_/A1 VGND VGND VPWR VPWR sky130_fd_sc_hd__diode_2
XFILLER_137_725 VGND VGND VPWR VPWR sky130_fd_sc_hd__fill_2
XANTENNA__3526__A0 _4903_/A0 VGND VGND VPWR VPWR sky130_fd_sc_hd__diode_2
X_5629_ _6098_/CLK _5629_/D VGND VGND VPWR VPWR _5629_/Q sky130_fd_sc_hd__dfxtp_1
XFILLER_3_727 VGND VGND VPWR VPWR sky130_fd_sc_hd__fill_1
XTAP_TAPCELL_ROW_57_1152 VGND VPWR sky130_fd_sc_hd__tapvpwrvgnd_1
XFILLER_2_215 VGND VGND VPWR VPWR sky130_fd_sc_hd__fill_4
XFILLER_132_474 VGND VGND VPWR VPWR sky130_fd_sc_hd__fill_2
XFILLER_120_625 VPWR VGND VPWR VGND sky130_ef_sc_hd__decap_40_12
XANTENNA__3829__A1 _5044_/A1 VGND VGND VPWR VPWR sky130_fd_sc_hd__diode_2
XFILLER_120_669 VPWR VGND VPWR VGND sky130_ef_sc_hd__decap_40_12
XFILLER_76_57 VGND VGND VPWR VPWR sky130_fd_sc_hd__fill_2
XTAP_TAPCELL_ROW_70_1352 VGND VPWR sky130_fd_sc_hd__tapvpwrvgnd_1
XFILLER_59_797 VPWR VGND VPWR VGND sky130_ef_sc_hd__decap_40_12
XFILLER_18_105 VGND VGND VPWR VPWR sky130_fd_sc_hd__fill_1
XFILLER_19_617 VPWR VGND VPWR VGND sky130_ef_sc_hd__decap_40_12
XFILLER_73_222 VGND VGND VPWR VPWR sky130_fd_sc_hd__fill_2
XANTENNA__4981__S _4984_/S VGND VGND VPWR VPWR sky130_fd_sc_hd__diode_2
XFILLER_74_778 VPWR VGND VPWR VGND sky130_ef_sc_hd__decap_40_12
XANTENNA__4254__B2 _4149_/A VGND VGND VPWR VPWR sky130_fd_sc_hd__diode_2
XFILLER_92_56 VGND VGND VPWR VPWR sky130_fd_sc_hd__fill_1
XFILLER_14_311 VGND VGND VPWR VPWR sky130_fd_sc_hd__fill_1
XFILLER_27_683 VGND VGND VPWR VPWR sky130_fd_sc_hd__fill_1
XFILLER_14_344 VGND VGND VPWR VPWR sky130_fd_sc_hd__fill_1
XFILLER_14_377 VPWR VGND VPWR VGND sky130_ef_sc_hd__decap_40_12
XFILLER_30_837 VGND VGND VPWR VPWR sky130_fd_sc_hd__fill_4
XFILLER_128_725 VPWR VGND VPWR VGND sky130_ef_sc_hd__decap_40_12
XFILLER_128_769 VPWR VGND VPWR VGND sky130_ef_sc_hd__decap_40_12
XTAP_TAPCELL_ROW_40_898 VGND VPWR sky130_fd_sc_hd__tapvpwrvgnd_1
XANTENNA__4221__S _4221_/S VGND VGND VPWR VPWR sky130_fd_sc_hd__diode_2
XFILLER_6_587 VGND VGND VPWR VPWR sky130_fd_sc_hd__fill_1
XPHY_EDGE_ROW_63_Left_202 VGND VGND VPWR VPWR sky130_fd_sc_hd__decap_3
XFILLER_97_837 VGND VGND VPWR VPWR sky130_fd_sc_hd__fill_2
XFILLER_2_793 VPWR VGND VPWR VGND sky130_ef_sc_hd__decap_40_12
XANTENNA__4168__S1 _4212_/A VGND VGND VPWR VPWR sky130_fd_sc_hd__diode_2
XANTENNA__2676__S _5241_/S VGND VGND VPWR VPWR sky130_fd_sc_hd__diode_2
XFILLER_111_669 VGND VGND VPWR VPWR sky130_fd_sc_hd__fill_2
XFILLER_1_292 VGND VGND VPWR VPWR sky130_fd_sc_hd__fill_1
XTAP_TAPCELL_ROW_88_1624 VGND VPWR sky130_fd_sc_hd__tapvpwrvgnd_1
XTAP_TAPCELL_ROW_88_1613 VGND VPWR sky130_fd_sc_hd__tapvpwrvgnd_1
XFILLER_65_701 VGND VGND VPWR VPWR sky130_fd_sc_hd__fill_2
XANTENNA__5052__S _5059_/S VGND VGND VPWR VPWR sky130_fd_sc_hd__diode_2
XFILLER_2_65 VPWR VGND VPWR VGND sky130_ef_sc_hd__decap_40_12
XANTENNA__4891__S _4893_/S VGND VGND VPWR VPWR sky130_fd_sc_hd__diode_2
XFILLER_92_531 VGND VGND VPWR VPWR sky130_fd_sc_hd__fill_1
XFILLER_49_285 VGND VGND VPWR VPWR sky130_fd_sc_hd__fill_2
XFILLER_37_447 VGND VGND VPWR VPWR sky130_fd_sc_hd__fill_1
XFILLER_52_417 VGND VGND VPWR VPWR sky130_fd_sc_hd__fill_1
XFILLER_25_609 VGND VGND VPWR VPWR sky130_fd_sc_hd__fill_4
X_5980_ clkload7/A _5980_/D VGND VGND VPWR VPWR _5980_/Q sky130_fd_sc_hd__dfxtp_1
XPHY_EDGE_ROW_72_Left_211 VGND VGND VPWR VPWR sky130_fd_sc_hd__decap_3
X_4931_ hold825/X _4981_/A1 _4934_/S VGND VGND VPWR VPWR _4931_/X sky130_fd_sc_hd__mux2_1
X_4862_ _4901_/A0 _4862_/A1 _4867_/S VGND VGND VPWR VPWR _4862_/X sky130_fd_sc_hd__mux2_1
XANTENNA__4192__A _4251_/A VGND VGND VPWR VPWR sky130_fd_sc_hd__diode_2
X_3813_ input7/X _3813_/B VGND VGND VPWR VPWR _3818_/S sky130_fd_sc_hd__nand2_2
XFILLER_21_837 VGND VGND VPWR VPWR sky130_fd_sc_hd__fill_2
X_4793_ _5869_/Q _5860_/Q _4795_/S VGND VGND VPWR VPWR _4794_/B sky130_fd_sc_hd__mux2_1
XFILLER_119_725 VGND VGND VPWR VPWR sky130_fd_sc_hd__fill_2
X_3744_ _3744_/A0 _5080_/A0 _3745_/S VGND VGND VPWR VPWR _3744_/X sky130_fd_sc_hd__mux2_1
XFILLER_21_19 VGND VGND VPWR VPWR sky130_fd_sc_hd__fill_1
XTAP_TAPCELL_ROW_99_1786 VGND VPWR sky130_fd_sc_hd__tapvpwrvgnd_1
X_3675_ _5213_/A1 _3675_/A1 _3678_/S VGND VGND VPWR VPWR _3675_/X sky130_fd_sc_hd__mux2_1
XFILLER_133_216 VGND VGND VPWR VPWR sky130_fd_sc_hd__fill_1
X_5414_ _6222_/CLK _5414_/D VGND VGND VPWR VPWR _5414_/Q sky130_fd_sc_hd__dfxtp_1
XANTENNA__3508__A0 _4846_/A0 VGND VGND VPWR VPWR sky130_fd_sc_hd__diode_2
X_2626_ _5833_/Q VGND VGND VPWR VPWR _2626_/Y sky130_fd_sc_hd__inv_2
XPHY_EDGE_ROW_81_Left_220 VGND VGND VPWR VPWR sky130_fd_sc_hd__decap_3
X_6394_ _6394_/CLK _6394_/D VGND VGND VPWR VPWR _6394_/Q sky130_fd_sc_hd__dfxtp_1
XANTENNA__2731__A1 _3085_/A VGND VGND VPWR VPWR sky130_fd_sc_hd__diode_2
X_5345_ _5820_/CLK _5345_/D VGND VGND VPWR VPWR _5345_/Q sky130_fd_sc_hd__dfxtp_1
XFILLER_114_485 VPWR VGND VPWR VGND sky130_ef_sc_hd__decap_40_12
XFILLER_114_474 VGND VGND VPWR VPWR sky130_fd_sc_hd__fill_2
XFILLER_102_625 VPWR VGND VPWR VGND sky130_ef_sc_hd__decap_40_12
X_5276_ _6129_/CLK _5276_/D VGND VGND VPWR VPWR _5276_/Q sky130_fd_sc_hd__dfxtp_1
XFILLER_101_113 VGND VGND VPWR VPWR sky130_fd_sc_hd__fill_4
XFILLER_99_185 VGND VGND VPWR VPWR sky130_fd_sc_hd__fill_4
XFILLER_88_837 VGND VGND VPWR VPWR sky130_fd_sc_hd__fill_4
XANTENNA__4159__S1 _4178_/A VGND VGND VPWR VPWR sky130_fd_sc_hd__diode_2
XTAP_TAPCELL_ROW_110_1953 VGND VPWR sky130_fd_sc_hd__tapvpwrvgnd_1
XFILLER_102_669 VPWR VGND VPWR VGND sky130_ef_sc_hd__decap_40_12
XFILLER_101_135 VGND VGND VPWR VPWR sky130_fd_sc_hd__fill_1
XFILLER_101_124 VGND VGND VPWR VPWR sky130_fd_sc_hd__fill_2
X_4227_ _4263_/A _4227_/B VGND VGND VPWR VPWR _4227_/X sky130_fd_sc_hd__or2_1
XTAP_TAPCELL_ROW_52_1082 VGND VPWR sky130_fd_sc_hd__tapvpwrvgnd_1
XFILLER_68_594 VGND VGND VPWR VPWR sky130_fd_sc_hd__fill_1
X_4158_ _4264_/A1 _4157_/X _4205_/A VGND VGND VPWR VPWR _4158_/Y sky130_fd_sc_hd__o21ai_1
X_3109_ hold518/X _5234_/A0 _3112_/S VGND VGND VPWR VPWR _3109_/X sky130_fd_sc_hd__mux2_1
XFILLER_56_789 VPWR VGND VPWR VGND sky130_ef_sc_hd__decap_40_12
X_4089_ _4088_/X _4083_/X _4260_/S VGND VGND VPWR VPWR _4089_/X sky130_fd_sc_hd__mux2_1
XFILLER_102_55 VGND VGND VPWR VPWR sky130_fd_sc_hd__fill_2
XFILLER_102_33 VGND VGND VPWR VPWR sky130_fd_sc_hd__fill_2
XANTENNA__3210__S _3220_/S VGND VGND VPWR VPWR sky130_fd_sc_hd__diode_2
XANTENNA__2893__S1 _3005_/A VGND VGND VPWR VPWR sky130_fd_sc_hd__diode_2
XFILLER_12_837 VGND VGND VPWR VPWR sky130_fd_sc_hd__fill_2
XFILLER_24_697 VGND VGND VPWR VPWR sky130_fd_sc_hd__fill_2
XANTENNA__5197__C1 _5085_/A VGND VGND VPWR VPWR sky130_fd_sc_hd__diode_2
XANTENNA__3747__A0 _4976_/A1 VGND VGND VPWR VPWR sky130_fd_sc_hd__diode_2
XFILLER_7_318 VGND VGND VPWR VPWR sky130_fd_sc_hd__fill_1
XFILLER_11_30 VGND VGND VPWR VPWR sky130_fd_sc_hd__fill_1
XFILLER_124_249 VGND VGND VPWR VPWR sky130_fd_sc_hd__fill_1
XFILLER_11_74 VGND VGND VPWR VPWR sky130_fd_sc_hd__fill_1
XANTENNA__4829__X _4841_/S VGND VGND VPWR VPWR sky130_fd_sc_hd__diode_2
XFILLER_87_23 VPWR VGND VPWR VGND sky130_ef_sc_hd__decap_40_12
XFILLER_3_557 VGND VGND VPWR VPWR sky130_fd_sc_hd__fill_2
XANTENNA__4976__S _4984_/S VGND VGND VPWR VPWR sky130_fd_sc_hd__diode_2
XFILLER_2_3 VPWR VGND VPWR VGND sky130_ef_sc_hd__decap_40_12
XFILLER_133_783 VGND VGND VPWR VPWR sky130_fd_sc_hd__fill_1
XFILLER_105_474 VGND VGND VPWR VPWR sky130_fd_sc_hd__fill_1
XFILLER_79_837 VGND VGND VPWR VPWR sky130_fd_sc_hd__fill_2
XANTENNA_fanout82_X _4488_/A0 VGND VGND VPWR VPWR sky130_fd_sc_hd__diode_2
XANTENNA__4475__A1 _5209_/A1 VGND VGND VPWR VPWR sky130_fd_sc_hd__diode_2
XTAP_TAPCELL_ROW_6_395 VGND VPWR sky130_fd_sc_hd__tapvpwrvgnd_1
XTAP_TAPCELL_ROW_6_384 VGND VPWR sky130_fd_sc_hd__tapvpwrvgnd_1
XFILLER_19_447 VGND VGND VPWR VPWR sky130_fd_sc_hd__fill_1
XFILLER_46_255 VGND VGND VPWR VPWR sky130_fd_sc_hd__fill_1
XFILLER_36_82 VGND VGND VPWR VPWR sky130_fd_sc_hd__fill_2
XTAP_TAPCELL_ROW_83_1543 VGND VPWR sky130_fd_sc_hd__tapvpwrvgnd_1
XTAP_TAPCELL_ROW_45_979 VGND VPWR sky130_fd_sc_hd__tapvpwrvgnd_1
XTAP_TAPCELL_ROW_45_968 VGND VPWR sky130_fd_sc_hd__tapvpwrvgnd_1
XFILLER_15_653 VPWR VGND VPWR VGND sky130_ef_sc_hd__decap_40_12
XFILLER_70_781 VGND VGND VPWR VPWR sky130_fd_sc_hd__fill_2
XFILLER_15_697 VPWR VGND VPWR VGND sky130_ef_sc_hd__decap_40_12
XTAP_TAPCELL_ROW_25_670 VGND VPWR sky130_fd_sc_hd__tapvpwrvgnd_1
XTAP_TAPCELL_ROW_25_681 VGND VPWR sky130_fd_sc_hd__tapvpwrvgnd_1
XFILLER_30_645 VGND VGND VPWR VPWR sky130_fd_sc_hd__fill_2
Xinput13 s_axil_wdata[10] VGND VGND VPWR VPWR _4912_/A sky130_fd_sc_hd__buf_1
XFILLER_128_533 VPWR VGND VPWR VGND sky130_ef_sc_hd__decap_40_12
Xinput24 s_axil_wdata[6] VGND VGND VPWR VPWR input24/X sky130_fd_sc_hd__buf_1
XFILLER_7_841 VGND VGND VPWR VPWR sky130_fd_sc_hd__fill_1
Xhold819 _6214_/Q VGND VGND VPWR VPWR hold819/X sky130_fd_sc_hd__dlygate4sd3_1
Xhold808 _2897_/X VGND VGND VPWR VPWR _5288_/D sky130_fd_sc_hd__dlygate4sd3_1
XFILLER_6_362 VGND VGND VPWR VPWR sky130_fd_sc_hd__fill_2
X_3460_ hold317/X _4903_/A0 _3463_/S VGND VGND VPWR VPWR _3460_/X sky130_fd_sc_hd__mux2_1
XFILLER_131_709 VPWR VGND VPWR VGND sky130_ef_sc_hd__decap_40_12
XANTENNA__4886__S _4893_/S VGND VGND VPWR VPWR sky130_fd_sc_hd__diode_2
X_3391_ _5320_/Q _3391_/B _5321_/Q VGND VGND VPWR VPWR _4935_/A sky130_fd_sc_hd__or3b_4
XFILLER_111_422 VGND VGND VPWR VPWR sky130_fd_sc_hd__fill_1
X_5130_ _5160_/A _5130_/B VGND VGND VPWR VPWR _5130_/Y sky130_fd_sc_hd__nand2_1
XFILLER_35_3 VGND VGND VPWR VPWR sky130_fd_sc_hd__fill_8
Xhold2209 _5321_/Q VGND VGND VPWR VPWR hold2209/X sky130_fd_sc_hd__dlygate4sd3_1
X_5061_ _3317_/A _3317_/B _5207_/S VGND VGND VPWR VPWR _5061_/X sky130_fd_sc_hd__mux2_1
Xhold1508 _5784_/Q VGND VGND VPWR VPWR _4191_/A0 sky130_fd_sc_hd__dlygate4sd3_1
Xhold1519 _3215_/X VGND VGND VPWR VPWR _5375_/D sky130_fd_sc_hd__dlygate4sd3_1
X_4012_ _5010_/B _5013_/C _5010_/A VGND VGND VPWR VPWR _4012_/X sky130_fd_sc_hd__o21ba_1
XFILLER_77_391 VGND VGND VPWR VPWR sky130_fd_sc_hd__fill_1
XANTENNA_clkbuf_leaf_74_clk_A clkload1/A VGND VGND VPWR VPWR sky130_fd_sc_hd__diode_2
XFILLER_38_778 VPWR VGND VPWR VGND sky130_ef_sc_hd__decap_40_12
XTAP_TAPCELL_ROW_125_2182 VGND VPWR sky130_fd_sc_hd__tapvpwrvgnd_1
XTAP_TAPCELL_ROW_125_2171 VGND VPWR sky130_fd_sc_hd__tapvpwrvgnd_1
XFILLER_92_372 VGND VGND VPWR VPWR sky130_fd_sc_hd__fill_4
X_5963_ _6334_/CLK _5963_/D VGND VGND VPWR VPWR _5963_/Q sky130_fd_sc_hd__dfxtp_1
XFILLER_25_417 VPWR VGND VPWR VGND sky130_ef_sc_hd__decap_40_12
X_4914_ _4914_/A _4922_/B _4922_/C VGND VGND VPWR VPWR _4914_/X sky130_fd_sc_hd__or3_1
XANTENNA__3030__S _3030_/S VGND VGND VPWR VPWR sky130_fd_sc_hd__diode_2
XFILLER_80_589 VGND VGND VPWR VPWR sky130_fd_sc_hd__fill_4
X_5894_ _6114_/CLK _5894_/D VGND VGND VPWR VPWR _5894_/Q sky130_fd_sc_hd__dfxtp_1
XANTENNA_clkbuf_leaf_89_clk_A clkload1/A VGND VGND VPWR VPWR sky130_fd_sc_hd__diode_2
X_4845_ _4445_/A _4845_/A1 _4854_/S VGND VGND VPWR VPWR _4845_/X sky130_fd_sc_hd__mux2_1
XFILLER_21_645 VGND VGND VPWR VPWR sky130_fd_sc_hd__fill_4
XANTENNA__4650__A _4789_/A VGND VGND VPWR VPWR sky130_fd_sc_hd__diode_2
X_4776_ _4791_/A1 _4775_/X _4791_/B1 VGND VGND VPWR VPWR _4776_/X sky130_fd_sc_hd__o21a_1
XANTENNA_clkbuf_leaf_12_clk_A clkbuf_leaf_9_clk/A VGND VGND VPWR VPWR sky130_fd_sc_hd__diode_2
X_3727_ hold875/X _4983_/A1 _3728_/S VGND VGND VPWR VPWR _3727_/X sky130_fd_sc_hd__mux2_1
XFILLER_134_525 VGND VGND VPWR VPWR sky130_fd_sc_hd__fill_4
X_3658_ _4483_/B _4955_/B VGND VGND VPWR VPWR _3667_/S sky130_fd_sc_hd__or2_4
XFILLER_134_569 VPWR VGND VPWR VGND sky130_ef_sc_hd__decap_40_12
XFILLER_88_601 VGND VGND VPWR VPWR sky130_fd_sc_hd__fill_2
X_3589_ _3589_/A0 _4958_/A0 _3595_/S VGND VGND VPWR VPWR _3589_/X sky130_fd_sc_hd__mux2_1
X_6377_ _6382_/CLK _6377_/D VGND VGND VPWR VPWR _6377_/Q sky130_fd_sc_hd__dfxtp_1
XTAP_TAPCELL_ROW_54_1111 VGND VPWR sky130_fd_sc_hd__tapvpwrvgnd_1
XANTENNA__4154__B1 _4272_/S VGND VGND VPWR VPWR sky130_fd_sc_hd__diode_2
XFILLER_115_783 VGND VGND VPWR VPWR sky130_fd_sc_hd__fill_1
XANTENNA_clkbuf_leaf_27_clk_A clkload3/A VGND VGND VPWR VPWR sky130_fd_sc_hd__diode_2
X_5328_ _6386_/CLK _5328_/D VGND VGND VPWR VPWR _5328_/Q sky130_fd_sc_hd__dfxtp_1
XFILLER_0_505 VPWR VGND VPWR VGND sky130_ef_sc_hd__decap_40_12
XFILLER_130_753 VGND VGND VPWR VPWR sky130_fd_sc_hd__fill_2
XANTENNA__5103__C1 _5034_/B VGND VGND VPWR VPWR sky130_fd_sc_hd__diode_2
XFILLER_102_488 VGND VGND VPWR VPWR sky130_fd_sc_hd__fill_2
XANTENNA__4097__A _4178_/A VGND VGND VPWR VPWR sky130_fd_sc_hd__diode_2
X_5259_ _6349_/CLK _5259_/D VGND VGND VPWR VPWR _5259_/Q sky130_fd_sc_hd__dfxtp_1
XFILLER_75_339 VGND VGND VPWR VPWR sky130_fd_sc_hd__fill_2
XTAP_TAPCELL_ROW_3_343 VGND VPWR sky130_fd_sc_hd__tapvpwrvgnd_1
XANTENNA__4209__A1 _4264_/A1 VGND VGND VPWR VPWR sky130_fd_sc_hd__diode_2
XFILLER_28_255 VGND VGND VPWR VPWR sky130_fd_sc_hd__fill_1
XFILLER_29_767 VPWR VGND VPWR VGND sky130_ef_sc_hd__decap_40_12
XFILLER_43_225 VGND VGND VPWR VPWR sky130_fd_sc_hd__fill_4
XFILLER_16_417 VGND VGND VPWR VPWR sky130_fd_sc_hd__fill_2
XFILLER_71_567 VGND VGND VPWR VPWR sky130_fd_sc_hd__fill_1
XFILLER_71_556 VGND VGND VPWR VPWR sky130_fd_sc_hd__fill_4
XFILLER_43_258 VGND VGND VPWR VPWR sky130_fd_sc_hd__fill_1
XANTENNA__4036__S _4237_/S VGND VGND VPWR VPWR sky130_fd_sc_hd__diode_2
XFILLER_71_578 VGND VGND VPWR VPWR sky130_fd_sc_hd__fill_8
XTAP_TAPCELL_ROW_65_1273 VGND VPWR sky130_fd_sc_hd__tapvpwrvgnd_1
XFILLER_52_781 VPWR VGND VPWR VGND sky130_ef_sc_hd__decap_40_12
XTAP_TAPCELL_ROW_42_927 VGND VPWR sky130_fd_sc_hd__tapvpwrvgnd_1
XFILLER_12_601 VPWR VGND VPWR VGND sky130_ef_sc_hd__decap_40_12
XFILLER_24_461 VGND VGND VPWR VPWR sky130_fd_sc_hd__fill_2
XFILLER_11_111 VGND VGND VPWR VPWR sky130_fd_sc_hd__fill_1
XFILLER_12_645 VPWR VGND VPWR VGND sky130_ef_sc_hd__decap_40_12
XANTENNA__4917__C1 _5176_/A VGND VGND VPWR VPWR sky130_fd_sc_hd__diode_2
XANTENNA__3196__A1 _5820_/Q VGND VGND VPWR VPWR sky130_fd_sc_hd__diode_2
XANTENNA__4393__A0 _4981_/A1 VGND VGND VPWR VPWR sky130_fd_sc_hd__diode_2
XFILLER_4_811 VGND VGND VPWR VPWR sky130_fd_sc_hd__fill_1
XFILLER_138_95 VGND VGND VPWR VPWR sky130_fd_sc_hd__fill_1
XFILLER_3_310 VPWR VGND VPWR VGND sky130_ef_sc_hd__decap_40_12
XFILLER_113_709 VPWR VGND VPWR VGND sky130_ef_sc_hd__decap_40_12
XFILLER_121_753 VPWR VGND VPWR VGND sky130_ef_sc_hd__decap_40_12
XFILLER_121_797 VPWR VGND VPWR VGND sky130_ef_sc_hd__decap_40_12
XFILLER_93_103 VGND VGND VPWR VPWR sky130_fd_sc_hd__fill_1
XFILLER_66_317 VGND VGND VPWR VPWR sky130_fd_sc_hd__fill_2
XFILLER_94_637 VGND VGND VPWR VPWR sky130_fd_sc_hd__fill_4
Xfanout190 _3086_/S VGND VGND VPWR VPWR _3030_/S sky130_fd_sc_hd__buf_4
XFILLER_59_391 VGND VGND VPWR VPWR sky130_fd_sc_hd__fill_1
XANTENNA__3120__A1 _5075_/A0 VGND VGND VPWR VPWR sky130_fd_sc_hd__diode_2
XANTENNA_clkload5_A clkload5/A VGND VGND VPWR VPWR sky130_fd_sc_hd__diode_2
XFILLER_62_501 VGND VGND VPWR VPWR sky130_fd_sc_hd__fill_2
XFILLER_34_214 VGND VGND VPWR VPWR sky130_fd_sc_hd__fill_1
X_2960_ _3094_/C1 _2955_/X _2957_/X _2959_/X VGND VGND VPWR VPWR _2960_/X sky130_fd_sc_hd__a22o_1
XFILLER_50_718 VGND VGND VPWR VPWR sky130_fd_sc_hd__fill_2
XFILLER_43_781 VGND VGND VPWR VPWR sky130_fd_sc_hd__fill_2
XFILLER_15_461 VPWR VGND VPWR VGND sky130_ef_sc_hd__decap_40_12
X_2891_ hold79/A _6223_/Q _3091_/S VGND VGND VPWR VPWR _2891_/X sky130_fd_sc_hd__mux2_1
X_4630_ _4799_/A _4630_/B VGND VGND VPWR VPWR _4630_/Y sky130_fd_sc_hd__nor2_1
XANTENNA__3187__A1 _5075_/A0 VGND VGND VPWR VPWR sky130_fd_sc_hd__diode_2
XFILLER_128_363 VGND VGND VPWR VPWR sky130_fd_sc_hd__fill_1
X_4561_ hold51/X _4906_/A0 _4561_/S VGND VGND VPWR VPWR hold52/A sky130_fd_sc_hd__mux2_1
XTAP_TAPCELL_ROW_96_1745 VGND VPWR sky130_fd_sc_hd__tapvpwrvgnd_1
XTAP_TAPCELL_ROW_96_1734 VGND VPWR sky130_fd_sc_hd__tapvpwrvgnd_1
X_6300_ _6300_/CLK _6300_/D VGND VGND VPWR VPWR _6300_/Q sky130_fd_sc_hd__dfxtp_1
Xhold616 _5544_/Q VGND VGND VPWR VPWR hold616/X sky130_fd_sc_hd__dlygate4sd3_1
XFILLER_116_525 VGND VGND VPWR VPWR sky130_fd_sc_hd__fill_4
Xhold605 _4560_/X VGND VGND VPWR VPWR _6160_/D sky130_fd_sc_hd__dlygate4sd3_1
X_4492_ _6406_/Q _4492_/A1 _4492_/S VGND VGND VPWR VPWR _4492_/X sky130_fd_sc_hd__mux2_1
X_3512_ _5233_/A0 _3512_/A1 _3516_/S VGND VGND VPWR VPWR _3512_/X sky130_fd_sc_hd__mux2_1
XFILLER_7_671 VGND VGND VPWR VPWR sky130_fd_sc_hd__fill_1
Xhold627 _5787_/Q VGND VGND VPWR VPWR hold627/X sky130_fd_sc_hd__dlygate4sd3_1
XFILLER_116_569 VPWR VGND VPWR VGND sky130_ef_sc_hd__decap_40_12
Xhold649 _5479_/Q VGND VGND VPWR VPWR hold649/X sky130_fd_sc_hd__dlygate4sd3_1
X_3443_ hold12/X _4886_/A1 _3450_/S VGND VGND VPWR VPWR hold13/A sky130_fd_sc_hd__mux2_1
Xhold638 _3537_/X VGND VGND VPWR VPWR _5580_/D sky130_fd_sc_hd__dlygate4sd3_1
X_6231_ _6239_/CLK _6231_/D VGND VGND VPWR VPWR _6231_/Q sky130_fd_sc_hd__dfxtp_1
XFILLER_131_517 VPWR VGND VPWR VGND sky130_ef_sc_hd__decap_40_12
X_6162_ _6292_/CLK _6162_/D VGND VGND VPWR VPWR _6162_/Q sky130_fd_sc_hd__dfxtp_1
XFILLER_112_753 VGND VGND VPWR VPWR sky130_fd_sc_hd__fill_2
X_3374_ _5092_/A0 _4994_/B _4445_/B _4906_/A0 _3801_/B VGND VGND VPWR VPWR _3374_/X
+ sky130_fd_sc_hd__a221o_1
Xhold2006 _6358_/Q VGND VGND VPWR VPWR _2651_/A sky130_fd_sc_hd__dlygate4sd3_1
XFILLER_69_122 VGND VGND VPWR VPWR sky130_fd_sc_hd__fill_4
XFILLER_69_111 VGND VGND VPWR VPWR sky130_fd_sc_hd__fill_1
Xhold2017 _6404_/Q VGND VGND VPWR VPWR _3955_/B sky130_fd_sc_hd__dlygate4sd3_1
XANTENNA__4782__S1 _4600_/A VGND VGND VPWR VPWR sky130_fd_sc_hd__diode_2
X_5113_ _3965_/A _4010_/A _5201_/B VGND VGND VPWR VPWR _5113_/X sky130_fd_sc_hd__o21a_1
XANTENNA__2793__S0 _3016_/S VGND VGND VPWR VPWR sky130_fd_sc_hd__diode_2
XTAP_TAPCELL_ROW_127_2211 VGND VPWR sky130_fd_sc_hd__tapvpwrvgnd_1
XTAP_TAPCELL_ROW_127_2200 VGND VPWR sky130_fd_sc_hd__tapvpwrvgnd_1
XFILLER_111_252 VGND VGND VPWR VPWR sky130_fd_sc_hd__fill_1
X_6093_ _6098_/CLK _6093_/D VGND VGND VPWR VPWR _6093_/Q sky130_fd_sc_hd__dfxtp_1
XFILLER_85_626 VGND VGND VPWR VPWR sky130_fd_sc_hd__fill_1
XFILLER_85_615 VGND VGND VPWR VPWR sky130_fd_sc_hd__fill_1
Xhold1316 _6176_/Q VGND VGND VPWR VPWR _4822_/A1 sky130_fd_sc_hd__dlygate4sd3_1
Xhold1305 _6195_/Q VGND VGND VPWR VPWR _4843_/A1 sky130_fd_sc_hd__dlygate4sd3_1
Xhold2028 _6357_/Q VGND VGND VPWR VPWR _3322_/B sky130_fd_sc_hd__dlygate4sd3_1
Xhold2039 _5151_/X VGND VGND VPWR VPWR _6394_/D sky130_fd_sc_hd__dlygate4sd3_1
XFILLER_84_136 VGND VGND VPWR VPWR sky130_fd_sc_hd__fill_4
XFILLER_69_199 VGND VGND VPWR VPWR sky130_fd_sc_hd__fill_4
Xhold1327 _5595_/Q VGND VGND VPWR VPWR _3556_/A1 sky130_fd_sc_hd__dlygate4sd3_1
X_5044_ hold35/X _5044_/A1 _5047_/S VGND VGND VPWR VPWR hold36/A sky130_fd_sc_hd__mux2_1
Xhold1349 _3772_/X VGND VGND VPWR VPWR _5782_/D sky130_fd_sc_hd__dlygate4sd3_1
Xhold1338 _5958_/Q VGND VGND VPWR VPWR _4310_/A0 sky130_fd_sc_hd__dlygate4sd3_1
XANTENNA__3111__A1 _5080_/A0 VGND VGND VPWR VPWR sky130_fd_sc_hd__diode_2
XFILLER_72_309 VGND VGND VPWR VPWR sky130_fd_sc_hd__fill_2
XTAP_TAPCELL_ROW_0_302 VGND VPWR sky130_fd_sc_hd__tapvpwrvgnd_1
XANTENNA__5240__S _5241_/S VGND VGND VPWR VPWR sky130_fd_sc_hd__diode_2
XANTENNA_fanout177_A _3027_/A VGND VGND VPWR VPWR sky130_fd_sc_hd__diode_2
XFILLER_81_821 VPWR VGND VPWR VGND sky130_ef_sc_hd__decap_40_12
XFILLER_80_342 VGND VGND VPWR VPWR sky130_fd_sc_hd__fill_4
XFILLER_80_320 VGND VGND VPWR VPWR sky130_fd_sc_hd__fill_4
XTAP_TAPCELL_ROW_105_1874 VGND VPWR sky130_fd_sc_hd__tapvpwrvgnd_1
X_5946_ _6334_/CLK _5946_/D VGND VGND VPWR VPWR _5946_/Q sky130_fd_sc_hd__dfxtp_1
X_5877_ _6097_/CLK _5877_/D VGND VGND VPWR VPWR _5877_/Q sky130_fd_sc_hd__dfxtp_1
XFILLER_34_781 VPWR VGND VPWR VGND sky130_ef_sc_hd__decap_40_12
X_4828_ _4906_/A0 _4828_/A1 _4828_/S VGND VGND VPWR VPWR _4828_/X sky130_fd_sc_hd__mux2_1
XANTENNA_fanout132_X _5232_/A0 VGND VGND VPWR VPWR sky130_fd_sc_hd__diode_2
XANTENNA__3695__S _3698_/S VGND VGND VPWR VPWR sky130_fd_sc_hd__diode_2
XTAP_TAPCELL_ROW_138_2384 VGND VPWR sky130_fd_sc_hd__tapvpwrvgnd_1
XTAP_TAPCELL_ROW_138_2373 VGND VPWR sky130_fd_sc_hd__tapvpwrvgnd_1
XANTENNA__4375__A0 _5046_/A1 VGND VGND VPWR VPWR sky130_fd_sc_hd__diode_2
XFILLER_21_497 VGND VGND VPWR VPWR sky130_fd_sc_hd__fill_4
XFILLER_107_503 VGND VGND VPWR VPWR sky130_fd_sc_hd__fill_1
X_4759_ _5682_/Q _5664_/Q _4808_/S VGND VGND VPWR VPWR _4760_/B sky130_fd_sc_hd__mux2_1
XFILLER_107_525 VPWR VGND VPWR VGND sky130_ef_sc_hd__decap_40_12
X_6429_ _6429_/CLK _6429_/D VGND VGND VPWR VPWR _6429_/Q sky130_fd_sc_hd__dfxtp_1
XFILLER_108_43 VGND VGND VPWR VPWR sky130_fd_sc_hd__fill_1
XTAP_TAPCELL_ROW_8_424 VGND VPWR sky130_fd_sc_hd__tapvpwrvgnd_1
XTAP_TAPCELL_ROW_8_413 VGND VPWR sky130_fd_sc_hd__tapvpwrvgnd_1
XFILLER_103_753 VPWR VGND VPWR VGND sky130_ef_sc_hd__decap_40_12
XFILLER_0_335 VGND VGND VPWR VPWR sky130_fd_sc_hd__fill_1
XFILLER_102_241 VGND VGND VPWR VPWR sky130_fd_sc_hd__fill_1
XFILLER_76_615 VGND VGND VPWR VPWR sky130_fd_sc_hd__fill_1
XFILLER_0_357 VGND VGND VPWR VPWR sky130_fd_sc_hd__fill_1
XFILLER_103_797 VPWR VGND VPWR VGND sky130_ef_sc_hd__decap_40_12
XANTENNA__3102__A1 _5239_/A1 VGND VGND VPWR VPWR sky130_fd_sc_hd__diode_2
Xhold1872 _3528_/X VGND VGND VPWR VPWR _5571_/D sky130_fd_sc_hd__dlygate4sd3_1
XANTENNA__2774__S _3091_/S VGND VGND VPWR VPWR sky130_fd_sc_hd__diode_2
XFILLER_75_169 VPWR VGND VPWR VGND sky130_ef_sc_hd__decap_40_12
Xhold1850 _4376_/X VGND VGND VPWR VPWR _6017_/D sky130_fd_sc_hd__dlygate4sd3_1
Xhold1861 _5703_/Q VGND VGND VPWR VPWR _3681_/A1 sky130_fd_sc_hd__dlygate4sd3_1
XFILLER_91_629 VPWR VGND VPWR VGND sky130_ef_sc_hd__decap_40_12
XTAP_TAPCELL_ROW_67_1302 VGND VPWR sky130_fd_sc_hd__tapvpwrvgnd_1
Xhold1883 _6169_/Q VGND VGND VPWR VPWR _5093_/A1 sky130_fd_sc_hd__dlygate4sd3_1
XTAP_TAPCELL_ROW_27_710 VGND VPWR sky130_fd_sc_hd__tapvpwrvgnd_1
Xhold1894 _5393_/Q VGND VGND VPWR VPWR _3352_/A1 sky130_fd_sc_hd__dlygate4sd3_1
XANTENNA__4842__X _4854_/S VGND VGND VPWR VPWR sky130_fd_sc_hd__diode_2
XTAP_TAPCELL_ROW_80_1502 VGND VPWR sky130_fd_sc_hd__tapvpwrvgnd_1
XANTENNA__4602__A1 _4811_/A1 VGND VGND VPWR VPWR sky130_fd_sc_hd__diode_2
XFILLER_44_589 VGND VGND VPWR VPWR sky130_fd_sc_hd__fill_4
XFILLER_17_84 VGND VGND VPWR VPWR sky130_fd_sc_hd__fill_1
XFILLER_32_729 VGND VGND VPWR VPWR sky130_fd_sc_hd__fill_4
XFILLER_8_413 VGND VGND VPWR VPWR sky130_fd_sc_hd__fill_4
XFILLER_12_475 VGND VGND VPWR VPWR sky130_fd_sc_hd__fill_1
XFILLER_8_457 VPWR VGND VPWR VGND sky130_ef_sc_hd__decap_40_12
XANTENNA__2916__A1 _3076_/A1 VGND VGND VPWR VPWR sky130_fd_sc_hd__diode_2
XTAP_TAPCELL_ROW_78_1464 VGND VPWR sky130_fd_sc_hd__tapvpwrvgnd_1
XTAP_TAPCELL_ROW_78_1475 VGND VPWR sky130_fd_sc_hd__tapvpwrvgnd_1
XFILLER_4_641 VGND VGND VPWR VPWR sky130_fd_sc_hd__fill_2
XFILLER_113_517 VPWR VGND VPWR VGND sky130_ef_sc_hd__decap_40_12
XFILLER_99_729 VPWR VGND VPWR VGND sky130_ef_sc_hd__decap_40_12
XTAP_TAPCELL_ROW_91_1664 VGND VPWR sky130_fd_sc_hd__tapvpwrvgnd_1
XFILLER_121_561 VPWR VGND VPWR VGND sky130_ef_sc_hd__decap_40_12
XFILLER_79_475 VGND VGND VPWR VPWR sky130_fd_sc_hd__fill_4
XFILLER_67_615 VGND VGND VPWR VPWR sky130_fd_sc_hd__fill_1
XFILLER_39_306 VGND VGND VPWR VPWR sky130_fd_sc_hd__fill_2
X_3090_ _3085_/X _3089_/X _2995_/A VGND VGND VPWR VPWR _3090_/Y sky130_fd_sc_hd__o21ai_1
Xhold2 hold2/A VGND VGND VPWR VPWR hold2/X sky130_fd_sc_hd__dlygate4sd3_1
XFILLER_67_659 VGND VGND VPWR VPWR sky130_fd_sc_hd__fill_1
XFILLER_67_648 VGND VGND VPWR VPWR sky130_fd_sc_hd__fill_1
XFILLER_54_309 VGND VGND VPWR VPWR sky130_fd_sc_hd__fill_4
XFILLER_75_681 VGND VGND VPWR VPWR sky130_fd_sc_hd__fill_1
XFILLER_75_670 VGND VGND VPWR VPWR sky130_fd_sc_hd__fill_2
XANTENNA__5164__A1_N _3958_/A VGND VGND VPWR VPWR sky130_fd_sc_hd__diode_2
XFILLER_63_821 VGND VGND VPWR VPWR sky130_fd_sc_hd__fill_1
XTAP_TAPCELL_ROW_122_2130 VGND VPWR sky130_fd_sc_hd__tapvpwrvgnd_1
XFILLER_62_342 VGND VGND VPWR VPWR sky130_fd_sc_hd__fill_1
X_3992_ _3988_/B _3958_/Y _3991_/X _5034_/B VGND VGND VPWR VPWR _5916_/D sky130_fd_sc_hd__o211a_1
X_5800_ _6121_/CLK _5800_/D VGND VGND VPWR VPWR _5800_/Q sky130_fd_sc_hd__dfxtp_1
XFILLER_23_707 VGND VGND VPWR VPWR sky130_fd_sc_hd__fill_1
XFILLER_23_729 VGND VGND VPWR VPWR sky130_fd_sc_hd__fill_4
X_2943_ hold339/X _5278_/Q _3030_/S VGND VGND VPWR VPWR _2943_/X sky130_fd_sc_hd__mux2_1
X_5731_ _5731_/CLK hold96/X VGND VGND VPWR VPWR hold95/A sky130_fd_sc_hd__dfxtp_1
XFILLER_16_781 VPWR VGND VPWR VGND sky130_ef_sc_hd__decap_40_12
XANTENNA__4404__S _4406_/S VGND VGND VPWR VPWR sky130_fd_sc_hd__diode_2
X_2874_ _3076_/A1 _2869_/X _2871_/X _2873_/X VGND VGND VPWR VPWR _2874_/X sky130_fd_sc_hd__a22o_1
X_5662_ _5682_/CLK _5662_/D VGND VGND VPWR VPWR _5662_/Q sky130_fd_sc_hd__dfxtp_1
XTAP_TAPCELL_ROW_100_1793 VGND VPWR sky130_fd_sc_hd__tapvpwrvgnd_1
X_5593_ _6298_/CLK _5593_/D VGND VGND VPWR VPWR _5593_/Q sky130_fd_sc_hd__dfxtp_1
X_4613_ _4791_/A1 _4612_/X _4792_/A1 VGND VGND VPWR VPWR _4613_/X sky130_fd_sc_hd__o21a_1
XTAP_TAPCELL_ROW_13_492 VGND VPWR sky130_fd_sc_hd__tapvpwrvgnd_1
X_4544_ hold353/X _4903_/A0 _4547_/S VGND VGND VPWR VPWR _4544_/X sky130_fd_sc_hd__mux2_1
XANTENNA__2907__A1 _3031_/A1 VGND VGND VPWR VPWR sky130_fd_sc_hd__diode_2
Xhold402 _4314_/X VGND VGND VPWR VPWR _5962_/D sky130_fd_sc_hd__dlygate4sd3_1
Xhold424 _3885_/X VGND VGND VPWR VPWR _5865_/D sky130_fd_sc_hd__dlygate4sd3_1
XANTENNA__3580__A1 _5212_/A1 VGND VGND VPWR VPWR sky130_fd_sc_hd__diode_2
Xhold413 _5716_/Q VGND VGND VPWR VPWR hold413/X sky130_fd_sc_hd__dlygate4sd3_1
Xhold435 _5679_/Q VGND VGND VPWR VPWR hold435/X sky130_fd_sc_hd__dlygate4sd3_1
XFILLER_132_837 VGND VGND VPWR VPWR sky130_fd_sc_hd__fill_4
XTAP_TAPCELL_ROW_133_2292 VGND VPWR sky130_fd_sc_hd__tapvpwrvgnd_1
X_6214_ _6238_/CLK _6214_/D VGND VGND VPWR VPWR _6214_/Q sky130_fd_sc_hd__dfxtp_1
Xhold468 _3445_/X VGND VGND VPWR VPWR _5495_/D sky130_fd_sc_hd__dlygate4sd3_1
XANTENNA__4204__S0 _4228_/S VGND VGND VPWR VPWR sky130_fd_sc_hd__diode_2
Xhold446 _4282_/X VGND VGND VPWR VPWR _5934_/D sky130_fd_sc_hd__dlygate4sd3_1
Xhold457 _5936_/Q VGND VGND VPWR VPWR hold457/X sky130_fd_sc_hd__dlygate4sd3_1
X_4475_ hold582/X _5209_/A1 _4482_/S VGND VGND VPWR VPWR _4475_/X sky130_fd_sc_hd__mux2_1
X_3426_ hold507/X _4882_/A1 _3437_/S VGND VGND VPWR VPWR _3426_/X sky130_fd_sc_hd__mux2_1
Xhold479 _6123_/Q VGND VGND VPWR VPWR hold479/X sky130_fd_sc_hd__dlygate4sd3_1
X_6145_ _6148_/CLK _6145_/D VGND VGND VPWR VPWR _6145_/Q sky130_fd_sc_hd__dfxtp_1
XFILLER_100_701 VPWR VGND VPWR VGND sky130_ef_sc_hd__decap_40_12
X_3357_ _5213_/A0 _3356_/X _3365_/S VGND VGND VPWR VPWR _3357_/X sky130_fd_sc_hd__mux2_1
X_6076_ _6429_/CLK _6076_/D VGND VGND VPWR VPWR _6076_/Q sky130_fd_sc_hd__dfxtp_1
Xhold1113 _4851_/X VGND VGND VPWR VPWR _6203_/D sky130_fd_sc_hd__dlygate4sd3_1
Xhold1102 _5769_/Q VGND VGND VPWR VPWR _3758_/A0 sky130_fd_sc_hd__dlygate4sd3_1
Xhold1124 _6280_/Q VGND VGND VPWR VPWR _4944_/A1 sky130_fd_sc_hd__dlygate4sd3_1
X_3288_ hold272/X _4899_/A0 _3295_/S VGND VGND VPWR VPWR _3288_/X sky130_fd_sc_hd__mux2_1
Xhold1135 _4866_/X VGND VGND VPWR VPWR _6217_/D sky130_fd_sc_hd__dlygate4sd3_1
X_5027_ _3326_/X _3327_/Y _3325_/X VGND VGND VPWR VPWR _5027_/X sky130_fd_sc_hd__a21o_1
XFILLER_57_169 VGND VGND VPWR VPWR sky130_fd_sc_hd__fill_2
Xhold1157 _4505_/X VGND VGND VPWR VPWR _6109_/D sky130_fd_sc_hd__dlygate4sd3_1
Xhold1146 _5768_/Q VGND VGND VPWR VPWR _3755_/A1 sky130_fd_sc_hd__dlygate4sd3_1
XTAP_TAPCELL_ROW_107_1903 VGND VPWR sky130_fd_sc_hd__tapvpwrvgnd_1
Xhold1179 _5684_/Q VGND VGND VPWR VPWR _3659_/A1 sky130_fd_sc_hd__dlygate4sd3_1
Xhold1168 _4388_/X VGND VGND VPWR VPWR _6027_/D sky130_fd_sc_hd__dlygate4sd3_1
XFILLER_54_27 VGND VGND VPWR VPWR sky130_fd_sc_hd__fill_1
XTAP_TAPCELL_ROW_49_1032 VGND VPWR sky130_fd_sc_hd__tapvpwrvgnd_1
XFILLER_38_394 VGND VGND VPWR VPWR sky130_fd_sc_hd__fill_1
XFILLER_53_375 VGND VGND VPWR VPWR sky130_fd_sc_hd__fill_4
XFILLER_80_172 VPWR VGND VPWR VGND sky130_ef_sc_hd__decap_40_12
XANTENNA__3399__A1 _4982_/A1 VGND VGND VPWR VPWR sky130_fd_sc_hd__diode_2
XFILLER_41_526 VGND VGND VPWR VPWR sky130_fd_sc_hd__fill_4
XTAP_TAPCELL_ROW_62_1232 VGND VPWR sky130_fd_sc_hd__tapvpwrvgnd_1
X_5929_ _6339_/CLK _5929_/D VGND VGND VPWR VPWR _5929_/Q sky130_fd_sc_hd__dfxtp_1
XFILLER_70_37 VGND VGND VPWR VPWR sky130_fd_sc_hd__fill_1
XFILLER_127_609 VGND VGND VPWR VPWR sky130_fd_sc_hd__fill_4
XANTENNA__3438__B _5069_/B VGND VGND VPWR VPWR sky130_fd_sc_hd__diode_2
XFILLER_119_171 VGND VGND VPWR VPWR sky130_fd_sc_hd__fill_1
XFILLER_5_405 VPWR VGND VPWR VGND sky130_ef_sc_hd__decap_40_12
XFILLER_135_653 VPWR VGND VPWR VGND sky130_ef_sc_hd__decap_40_12
XFILLER_134_141 VGND VGND VPWR VPWR sky130_fd_sc_hd__fill_4
XANTENNA__2769__S _3030_/S VGND VGND VPWR VPWR sky130_fd_sc_hd__diode_2
XANTENNA__3571__A1 _4961_/A0 VGND VGND VPWR VPWR sky130_fd_sc_hd__diode_2
XFILLER_5_449 VPWR VGND VPWR VGND sky130_ef_sc_hd__decap_40_12
XFILLER_135_697 VPWR VGND VPWR VGND sky130_ef_sc_hd__decap_40_12
XFILLER_123_837 VGND VGND VPWR VPWR sky130_fd_sc_hd__fill_2
XFILLER_102_3 VPWR VGND VPWR VGND sky130_ef_sc_hd__decap_40_12
XFILLER_79_57 VGND VGND VPWR VPWR sky130_fd_sc_hd__fill_4
Xhold980 _3560_/X VGND VGND VPWR VPWR _5599_/D sky130_fd_sc_hd__dlygate4sd3_1
Xhold991 _5603_/Q VGND VGND VPWR VPWR hold991/X sky130_fd_sc_hd__dlygate4sd3_1
XFILLER_103_561 VPWR VGND VPWR VGND sky130_ef_sc_hd__decap_40_12
XTAP_TAPCELL_ROW_73_1394 VGND VPWR sky130_fd_sc_hd__tapvpwrvgnd_1
XANTENNA__4984__S _4984_/S VGND VGND VPWR VPWR sky130_fd_sc_hd__diode_2
XANTENNA_input22_A s_axil_wdata[4] VGND VGND VPWR VPWR sky130_fd_sc_hd__diode_2
Xhold1680 _6369_/Q VGND VGND VPWR VPWR _5078_/A1 sky130_fd_sc_hd__dlygate4sd3_1
XFILLER_45_821 VPWR VGND VPWR VGND sky130_ef_sc_hd__decap_40_12
XFILLER_17_501 VGND VGND VPWR VPWR sky130_fd_sc_hd__fill_2
Xhold1691 _5572_/Q VGND VGND VPWR VPWR _3529_/A1 sky130_fd_sc_hd__dlygate4sd3_1
XFILLER_63_139 VGND VGND VPWR VPWR sky130_fd_sc_hd__fill_1
XFILLER_60_813 VPWR VGND VPWR VGND sky130_ef_sc_hd__decap_40_12
XFILLER_32_515 VGND VGND VPWR VPWR sky130_fd_sc_hd__fill_1
XANTENNA__4682__S0 _4773_/S VGND VGND VPWR VPWR sky130_fd_sc_hd__diode_2
XFILLER_9_777 VGND VGND VPWR VPWR sky130_fd_sc_hd__fill_4
XTAP_TAPCELL_ROW_30_749 VGND VPWR sky130_fd_sc_hd__tapvpwrvgnd_1
XFILLER_40_592 VGND VGND VPWR VPWR sky130_fd_sc_hd__fill_1
XTAP_TAPCELL_ROW_10_451 VGND VPWR sky130_fd_sc_hd__tapvpwrvgnd_1
XFILLER_126_697 VGND VGND VPWR VPWR sky130_fd_sc_hd__fill_2
XFILLER_114_837 VGND VGND VPWR VPWR sky130_fd_sc_hd__fill_4
XFILLER_99_537 VPWR VGND VPWR VGND sky130_ef_sc_hd__decap_40_12
XANTENNA__5055__S _5059_/S VGND VGND VPWR VPWR sky130_fd_sc_hd__diode_2
XFILLER_99_559 VGND VGND VPWR VPWR sky130_fd_sc_hd__fill_1
XFILLER_5_65 VGND VGND VPWR VPWR sky130_fd_sc_hd__fill_2
X_4260_ _4259_/X _4254_/X _4260_/S VGND VGND VPWR VPWR _4260_/X sky130_fd_sc_hd__mux2_1
X_3211_ _5228_/A0 hold793/X _3220_/S VGND VGND VPWR VPWR _3211_/X sky130_fd_sc_hd__mux2_1
X_4191_ _4191_/A0 _4191_/A1 _4250_/S VGND VGND VPWR VPWR _4192_/B sky130_fd_sc_hd__mux2_1
XFILLER_95_721 VGND VGND VPWR VPWR sky130_fd_sc_hd__fill_4
XFILLER_79_294 VGND VGND VPWR VPWR sky130_fd_sc_hd__fill_2
X_3142_ _5050_/B _5038_/A VGND VGND VPWR VPWR _4993_/S sky130_fd_sc_hd__nor2_4
XFILLER_39_125 VGND VGND VPWR VPWR sky130_fd_sc_hd__fill_4
XFILLER_95_765 VPWR VGND VPWR VGND sky130_ef_sc_hd__decap_40_12
XFILLER_94_253 VGND VGND VPWR VPWR sky130_fd_sc_hd__fill_4
XFILLER_39_158 VGND VGND VPWR VPWR sky130_fd_sc_hd__fill_1
X_3073_ _3092_/A _6434_/Q VGND VGND VPWR VPWR _3073_/X sky130_fd_sc_hd__and2_1
XANTENNA__4814__A1 _3278_/A VGND VGND VPWR VPWR sky130_fd_sc_hd__diode_2
XFILLER_36_810 VGND VGND VPWR VPWR sky130_fd_sc_hd__fill_2
XFILLER_62_150 VGND VGND VPWR VPWR sky130_fd_sc_hd__fill_1
XFILLER_35_353 VGND VGND VPWR VPWR sky130_fd_sc_hd__fill_2
XFILLER_50_323 VPWR VGND VPWR VGND sky130_ef_sc_hd__decap_40_12
XTAP_TAPCELL_ROW_18_573 VGND VPWR sky130_fd_sc_hd__tapvpwrvgnd_1
XFILLER_23_548 VGND VGND VPWR VPWR sky130_fd_sc_hd__fill_1
XTAP_TAPCELL_ROW_102_1833 VGND VPWR sky130_fd_sc_hd__tapvpwrvgnd_1
X_3975_ _3975_/A _5102_/A _3975_/C _3964_/B VGND VGND VPWR VPWR _3976_/C sky130_fd_sc_hd__or4b_1
XFILLER_50_367 VGND VGND VPWR VPWR sky130_fd_sc_hd__fill_2
XANTENNA__4673__S0 _4810_/S VGND VGND VPWR VPWR sky130_fd_sc_hd__diode_2
X_2926_ _5302_/Q _5375_/Q _5363_/Q _6144_/Q _2984_/S _2985_/A VGND VGND VPWR VPWR
+ _2926_/X sky130_fd_sc_hd__mux4_1
X_5714_ _5714_/CLK _5714_/D VGND VGND VPWR VPWR _5714_/Q sky130_fd_sc_hd__dfxtp_1
XTAP_TAPCELL_ROW_135_2332 VGND VPWR sky130_fd_sc_hd__tapvpwrvgnd_1
XTAP_TAPCELL_ROW_135_2321 VGND VPWR sky130_fd_sc_hd__tapvpwrvgnd_1
X_2857_ _6426_/Q _5311_/Q _3072_/S VGND VGND VPWR VPWR _2857_/X sky130_fd_sc_hd__mux2_1
XFILLER_109_609 VGND VGND VPWR VPWR sky130_fd_sc_hd__fill_4
X_5645_ _6236_/CLK _5645_/D VGND VGND VPWR VPWR _5645_/Q sky130_fd_sc_hd__dfxtp_1
Xhold210 _5502_/Q VGND VGND VPWR VPWR hold210/X sky130_fd_sc_hd__dlygate4sd3_1
X_2788_ _3076_/A1 _2783_/X _2785_/X _2787_/X VGND VGND VPWR VPWR _2788_/X sky130_fd_sc_hd__a22o_1
XFILLER_117_653 VPWR VGND VPWR VGND sky130_ef_sc_hd__decap_40_12
X_5576_ _6129_/CLK _5576_/D VGND VGND VPWR VPWR _5576_/Q sky130_fd_sc_hd__dfxtp_1
Xhold232 _6246_/Q VGND VGND VPWR VPWR hold232/X sky130_fd_sc_hd__dlygate4sd3_1
XFILLER_132_601 VPWR VGND VPWR VGND sky130_ef_sc_hd__decap_40_12
XFILLER_117_697 VPWR VGND VPWR VGND sky130_ef_sc_hd__decap_40_12
XFILLER_116_163 VGND VGND VPWR VPWR sky130_fd_sc_hd__fill_1
Xhold221 _3295_/X VGND VGND VPWR VPWR _5414_/D sky130_fd_sc_hd__dlygate4sd3_1
XFILLER_105_837 VGND VGND VPWR VPWR sky130_fd_sc_hd__fill_2
Xhold243 _3745_/X VGND VGND VPWR VPWR _5759_/D sky130_fd_sc_hd__dlygate4sd3_1
X_4527_ hold612/X _4846_/A0 _4535_/S VGND VGND VPWR VPWR _4527_/X sky130_fd_sc_hd__mux2_1
Xhold276 _6437_/Q VGND VGND VPWR VPWR hold276/X sky130_fd_sc_hd__dlygate4sd3_1
XFILLER_132_645 VPWR VGND VPWR VGND sky130_ef_sc_hd__decap_40_12
XFILLER_104_325 VGND VGND VPWR VPWR sky130_fd_sc_hd__fill_1
X_4458_ _6262_/Q _3366_/X _4427_/B _5216_/B _3801_/B VGND VGND VPWR VPWR _4458_/X
+ sky130_fd_sc_hd__a221o_1
Xhold254 _6345_/Q VGND VGND VPWR VPWR hold254/X sky130_fd_sc_hd__dlygate4sd3_1
Xhold287 _6114_/Q VGND VGND VPWR VPWR hold287/X sky130_fd_sc_hd__dlygate4sd3_1
Xhold265 _3629_/X VGND VGND VPWR VPWR _5657_/D sky130_fd_sc_hd__dlygate4sd3_1
XTAP_TAPCELL_ROW_113_1995 VGND VPWR sky130_fd_sc_hd__tapvpwrvgnd_1
XANTENNA__3305__A1 _5234_/A0 VGND VGND VPWR VPWR sky130_fd_sc_hd__diode_2
Xhold298 _4277_/X VGND VGND VPWR VPWR _5929_/D sky130_fd_sc_hd__dlygate4sd3_1
X_3409_ _5044_/A1 _3409_/A1 _3412_/S VGND VGND VPWR VPWR _3409_/X sky130_fd_sc_hd__mux2_1
X_6128_ _6129_/CLK _6128_/D VGND VGND VPWR VPWR _6128_/Q sky130_fd_sc_hd__dfxtp_1
XFILLER_98_581 VGND VGND VPWR VPWR sky130_fd_sc_hd__fill_4
X_4389_ _5052_/A1 _4389_/A1 _4396_/S VGND VGND VPWR VPWR _4389_/X sky130_fd_sc_hd__mux2_1
XFILLER_100_531 VGND VGND VPWR VPWR sky130_fd_sc_hd__fill_1
XANTENNA__5058__A1 _5830_/Q VGND VGND VPWR VPWR sky130_fd_sc_hd__diode_2
XANTENNA__3213__S _3220_/S VGND VGND VPWR VPWR sky130_fd_sc_hd__diode_2
X_6059_ clkload1/A _6059_/D VGND VGND VPWR VPWR _6059_/Q sky130_fd_sc_hd__dfxtp_1
XFILLER_18_309 VGND VGND VPWR VPWR sky130_fd_sc_hd__fill_1
XFILLER_27_821 VPWR VGND VPWR VGND sky130_ef_sc_hd__decap_40_12
XANTENNA__2816__B1 _3089_/C1 VGND VGND VPWR VPWR sky130_fd_sc_hd__diode_2
XFILLER_73_437 VGND VGND VPWR VPWR sky130_fd_sc_hd__fill_2
XFILLER_65_59 VGND VGND VPWR VPWR sky130_fd_sc_hd__fill_1
XANTENNA__2911__S0 _2984_/S VGND VGND VPWR VPWR sky130_fd_sc_hd__diode_2
XFILLER_60_109 VGND VGND VPWR VPWR sky130_fd_sc_hd__fill_2
XFILLER_42_813 VPWR VGND VPWR VGND sky130_ef_sc_hd__decap_40_12
XTAP_TAPCELL_ROW_37_860 VGND VPWR sky130_fd_sc_hd__tapvpwrvgnd_1
XANTENNA__4018__C1 _5200_/A VGND VGND VPWR VPWR sky130_fd_sc_hd__diode_2
XFILLER_41_334 VGND VGND VPWR VPWR sky130_fd_sc_hd__fill_2
XANTENNA__3241__B1 _3801_/A VGND VGND VPWR VPWR sky130_fd_sc_hd__diode_2
XPHY_EDGE_ROW_101_Left_240 VGND VGND VPWR VPWR sky130_fd_sc_hd__decap_3
XANTENNA__3792__A1 _5211_/A1 VGND VGND VPWR VPWR sky130_fd_sc_hd__diode_2
XANTENNA__4979__S _4984_/S VGND VGND VPWR VPWR sky130_fd_sc_hd__diode_2
XFILLER_22_581 VGND VGND VPWR VPWR sky130_fd_sc_hd__fill_4
XFILLER_6_725 VPWR VGND VPWR VGND sky130_ef_sc_hd__decap_40_12
XANTENNA__3544__A1 _4484_/A0 VGND VGND VPWR VPWR sky130_fd_sc_hd__diode_2
XFILLER_6_769 VPWR VGND VPWR VGND sky130_ef_sc_hd__decap_40_12
XANTENNA__2978__S0 _3072_/S VGND VGND VPWR VPWR sky130_fd_sc_hd__diode_2
XTAP_TAPCELL_ROW_75_1423 VGND VPWR sky130_fd_sc_hd__tapvpwrvgnd_1
XFILLER_5_268 VGND VGND VPWR VPWR sky130_fd_sc_hd__fill_2
XFILLER_108_697 VGND VGND VPWR VPWR sky130_fd_sc_hd__fill_2
XFILLER_1_430 VPWR VGND VPWR VGND sky130_ef_sc_hd__decap_40_12
XFILLER_122_199 VPWR VGND VPWR VGND sky130_ef_sc_hd__decap_40_12
XFILLER_110_328 VGND VGND VPWR VPWR sky130_fd_sc_hd__fill_2
XFILLER_110_317 VGND VGND VPWR VPWR sky130_fd_sc_hd__fill_1
XFILLER_1_485 VPWR VGND VPWR VGND sky130_ef_sc_hd__decap_40_12
XFILLER_49_445 VGND VGND VPWR VPWR sky130_fd_sc_hd__fill_2
XFILLER_92_713 VPWR VGND VPWR VGND sky130_ef_sc_hd__decap_40_12
XFILLER_92_757 VPWR VGND VPWR VGND sky130_ef_sc_hd__decap_40_12
XFILLER_91_223 VGND VGND VPWR VPWR sky130_fd_sc_hd__fill_1
XFILLER_36_139 VGND VGND VPWR VPWR sky130_fd_sc_hd__fill_1
XTAP_TAPCELL_ROW_35_819 VGND VPWR sky130_fd_sc_hd__tapvpwrvgnd_1
XTAP_TAPCELL_ROW_86_1596 VGND VPWR sky130_fd_sc_hd__tapvpwrvgnd_1
XTAP_TAPCELL_ROW_86_1585 VGND VPWR sky130_fd_sc_hd__tapvpwrvgnd_1
XFILLER_60_643 VGND VGND VPWR VPWR sky130_fd_sc_hd__fill_1
XTAP_TAPCELL_ROW_15_521 VGND VPWR sky130_fd_sc_hd__tapvpwrvgnd_1
XTAP_TAPCELL_ROW_15_532 VGND VPWR sky130_fd_sc_hd__tapvpwrvgnd_1
X_3760_ hold173/X _4978_/A1 _3766_/S VGND VGND VPWR VPWR _3760_/X sky130_fd_sc_hd__mux2_1
XFILLER_20_529 VGND VGND VPWR VPWR sky130_fd_sc_hd__fill_2
XANTENNA__4889__S _4893_/S VGND VGND VPWR VPWR sky130_fd_sc_hd__diode_2
XFILLER_9_541 VPWR VGND VPWR VGND sky130_ef_sc_hd__decap_40_12
XANTENNA__3783__A1 _5212_/A1 VGND VGND VPWR VPWR sky130_fd_sc_hd__diode_2
X_2711_ _5042_/A1 _2711_/A1 _2716_/S VGND VGND VPWR VPWR _2711_/X sky130_fd_sc_hd__mux2_1
XTAP_TAPCELL_ROW_117_2051 VGND VPWR sky130_fd_sc_hd__tapvpwrvgnd_1
X_3691_ hold208/X _4515_/A1 _3698_/S VGND VGND VPWR VPWR _3691_/X sky130_fd_sc_hd__mux2_1
XFILLER_9_585 VPWR VGND VPWR VGND sky130_ef_sc_hd__decap_40_12
X_5430_ _6408_/CLK _5430_/D VGND VGND VPWR VPWR _5430_/Q sky130_fd_sc_hd__dfxtp_1
X_2642_ _3044_/A VGND VGND VPWR VPWR _2642_/Y sky130_fd_sc_hd__inv_2
XTAP_TAPCELL_ROW_117_2062 VGND VPWR sky130_fd_sc_hd__tapvpwrvgnd_1
X_5361_ _6143_/CLK _5361_/D VGND VGND VPWR VPWR _5361_/Q sky130_fd_sc_hd__dfxtp_1
XFILLER_126_461 VGND VGND VPWR VPWR sky130_fd_sc_hd__fill_1
XFILLER_114_601 VPWR VGND VPWR VGND sky130_ef_sc_hd__decap_40_12
XANTENNA__3535__A1 _5075_/A0 VGND VGND VPWR VPWR sky130_fd_sc_hd__diode_2
XTAP_TAPCELL_ROW_130_2251 VGND VPWR sky130_fd_sc_hd__tapvpwrvgnd_1
XFILLER_114_645 VPWR VGND VPWR VGND sky130_ef_sc_hd__decap_40_12
X_5292_ _6172_/CLK _5292_/D VGND VGND VPWR VPWR _5292_/Q sky130_fd_sc_hd__dfxtp_1
X_4312_ _4312_/A0 _5044_/A1 _4315_/S VGND VGND VPWR VPWR _4312_/X sky130_fd_sc_hd__mux2_1
X_4243_ _2636_/Y _4242_/X _3172_/B VGND VGND VPWR VPWR _4243_/Y sky130_fd_sc_hd__o21ai_1
XFILLER_113_188 VGND VGND VPWR VPWR sky130_fd_sc_hd__fill_1
XFILLER_101_306 VGND VGND VPWR VPWR sky130_fd_sc_hd__fill_2
XFILLER_19_19 VGND VGND VPWR VPWR sky130_fd_sc_hd__fill_2
XFILLER_68_754 VGND VGND VPWR VPWR sky130_fd_sc_hd__fill_2
X_4174_ _4264_/A1 _4173_/X _4271_/S1 VGND VGND VPWR VPWR _4174_/X sky130_fd_sc_hd__o21a_1
X_3125_ _3125_/A0 _5080_/A0 _3126_/S VGND VGND VPWR VPWR _3125_/X sky130_fd_sc_hd__mux2_1
XANTENNA__3033__S _3033_/S VGND VGND VPWR VPWR sky130_fd_sc_hd__diode_2
XFILLER_95_573 VPWR VGND VPWR VGND sky130_ef_sc_hd__decap_40_12
XANTENNA__5810__Q _5810_/Q VGND VGND VPWR VPWR sky130_fd_sc_hd__diode_2
X_3056_ _6136_/Q _5559_/Q _3086_/S VGND VGND VPWR VPWR _3056_/X sky130_fd_sc_hd__mux2_1
XANTENNA__2872__S _3072_/S VGND VGND VPWR VPWR sky130_fd_sc_hd__diode_2
XFILLER_83_779 VGND VGND VPWR VPWR sky130_fd_sc_hd__fill_4
XFILLER_24_813 VPWR VGND VPWR VGND sky130_ef_sc_hd__decap_40_12
XANTENNA__3471__A0 _4887_/A1 VGND VGND VPWR VPWR sky130_fd_sc_hd__diode_2
XANTENNA__5212__A1 _5212_/A1 VGND VGND VPWR VPWR sky130_fd_sc_hd__diode_2
XANTENNA__3269__A _4802_/A VGND VGND VPWR VPWR sky130_fd_sc_hd__diode_2
XFILLER_11_529 VPWR VGND VPWR VGND sky130_ef_sc_hd__decap_40_12
XFILLER_23_389 VGND VGND VPWR VPWR sky130_fd_sc_hd__fill_2
X_3958_ _3958_/A _4007_/A VGND VGND VPWR VPWR _3958_/Y sky130_fd_sc_hd__nor2_2
XANTENNA__4971__A0 _4981_/A1 VGND VGND VPWR VPWR sky130_fd_sc_hd__diode_2
X_2909_ _2905_/X _2907_/X _2908_/X _3089_/C1 VGND VGND VPWR VPWR _2909_/X sky130_fd_sc_hd__a22o_1
X_3889_ _3889_/A0 _4964_/A0 _3889_/S VGND VGND VPWR VPWR _3889_/X sky130_fd_sc_hd__mux2_1
X_5628_ _6097_/CLK _5628_/D VGND VGND VPWR VPWR _5628_/Q sky130_fd_sc_hd__dfxtp_1
XFILLER_124_409 VGND VGND VPWR VPWR sky130_fd_sc_hd__fill_1
X_5559_ _6434_/CLK _5559_/D VGND VGND VPWR VPWR _5559_/Q sky130_fd_sc_hd__dfxtp_1
XFILLER_117_483 VPWR VGND VPWR VGND sky130_ef_sc_hd__decap_40_12
XTAP_TAPCELL_ROW_57_1153 VGND VPWR sky130_fd_sc_hd__tapvpwrvgnd_1
XFILLER_120_637 VGND VGND VPWR VPWR sky130_fd_sc_hd__fill_4
XFILLER_116_43 VGND VGND VPWR VPWR sky130_fd_sc_hd__fill_1
XTAP_TAPCELL_ROW_70_1353 VGND VPWR sky130_fd_sc_hd__tapvpwrvgnd_1
XANTENNA_fanout72_A _2629_/Y VGND VGND VPWR VPWR sky130_fd_sc_hd__diode_2
XFILLER_19_629 VPWR VGND VPWR VGND sky130_ef_sc_hd__decap_40_12
XFILLER_18_139 VGND VGND VPWR VPWR sky130_fd_sc_hd__fill_1
XFILLER_92_68 VGND VGND VPWR VPWR sky130_fd_sc_hd__fill_4
XFILLER_27_673 VGND VGND VPWR VPWR sky130_fd_sc_hd__fill_8
XFILLER_42_643 VGND VGND VPWR VPWR sky130_fd_sc_hd__fill_1
XFILLER_25_51 VGND VGND VPWR VPWR sky130_fd_sc_hd__fill_2
XFILLER_30_805 VGND VGND VPWR VPWR sky130_fd_sc_hd__fill_4
XANTENNA__3214__A0 _5075_/A0 VGND VGND VPWR VPWR sky130_fd_sc_hd__diode_2
XFILLER_42_676 VPWR VGND VPWR VGND sky130_ef_sc_hd__decap_40_12
XFILLER_14_389 VPWR VGND VPWR VGND sky130_ef_sc_hd__decap_40_12
XANTENNA__4962__A0 _5214_/A1 VGND VGND VPWR VPWR sky130_fd_sc_hd__diode_2
XANTENNA__3765__A1 _4983_/A1 VGND VGND VPWR VPWR sky130_fd_sc_hd__diode_2
XFILLER_128_737 VPWR VGND VPWR VGND sky130_ef_sc_hd__decap_40_12
XFILLER_6_533 VPWR VGND VPWR VGND sky130_ef_sc_hd__decap_40_12
XTAP_TAPCELL_ROW_40_899 VGND VPWR sky130_fd_sc_hd__tapvpwrvgnd_1
XFILLER_41_61 VGND VGND VPWR VPWR sky130_fd_sc_hd__fill_2
XFILLER_115_409 VGND VGND VPWR VPWR sky130_fd_sc_hd__fill_1
XFILLER_136_781 VPWR VGND VPWR VGND sky130_ef_sc_hd__decap_40_12
XFILLER_69_507 VGND VGND VPWR VPWR sky130_fd_sc_hd__fill_1
XFILLER_111_615 VGND VGND VPWR VPWR sky130_fd_sc_hd__fill_1
XFILLER_110_103 VGND VGND VPWR VPWR sky130_fd_sc_hd__fill_1
XTAP_TAPCELL_ROW_88_1625 VGND VPWR sky130_fd_sc_hd__tapvpwrvgnd_1
XTAP_TAPCELL_ROW_88_1614 VGND VPWR sky130_fd_sc_hd__tapvpwrvgnd_1
XFILLER_2_77 VGND VGND VPWR VPWR sky130_fd_sc_hd__fill_4
XFILLER_37_415 VGND VGND VPWR VPWR sky130_fd_sc_hd__fill_4
XFILLER_92_587 VGND VGND VPWR VPWR sky130_fd_sc_hd__fill_1
XFILLER_80_749 VGND VGND VPWR VPWR sky130_fd_sc_hd__fill_4
XFILLER_64_289 VGND VGND VPWR VPWR sky130_fd_sc_hd__fill_2
X_4930_ hold737/X _4980_/A1 _4934_/S VGND VGND VPWR VPWR _4930_/X sky130_fd_sc_hd__mux2_1
X_4861_ _4887_/A1 _4861_/A1 _4867_/S VGND VGND VPWR VPWR _4861_/X sky130_fd_sc_hd__mux2_1
XANTENNA__2705__B _4451_/A VGND VGND VPWR VPWR sky130_fd_sc_hd__diode_2
X_3812_ input8/X _4922_/B VGND VGND VPWR VPWR _3813_/B sky130_fd_sc_hd__nor2_1
XANTENNA__4628__S0 _4778_/S VGND VGND VPWR VPWR sky130_fd_sc_hd__diode_2
XFILLER_32_164 VGND VGND VPWR VPWR sky130_fd_sc_hd__fill_1
XPHY_EDGE_ROW_120_Right_120 VGND VGND VPWR VPWR sky130_fd_sc_hd__decap_3
X_4792_ _4792_/A1 _4787_/X _4789_/X _4791_/X VGND VGND VPWR VPWR _4792_/X sky130_fd_sc_hd__a22o_1
XANTENNA__4953__A0 _4983_/A1 VGND VGND VPWR VPWR sky130_fd_sc_hd__diode_2
X_3743_ _3743_/A0 _5235_/A0 _3745_/S VGND VGND VPWR VPWR _3743_/X sky130_fd_sc_hd__mux2_1
XANTENNA__3376__X _3376_/X VGND VGND VPWR VPWR sky130_fd_sc_hd__diode_2
XTAP_TAPCELL_ROW_99_1787 VGND VPWR sky130_fd_sc_hd__tapvpwrvgnd_1
XANTENNA__4412__S _4416_/S VGND VGND VPWR VPWR sky130_fd_sc_hd__diode_2
XFILLER_9_393 VPWR VGND VPWR VGND sky130_ef_sc_hd__decap_40_12
X_3674_ _4488_/A0 _3674_/A1 _3678_/S VGND VGND VPWR VPWR _3674_/X sky130_fd_sc_hd__mux2_1
X_5413_ _6435_/CLK _5413_/D VGND VGND VPWR VPWR _5413_/Q sky130_fd_sc_hd__dfxtp_1
X_6393_ _6394_/CLK _6393_/D VGND VGND VPWR VPWR _6393_/Q sky130_fd_sc_hd__dfxtp_1
X_2625_ _2625_/A VGND VGND VPWR VPWR _2625_/Y sky130_fd_sc_hd__inv_2
XFILLER_127_781 VGND VGND VPWR VPWR sky130_fd_sc_hd__fill_2
XANTENNA__3028__S _3086_/S VGND VGND VPWR VPWR sky130_fd_sc_hd__diode_2
XANTENNA__4181__A1 _4149_/A VGND VGND VPWR VPWR sky130_fd_sc_hd__diode_2
X_5344_ _5988_/CLK _5344_/D VGND VGND VPWR VPWR _5344_/Q sky130_fd_sc_hd__dfxtp_1
XFILLER_88_805 VGND VGND VPWR VPWR sky130_fd_sc_hd__fill_4
XFILLER_114_497 VPWR VGND VPWR VGND sky130_ef_sc_hd__decap_40_12
XFILLER_102_637 VGND VGND VPWR VPWR sky130_fd_sc_hd__fill_4
X_5275_ _5753_/CLK _5275_/D VGND VGND VPWR VPWR _5275_/Q sky130_fd_sc_hd__dfxtp_1
XTAP_TAPCELL_ROW_110_1954 VGND VPWR sky130_fd_sc_hd__tapvpwrvgnd_1
XTAP_TAPCELL_ROW_110_1943 VGND VPWR sky130_fd_sc_hd__tapvpwrvgnd_1
X_4226_ _5953_/Q _6341_/Q _4228_/S VGND VGND VPWR VPWR _4227_/B sky130_fd_sc_hd__mux2_1
XFILLER_101_169 VGND VGND VPWR VPWR sky130_fd_sc_hd__fill_1
X_4157_ hold45/A _5995_/Q _4270_/S VGND VGND VPWR VPWR _4157_/X sky130_fd_sc_hd__mux2_1
XTAP_TAPCELL_ROW_52_1083 VGND VPWR sky130_fd_sc_hd__tapvpwrvgnd_1
XANTENNA__4935__X _4944_/S VGND VGND VPWR VPWR sky130_fd_sc_hd__diode_2
X_3108_ hold228/X _5812_/Q _3112_/S VGND VGND VPWR VPWR _3108_/X sky130_fd_sc_hd__mux2_1
XFILLER_110_681 VPWR VGND VPWR VGND sky130_ef_sc_hd__decap_40_12
X_4088_ _4084_/X _4085_/X _4086_/X _4087_/X _4252_/A1 _3172_/B VGND VGND VPWR VPWR
+ _4088_/X sky130_fd_sc_hd__mux4_1
XANTENNA__3698__S _3698_/S VGND VGND VPWR VPWR sky130_fd_sc_hd__diode_2
X_3039_ _2967_/S _3038_/X _3032_/Y _2735_/A VGND VGND VPWR VPWR _3039_/Y sky130_fd_sc_hd__o211ai_1
XFILLER_55_278 VGND VGND VPWR VPWR sky130_fd_sc_hd__fill_2
XANTENNA_fanout162_X _4263_/A VGND VGND VPWR VPWR sky130_fd_sc_hd__diode_2
XFILLER_12_805 VGND VGND VPWR VPWR sky130_fd_sc_hd__fill_4
XFILLER_8_809 VGND VGND VPWR VPWR sky130_fd_sc_hd__fill_2
XFILLER_11_337 VGND VGND VPWR VPWR sky130_fd_sc_hd__fill_1
XANTENNA__4944__A0 _4984_/A1 VGND VGND VPWR VPWR sky130_fd_sc_hd__diode_2
XFILLER_137_501 VGND VGND VPWR VPWR sky130_fd_sc_hd__fill_2
XFILLER_125_729 VPWR VGND VPWR VGND sky130_ef_sc_hd__decap_40_12
XFILLER_3_503 VGND VGND VPWR VPWR sky130_fd_sc_hd__fill_1
XFILLER_127_31 VGND VGND VPWR VPWR sky130_fd_sc_hd__fill_1
XFILLER_118_781 VPWR VGND VPWR VGND sky130_ef_sc_hd__decap_40_12
XANTENNA__3733__Y _3745_/S VGND VGND VPWR VPWR sky130_fd_sc_hd__diode_2
XFILLER_87_68 VGND VGND VPWR VPWR sky130_fd_sc_hd__fill_1
XFILLER_87_35 VGND VGND VPWR VPWR sky130_fd_sc_hd__fill_2
XANTENNA__3380__C1 _3801_/B VGND VGND VPWR VPWR sky130_fd_sc_hd__diode_2
XANTENNA_fanout75_X _4791_/B1 VGND VGND VPWR VPWR sky130_fd_sc_hd__diode_2
XANTENNA__4992__S _4993_/S VGND VGND VPWR VPWR sky130_fd_sc_hd__diode_2
XTAP_TAPCELL_ROW_6_385 VGND VPWR sky130_fd_sc_hd__tapvpwrvgnd_1
XFILLER_86_392 VGND VGND VPWR VPWR sky130_fd_sc_hd__fill_1
XANTENNA__3683__A0 _4517_/A1 VGND VGND VPWR VPWR sky130_fd_sc_hd__diode_2
XTAP_TAPCELL_ROW_6_396 VGND VPWR sky130_fd_sc_hd__tapvpwrvgnd_1
XFILLER_61_215 VGND VGND VPWR VPWR sky130_fd_sc_hd__fill_1
XTAP_TAPCELL_ROW_83_1544 VGND VPWR sky130_fd_sc_hd__tapvpwrvgnd_1
XTAP_TAPCELL_ROW_45_969 VGND VPWR sky130_fd_sc_hd__tapvpwrvgnd_1
XFILLER_15_665 VGND VGND VPWR VPWR sky130_fd_sc_hd__fill_4
XANTENNA__5188__B1 _5085_/A VGND VGND VPWR VPWR sky130_fd_sc_hd__diode_2
XTAP_TAPCELL_ROW_25_671 VGND VPWR sky130_fd_sc_hd__tapvpwrvgnd_1
XTAP_TAPCELL_ROW_25_682 VGND VPWR sky130_fd_sc_hd__tapvpwrvgnd_1
XANTENNA__3738__A1 _4886_/A1 VGND VGND VPWR VPWR sky130_fd_sc_hd__diode_2
XFILLER_128_545 VPWR VGND VPWR VGND sky130_ef_sc_hd__decap_40_12
Xinput14 s_axil_wdata[11] VGND VGND VPWR VPWR _4914_/A sky130_fd_sc_hd__buf_1
Xinput25 s_axil_wdata[7] VGND VGND VPWR VPWR input25/X sky130_fd_sc_hd__buf_1
Xclkbuf_leaf_103_clk clkload0/A VGND VGND VPWR VPWR _6315_/CLK sky130_fd_sc_hd__clkbuf_8
XFILLER_128_589 VPWR VGND VPWR VGND sky130_ef_sc_hd__decap_40_12
XTAP_TAPCELL_ROW_114_2010 VGND VPWR sky130_fd_sc_hd__tapvpwrvgnd_1
Xhold809 _5671_/Q VGND VGND VPWR VPWR hold809/X sky130_fd_sc_hd__dlygate4sd3_1
XFILLER_109_781 VGND VGND VPWR VPWR sky130_fd_sc_hd__fill_2
X_3390_ hold343/X _4984_/A1 _3390_/S VGND VGND VPWR VPWR _3390_/X sky130_fd_sc_hd__mux2_1
XFILLER_97_613 VGND VGND VPWR VPWR sky130_fd_sc_hd__fill_2
XANTENNA__3910__A1 _5208_/A1 VGND VGND VPWR VPWR sky130_fd_sc_hd__diode_2
X_5060_ _5060_/A _5060_/B VGND VGND VPWR VPWR _5207_/S sky130_fd_sc_hd__nand2_4
X_4011_ _5201_/B _4010_/A _4009_/Y _4010_/Y VGND VGND VPWR VPWR _5013_/C sky130_fd_sc_hd__a211o_1
Xhold1509 _3774_/X VGND VGND VPWR VPWR _5784_/D sky130_fd_sc_hd__dlygate4sd3_1
XFILLER_28_3 VPWR VGND VPWR VGND sky130_ef_sc_hd__decap_40_12
XFILLER_93_841 VGND VGND VPWR VPWR sky130_fd_sc_hd__fill_1
XANTENNA__3674__A0 _4488_/A0 VGND VGND VPWR VPWR sky130_fd_sc_hd__diode_2
XTAP_TAPCELL_ROW_125_2172 VGND VPWR sky130_fd_sc_hd__tapvpwrvgnd_1
XFILLER_53_727 VGND VGND VPWR VPWR sky130_fd_sc_hd__fill_1
XFILLER_25_429 VPWR VGND VPWR VGND sky130_ef_sc_hd__decap_40_12
X_5962_ _5990_/CLK _5962_/D VGND VGND VPWR VPWR _5962_/Q sky130_fd_sc_hd__dfxtp_1
XFILLER_80_557 VGND VGND VPWR VPWR sky130_fd_sc_hd__fill_1
X_4913_ _5178_/A1 _4907_/Y _4912_/X _5176_/A VGND VGND VPWR VPWR _6257_/D sky130_fd_sc_hd__o211a_1
X_5893_ _6414_/CLK _5893_/D VGND VGND VPWR VPWR _5893_/Q sky130_fd_sc_hd__dfxtp_1
XFILLER_33_451 VGND VGND VPWR VPWR sky130_fd_sc_hd__fill_1
X_4844_ _5239_/A1 hold700/X _4854_/S VGND VGND VPWR VPWR _4844_/X sky130_fd_sc_hd__mux2_1
XFILLER_138_309 VGND VGND VPWR VPWR sky130_fd_sc_hd__fill_1
X_4775_ _5601_/Q _5592_/Q _4778_/S VGND VGND VPWR VPWR _4775_/X sky130_fd_sc_hd__mux2_1
XFILLER_21_657 VGND VGND VPWR VPWR sky130_fd_sc_hd__fill_1
XANTENNA__5238__S _5241_/S VGND VGND VPWR VPWR sky130_fd_sc_hd__diode_2
X_3726_ _4193_/A1 _4982_/A1 _3728_/S VGND VGND VPWR VPWR _3726_/X sky130_fd_sc_hd__mux2_1
XANTENNA__4142__S _4257_/S VGND VGND VPWR VPWR sky130_fd_sc_hd__diode_2
XFILLER_107_729 VPWR VGND VPWR VGND sky130_ef_sc_hd__decap_40_12
X_3657_ hold385/X _5202_/A1 _3657_/S VGND VGND VPWR VPWR _3657_/X sky130_fd_sc_hd__mux2_1
X_6376_ _6382_/CLK _6376_/D VGND VGND VPWR VPWR _6376_/Q sky130_fd_sc_hd__dfxtp_1
X_3588_ _3588_/A0 _4515_/A1 _3595_/S VGND VGND VPWR VPWR _3588_/X sky130_fd_sc_hd__mux2_1
X_5327_ _6405_/CLK _5327_/D VGND VGND VPWR VPWR _5327_/Q sky130_fd_sc_hd__dfxtp_1
XTAP_TAPCELL_ROW_54_1112 VGND VPWR sky130_fd_sc_hd__tapvpwrvgnd_1
XANTENNA__3901__A1 _5209_/A1 VGND VGND VPWR VPWR sky130_fd_sc_hd__diode_2
XFILLER_0_517 VPWR VGND VPWR VGND sky130_ef_sc_hd__decap_40_12
X_5258_ _6404_/CLK _5258_/D VGND VGND VPWR VPWR _5258_/Q sky130_fd_sc_hd__dfxtp_1
XANTENNA__3665__A0 _3926_/A1 VGND VGND VPWR VPWR sky130_fd_sc_hd__diode_2
XFILLER_84_841 VGND VGND VPWR VPWR sky130_fd_sc_hd__fill_1
X_5189_ _3953_/Y _5175_/S _5191_/A VGND VGND VPWR VPWR _5189_/Y sky130_fd_sc_hd__a21boi_1
X_4209_ _4264_/A1 _4208_/X _4207_/X _4271_/S1 VGND VGND VPWR VPWR _4209_/X sky130_fd_sc_hd__o211a_1
XTAP_TAPCELL_ROW_3_344 VGND VPWR sky130_fd_sc_hd__tapvpwrvgnd_1
XFILLER_29_779 VGND VGND VPWR VPWR sky130_fd_sc_hd__fill_4
XFILLER_73_15 VGND VGND VPWR VPWR sky130_fd_sc_hd__fill_4
Xwire60 wire60/A VGND VGND VPWR VPWR wire60/X sky130_fd_sc_hd__buf_1
XTAP_TAPCELL_ROW_65_1274 VGND VPWR sky130_fd_sc_hd__tapvpwrvgnd_1
XTAP_TAPCELL_ROW_42_928 VGND VPWR sky130_fd_sc_hd__tapvpwrvgnd_1
XFILLER_12_613 VPWR VGND VPWR VGND sky130_ef_sc_hd__decap_40_12
XFILLER_52_793 VPWR VGND VPWR VGND sky130_ef_sc_hd__decap_40_12
XFILLER_132_3 VPWR VGND VPWR VGND sky130_ef_sc_hd__decap_40_12
XFILLER_12_657 VPWR VGND VPWR VGND sky130_ef_sc_hd__decap_40_12
XTAP_TAPCELL_ROW_22_630 VGND VPWR sky130_fd_sc_hd__tapvpwrvgnd_1
XFILLER_7_138 VGND VGND VPWR VPWR sky130_fd_sc_hd__fill_1
XFILLER_138_41 VPWR VGND VPWR VGND sky130_ef_sc_hd__decap_40_12
XFILLER_138_85 VGND VGND VPWR VPWR sky130_fd_sc_hd__fill_8
XANTENNA__3891__S _3899_/S VGND VGND VPWR VPWR sky130_fd_sc_hd__diode_2
XANTENNA__4987__S _4993_/S VGND VGND VPWR VPWR sky130_fd_sc_hd__diode_2
XFILLER_125_559 VGND VGND VPWR VPWR sky130_fd_sc_hd__fill_1
XFILLER_3_322 VPWR VGND VPWR VGND sky130_ef_sc_hd__decap_40_12
XFILLER_121_721 VGND VGND VPWR VPWR sky130_fd_sc_hd__fill_4
XFILLER_79_613 VGND VGND VPWR VPWR sky130_fd_sc_hd__fill_1
XFILLER_121_765 VPWR VGND VPWR VGND sky130_ef_sc_hd__decap_40_12
Xfanout180 hold2217/X VGND VGND VPWR VPWR _3027_/A sky130_fd_sc_hd__clkbuf_4
Xfanout191 _5266_/Q VGND VGND VPWR VPWR _3086_/S sky130_fd_sc_hd__buf_4
XFILLER_75_841 VGND VGND VPWR VPWR sky130_fd_sc_hd__fill_1
XFILLER_93_148 VGND VGND VPWR VPWR sky130_fd_sc_hd__fill_2
XFILLER_90_811 VGND VGND VPWR VPWR sky130_fd_sc_hd__fill_1
XANTENNA__3408__A0 _5043_/A1 VGND VGND VPWR VPWR sky130_fd_sc_hd__diode_2
XANTENNA__4081__B1 _4252_/B1 VGND VGND VPWR VPWR sky130_fd_sc_hd__diode_2
X_2890_ _3005_/A _2890_/B VGND VGND VPWR VPWR _2890_/Y sky130_fd_sc_hd__nor2_1
XFILLER_15_473 VPWR VGND VPWR VGND sky130_ef_sc_hd__decap_40_12
XFILLER_30_421 VPWR VGND VPWR VGND sky130_ef_sc_hd__decap_40_12
XFILLER_129_821 VPWR VGND VPWR VGND sky130_ef_sc_hd__decap_40_12
XFILLER_128_320 VGND VGND VPWR VPWR sky130_fd_sc_hd__fill_1
X_4560_ hold604/X _4905_/A0 _4561_/S VGND VGND VPWR VPWR _4560_/X sky130_fd_sc_hd__mux2_1
XANTENNA__5058__S _5059_/S VGND VGND VPWR VPWR sky130_fd_sc_hd__diode_2
XANTENNA__4384__A1 _5829_/Q VGND VGND VPWR VPWR sky130_fd_sc_hd__diode_2
XTAP_TAPCELL_ROW_96_1735 VGND VPWR sky130_fd_sc_hd__tapvpwrvgnd_1
XANTENNA__4897__S _4906_/S VGND VGND VPWR VPWR sky130_fd_sc_hd__diode_2
Xhold617 _3499_/X VGND VGND VPWR VPWR _5544_/D sky130_fd_sc_hd__dlygate4sd3_1
XTAP_TAPCELL_ROW_96_1746 VGND VPWR sky130_fd_sc_hd__tapvpwrvgnd_1
X_3511_ _5232_/A0 _3511_/A1 _3516_/S VGND VGND VPWR VPWR _3511_/X sky130_fd_sc_hd__mux2_1
Xhold606 _5473_/Q VGND VGND VPWR VPWR hold606/X sky130_fd_sc_hd__dlygate4sd3_1
X_4491_ _5215_/A1 _4491_/A1 _4492_/S VGND VGND VPWR VPWR _4491_/X sky130_fd_sc_hd__mux2_1
X_3442_ hold958/X _4846_/A0 _3450_/S VGND VGND VPWR VPWR _3442_/X sky130_fd_sc_hd__mux2_1
X_6230_ _6238_/CLK _6230_/D VGND VGND VPWR VPWR _6230_/Q sky130_fd_sc_hd__dfxtp_1
Xhold639 _6219_/Q VGND VGND VPWR VPWR hold639/X sky130_fd_sc_hd__dlygate4sd3_1
XFILLER_6_193 VGND VGND VPWR VPWR sky130_fd_sc_hd__fill_2
Xhold628 _3779_/X VGND VGND VPWR VPWR _5787_/D sky130_fd_sc_hd__dlygate4sd3_1
XFILLER_131_529 VPWR VGND VPWR VGND sky130_ef_sc_hd__decap_40_12
X_6161_ _6242_/CLK hold52/X VGND VGND VPWR VPWR hold51/A sky130_fd_sc_hd__dfxtp_1
X_3373_ _5839_/Q input5/X input4/X VGND VGND VPWR VPWR _3373_/X sky130_fd_sc_hd__and3_1
XFILLER_124_581 VGND VGND VPWR VPWR sky130_fd_sc_hd__fill_4
Xhold2007 _5066_/X VGND VGND VPWR VPWR _6358_/D sky130_fd_sc_hd__dlygate4sd3_1
Xhold2018 _5195_/Y VGND VGND VPWR VPWR _5197_/B1 sky130_fd_sc_hd__dlygate4sd3_1
X_5112_ _5112_/A _5112_/B _5019_/B VGND VGND VPWR VPWR _5112_/X sky130_fd_sc_hd__or3b_1
XTAP_TAPCELL_ROW_127_2212 VGND VPWR sky130_fd_sc_hd__tapvpwrvgnd_1
XANTENNA__2793__S1 _3044_/A VGND VGND VPWR VPWR sky130_fd_sc_hd__diode_2
XTAP_TAPCELL_ROW_127_2201 VGND VPWR sky130_fd_sc_hd__tapvpwrvgnd_1
XFILLER_111_242 VGND VGND VPWR VPWR sky130_fd_sc_hd__fill_1
Xhold1306 _4843_/X VGND VGND VPWR VPWR _6195_/D sky130_fd_sc_hd__dlygate4sd3_1
Xhold2029 _5065_/X VGND VGND VPWR VPWR _6357_/D sky130_fd_sc_hd__dlygate4sd3_1
X_6092_ _6094_/CLK _6092_/D VGND VGND VPWR VPWR _6092_/Q sky130_fd_sc_hd__dfxtp_1
XFILLER_57_318 VGND VGND VPWR VPWR sky130_fd_sc_hd__fill_2
XFILLER_111_297 VGND VGND VPWR VPWR sky130_fd_sc_hd__fill_1
XFILLER_97_487 VGND VGND VPWR VPWR sky130_fd_sc_hd__fill_1
Xhold1317 _4822_/X VGND VGND VPWR VPWR _6176_/D sky130_fd_sc_hd__dlygate4sd3_1
X_5043_ hold39/X _5043_/A1 _5047_/S VGND VGND VPWR VPWR hold40/A sky130_fd_sc_hd__mux2_1
Xhold1339 _4310_/X VGND VGND VPWR VPWR _5958_/D sky130_fd_sc_hd__dlygate4sd3_1
Xhold1328 _5261_/Q VGND VGND VPWR VPWR _2713_/A1 sky130_fd_sc_hd__dlygate4sd3_1
XTAP_TAPCELL_ROW_0_303 VGND VPWR sky130_fd_sc_hd__tapvpwrvgnd_1
XFILLER_93_671 VGND VGND VPWR VPWR sky130_fd_sc_hd__fill_1
XFILLER_81_833 VGND VGND VPWR VPWR sky130_fd_sc_hd__fill_4
XFILLER_65_373 VGND VGND VPWR VPWR sky130_fd_sc_hd__fill_1
XFILLER_65_362 VGND VGND VPWR VPWR sky130_fd_sc_hd__fill_1
XFILLER_38_587 VGND VGND VPWR VPWR sky130_fd_sc_hd__fill_1
XFILLER_80_332 VGND VGND VPWR VPWR sky130_fd_sc_hd__fill_2
XTAP_TAPCELL_ROW_105_1875 VGND VPWR sky130_fd_sc_hd__tapvpwrvgnd_1
XANTENNA__4072__B1 _4205_/A VGND VGND VPWR VPWR sky130_fd_sc_hd__diode_2
X_5945_ _6316_/CLK _5945_/D VGND VGND VPWR VPWR _5945_/Q sky130_fd_sc_hd__dfxtp_1
X_5876_ _6098_/CLK _5876_/D VGND VGND VPWR VPWR _5876_/Q sky130_fd_sc_hd__dfxtp_1
XFILLER_34_793 VPWR VGND VPWR VGND sky130_ef_sc_hd__decap_40_12
X_4827_ _4905_/A0 _4827_/A1 _4828_/S VGND VGND VPWR VPWR _4827_/X sky130_fd_sc_hd__mux2_1
XTAP_TAPCELL_ROW_138_2374 VGND VPWR sky130_fd_sc_hd__tapvpwrvgnd_1
XTAP_TAPCELL_ROW_138_2363 VGND VPWR sky130_fd_sc_hd__tapvpwrvgnd_1
XTAP_TAPCELL_ROW_138_2385 VGND VPWR sky130_fd_sc_hd__tapvpwrvgnd_1
X_4758_ _4758_/A1 _4676_/A _4743_/X _4757_/Y VGND VGND VPWR VPWR _4758_/X sky130_fd_sc_hd__a22o_1
XANTENNA_fanout125_X _4905_/A0 VGND VGND VPWR VPWR sky130_fd_sc_hd__diode_2
XTAP_TAPCELL_ROW_60_1193 VGND VPWR sky130_fd_sc_hd__tapvpwrvgnd_1
XFILLER_5_609 VGND VGND VPWR VPWR sky130_fd_sc_hd__fill_4
XFILLER_107_537 VPWR VGND VPWR VGND sky130_ef_sc_hd__decap_40_12
X_4689_ _4688_/X _4683_/X _4799_/A VGND VGND VPWR VPWR _4689_/X sky130_fd_sc_hd__mux2_1
X_3709_ hold841/X _4976_/A1 _3717_/S VGND VGND VPWR VPWR _3709_/X sky130_fd_sc_hd__mux2_1
X_6428_ _6428_/CLK _6428_/D VGND VGND VPWR VPWR _6428_/Q sky130_fd_sc_hd__dfxtp_1
XFILLER_107_559 VGND VGND VPWR VPWR sky130_fd_sc_hd__fill_1
XFILLER_122_529 VGND VGND VPWR VPWR sky130_fd_sc_hd__fill_2
XANTENNA__3283__Y _3295_/S VGND VGND VPWR VPWR sky130_fd_sc_hd__diode_2
XTAP_TAPCELL_ROW_8_425 VGND VPWR sky130_fd_sc_hd__tapvpwrvgnd_1
XTAP_TAPCELL_ROW_8_414 VGND VPWR sky130_fd_sc_hd__tapvpwrvgnd_1
XANTENNA__3216__S _3220_/S VGND VGND VPWR VPWR sky130_fd_sc_hd__diode_2
XFILLER_103_721 VGND VGND VPWR VPWR sky130_fd_sc_hd__fill_4
XFILLER_88_421 VGND VGND VPWR VPWR sky130_fd_sc_hd__fill_4
X_6359_ _6386_/CLK _6359_/D VGND VGND VPWR VPWR _6359_/Q sky130_fd_sc_hd__dfxtp_1
XFILLER_68_37 VGND VGND VPWR VPWR sky130_fd_sc_hd__fill_1
XFILLER_1_837 VGND VGND VPWR VPWR sky130_fd_sc_hd__fill_2
XFILLER_103_765 VPWR VGND VPWR VGND sky130_ef_sc_hd__decap_40_12
XANTENNA__3350__A2 _5035_/C VGND VGND VPWR VPWR sky130_fd_sc_hd__diode_2
XFILLER_124_43 VGND VGND VPWR VPWR sky130_fd_sc_hd__fill_1
XFILLER_76_638 VGND VGND VPWR VPWR sky130_fd_sc_hd__fill_4
XFILLER_76_627 VGND VGND VPWR VPWR sky130_fd_sc_hd__fill_2
Xhold1851 _6188_/Q VGND VGND VPWR VPWR _4835_/A1 sky130_fd_sc_hd__dlygate4sd3_1
XFILLER_84_25 VGND VGND VPWR VPWR sky130_fd_sc_hd__fill_2
Xhold1840 _6378_/Q VGND VGND VPWR VPWR _5090_/A0 sky130_fd_sc_hd__dlygate4sd3_1
XFILLER_57_841 VGND VGND VPWR VPWR sky130_fd_sc_hd__fill_1
Xhold1862 _3681_/X VGND VGND VPWR VPWR _5703_/D sky130_fd_sc_hd__dlygate4sd3_1
XFILLER_90_118 VGND VGND VPWR VPWR sky130_fd_sc_hd__fill_4
Xhold1873 _6096_/Q VGND VGND VPWR VPWR _4490_/A1 sky130_fd_sc_hd__dlygate4sd3_1
XFILLER_72_800 VPWR VGND VPWR VGND sky130_ef_sc_hd__decap_40_12
XTAP_TAPCELL_ROW_67_1303 VGND VPWR sky130_fd_sc_hd__tapvpwrvgnd_1
Xhold1884 _4786_/X VGND VGND VPWR VPWR _6169_/D sky130_fd_sc_hd__dlygate4sd3_1
XANTENNA_hold1988_A _5401_/Q VGND VGND VPWR VPWR sky130_fd_sc_hd__diode_2
XFILLER_56_373 VGND VGND VPWR VPWR sky130_fd_sc_hd__fill_4
XFILLER_56_362 VGND VGND VPWR VPWR sky130_fd_sc_hd__fill_2
XFILLER_17_727 VGND VGND VPWR VPWR sky130_fd_sc_hd__fill_1
XTAP_TAPCELL_ROW_27_700 VGND VPWR sky130_fd_sc_hd__tapvpwrvgnd_1
XTAP_TAPCELL_ROW_27_711 VGND VPWR sky130_fd_sc_hd__tapvpwrvgnd_1
Xhold1895 _3257_/X VGND VGND VPWR VPWR _5393_/D sky130_fd_sc_hd__dlygate4sd3_1
XFILLER_71_343 VPWR VGND VPWR VGND sky130_ef_sc_hd__decap_40_12
XFILLER_71_321 VGND VGND VPWR VPWR sky130_fd_sc_hd__fill_2
XFILLER_44_557 VGND VGND VPWR VPWR sky130_fd_sc_hd__fill_1
XTAP_TAPCELL_ROW_80_1503 VGND VPWR sky130_fd_sc_hd__tapvpwrvgnd_1
XFILLER_71_387 VGND VGND VPWR VPWR sky130_fd_sc_hd__fill_4
XFILLER_12_421 VPWR VGND VPWR VGND sky130_ef_sc_hd__decap_40_12
XANTENNA__4366__A1 _5047_/A1 VGND VGND VPWR VPWR sky130_fd_sc_hd__diode_2
XFILLER_126_813 VPWR VGND VPWR VGND sky130_ef_sc_hd__decap_40_12
XFILLER_8_469 VGND VGND VPWR VPWR sky130_fd_sc_hd__fill_4
XFILLER_138_673 VPWR VGND VPWR VGND sky130_ef_sc_hd__decap_40_12
XANTENNA_clkbuf_leaf_73_clk_A clkload2/A VGND VGND VPWR VPWR sky130_fd_sc_hd__diode_2
XFILLER_137_194 VGND VGND VPWR VPWR sky130_fd_sc_hd__fill_1
XTAP_TAPCELL_ROW_78_1476 VGND VPWR sky130_fd_sc_hd__tapvpwrvgnd_1
XTAP_TAPCELL_ROW_78_1465 VGND VPWR sky130_fd_sc_hd__tapvpwrvgnd_1
XFILLER_113_529 VPWR VGND VPWR VGND sky130_ef_sc_hd__decap_40_12
XFILLER_3_163 VGND VGND VPWR VPWR sky130_fd_sc_hd__fill_1
XFILLER_106_581 VGND VGND VPWR VPWR sky130_fd_sc_hd__fill_4
XTAP_TAPCELL_ROW_91_1665 VGND VPWR sky130_fd_sc_hd__tapvpwrvgnd_1
XANTENNA__3877__A0 _3926_/A1 VGND VGND VPWR VPWR sky130_fd_sc_hd__diode_2
XFILLER_4_697 VGND VGND VPWR VPWR sky130_fd_sc_hd__fill_2
XANTENNA_clkbuf_leaf_88_clk_A clkload1/A VGND VGND VPWR VPWR sky130_fd_sc_hd__diode_2
XFILLER_121_573 VPWR VGND VPWR VGND sky130_ef_sc_hd__decap_40_12
Xhold3 hold3/A VGND VGND VPWR VPWR hold3/X sky130_fd_sc_hd__dlygate4sd3_1
XFILLER_48_841 VGND VGND VPWR VPWR sky130_fd_sc_hd__fill_1
XANTENNA_clkbuf_leaf_11_clk_A clkbuf_leaf_9_clk/A VGND VGND VPWR VPWR sky130_fd_sc_hd__diode_2
XFILLER_47_362 VPWR VGND VPWR VGND sky130_ef_sc_hd__decap_40_12
XTAP_TAPCELL_ROW_122_2131 VGND VPWR sky130_fd_sc_hd__tapvpwrvgnd_1
XANTENNA__2852__B2 _3089_/C1 VGND VGND VPWR VPWR sky130_fd_sc_hd__diode_2
XFILLER_90_641 VGND VGND VPWR VPWR sky130_fd_sc_hd__fill_2
XFILLER_74_192 VGND VGND VPWR VPWR sky130_fd_sc_hd__fill_1
XFILLER_47_395 VPWR VGND VPWR VGND sky130_ef_sc_hd__decap_40_12
XFILLER_35_546 VGND VGND VPWR VPWR sky130_fd_sc_hd__fill_1
XFILLER_74_80 VGND VGND VPWR VPWR sky130_fd_sc_hd__fill_4
X_3991_ _5082_/A _3991_/B _5048_/B VGND VGND VPWR VPWR _3991_/X sky130_fd_sc_hd__or3b_1
XFILLER_95_3 VPWR VGND VPWR VGND sky130_ef_sc_hd__decap_40_12
X_2942_ _3029_/A _2942_/B VGND VGND VPWR VPWR _2942_/X sky130_fd_sc_hd__or2_1
XANTENNA_clkbuf_leaf_26_clk_A clkload3/A VGND VGND VPWR VPWR sky130_fd_sc_hd__diode_2
X_5730_ _5731_/CLK _5730_/D VGND VGND VPWR VPWR _5730_/Q sky130_fd_sc_hd__dfxtp_1
XFILLER_16_793 VPWR VGND VPWR VGND sky130_ef_sc_hd__decap_40_12
XANTENNA__3368__Y _3801_/B VGND VGND VPWR VPWR sky130_fd_sc_hd__diode_2
XFILLER_15_281 VGND VGND VPWR VPWR sky130_fd_sc_hd__fill_4
X_2873_ _3031_/A1 _2872_/X _3075_/C1 VGND VGND VPWR VPWR _2873_/X sky130_fd_sc_hd__o21a_1
X_5661_ _5682_/CLK _5661_/D VGND VGND VPWR VPWR _5661_/Q sky130_fd_sc_hd__dfxtp_1
XFILLER_31_785 VPWR VGND VPWR VGND sky130_ef_sc_hd__decap_40_12
XTAP_TAPCELL_ROW_100_1794 VGND VPWR sky130_fd_sc_hd__tapvpwrvgnd_1
X_5592_ _6094_/CLK _5592_/D VGND VGND VPWR VPWR _5592_/Q sky130_fd_sc_hd__dfxtp_1
X_4612_ _5844_/Q _5622_/Q _4778_/S VGND VGND VPWR VPWR _4612_/X sky130_fd_sc_hd__mux2_1
XTAP_TAPCELL_ROW_13_493 VGND VPWR sky130_fd_sc_hd__tapvpwrvgnd_1
XFILLER_129_673 VPWR VGND VPWR VGND sky130_ef_sc_hd__decap_40_12
X_4543_ _4543_/A0 _5233_/A0 _4547_/S VGND VGND VPWR VPWR _4543_/X sky130_fd_sc_hd__mux2_1
XFILLER_132_805 VGND VGND VPWR VPWR sky130_fd_sc_hd__fill_4
Xhold425 _5275_/Q VGND VGND VPWR VPWR hold425/X sky130_fd_sc_hd__dlygate4sd3_1
XANTENNA__4109__A1 _4149_/A VGND VGND VPWR VPWR sky130_fd_sc_hd__diode_2
Xhold403 _5770_/Q VGND VGND VPWR VPWR hold403/X sky130_fd_sc_hd__dlygate4sd3_1
Xhold414 _3695_/X VGND VGND VPWR VPWR _5716_/D sky130_fd_sc_hd__dlygate4sd3_1
Xhold436 _3653_/X VGND VGND VPWR VPWR _5679_/D sky130_fd_sc_hd__dlygate4sd3_1
XTAP_TAPCELL_ROW_133_2293 VGND VPWR sky130_fd_sc_hd__tapvpwrvgnd_1
XFILLER_104_529 VGND VGND VPWR VPWR sky130_fd_sc_hd__fill_2
Xhold469 _5424_/Q VGND VGND VPWR VPWR hold469/X sky130_fd_sc_hd__dlygate4sd3_1
X_6213_ _6237_/CLK _6213_/D VGND VGND VPWR VPWR _6213_/Q sky130_fd_sc_hd__dfxtp_1
XANTENNA__4204__S1 _4263_/A VGND VGND VPWR VPWR sky130_fd_sc_hd__diode_2
Xhold458 _4284_/X VGND VGND VPWR VPWR _5936_/D sky130_fd_sc_hd__dlygate4sd3_1
Xhold447 _6118_/Q VGND VGND VPWR VPWR hold447/X sky130_fd_sc_hd__dlygate4sd3_1
X_4474_ hold600/X _5208_/A1 _4482_/S VGND VGND VPWR VPWR _4474_/X sky130_fd_sc_hd__mux2_1
X_3425_ _4868_/A _4842_/B VGND VGND VPWR VPWR _3437_/S sky130_fd_sc_hd__nor2_8
XANTENNA__5813__Q _5813_/Q VGND VGND VPWR VPWR sky130_fd_sc_hd__diode_2
XANTENNA__3868__A0 _6417_/Q VGND VGND VPWR VPWR sky130_fd_sc_hd__diode_2
X_6144_ _6148_/CLK _6144_/D VGND VGND VPWR VPWR _6144_/Q sky130_fd_sc_hd__dfxtp_1
X_3356_ _3356_/A1 _5035_/C _5201_/B _5212_/A0 VGND VGND VPWR VPWR _3356_/X sky130_fd_sc_hd__a22o_1
X_3287_ hold835/X _5241_/A1 _3295_/S VGND VGND VPWR VPWR _3287_/X sky130_fd_sc_hd__mux2_1
X_6075_ _6429_/CLK _6075_/D VGND VGND VPWR VPWR _6075_/Q sky130_fd_sc_hd__dfxtp_1
XFILLER_100_713 VPWR VGND VPWR VGND sky130_ef_sc_hd__decap_40_12
Xhold1114 _5552_/Q VGND VGND VPWR VPWR _3508_/A1 sky130_fd_sc_hd__dlygate4sd3_1
Xhold1103 _3758_/X VGND VGND VPWR VPWR _5769_/D sky130_fd_sc_hd__dlygate4sd3_1
XFILLER_38_29 VGND VGND VPWR VPWR sky130_fd_sc_hd__fill_1
XFILLER_100_757 VPWR VGND VPWR VGND sky130_ef_sc_hd__decap_40_12
Xhold1136 _5263_/Q VGND VGND VPWR VPWR _2715_/A1 sky130_fd_sc_hd__dlygate4sd3_1
X_5026_ _2652_/Y _5024_/X _5025_/Y _5006_/B VGND VGND VPWR VPWR _5026_/X sky130_fd_sc_hd__o2bb2a_1
Xhold1125 _4944_/X VGND VGND VPWR VPWR _6280_/D sky130_fd_sc_hd__dlygate4sd3_1
Xhold1147 _3755_/X VGND VGND VPWR VPWR _5768_/D sky130_fd_sc_hd__dlygate4sd3_1
Xhold1158 _5879_/Q VGND VGND VPWR VPWR _3900_/A0 sky130_fd_sc_hd__dlygate4sd3_1
XFILLER_39_841 VGND VGND VPWR VPWR sky130_fd_sc_hd__fill_1
Xhold1169 _5530_/Q VGND VGND VPWR VPWR _3484_/A0 sky130_fd_sc_hd__dlygate4sd3_1
XTAP_TAPCELL_ROW_107_1904 VGND VPWR sky130_fd_sc_hd__tapvpwrvgnd_1
XANTENNA__3096__A1 _3096_/A1 VGND VGND VPWR VPWR sky130_fd_sc_hd__diode_2
XFILLER_54_811 VGND VGND VPWR VPWR sky130_fd_sc_hd__fill_1
Xclkbuf_leaf_92_clk clkload2/A VGND VGND VPWR VPWR _6418_/CLK sky130_fd_sc_hd__clkbuf_8
XTAP_TAPCELL_ROW_49_1033 VGND VPWR sky130_fd_sc_hd__tapvpwrvgnd_1
XFILLER_81_663 VGND VGND VPWR VPWR sky130_fd_sc_hd__fill_1
XFILLER_53_354 VGND VGND VPWR VPWR sky130_fd_sc_hd__fill_2
XFILLER_80_184 VGND VGND VPWR VPWR sky130_fd_sc_hd__fill_8
X_5928_ _6351_/CLK _5928_/D VGND VGND VPWR VPWR _5928_/Q sky130_fd_sc_hd__dfxtp_1
XFILLER_53_387 VGND VGND VPWR VPWR sky130_fd_sc_hd__fill_4
XFILLER_110_45 VGND VGND VPWR VPWR sky130_fd_sc_hd__fill_2
XTAP_TAPCELL_ROW_62_1233 VGND VPWR sky130_fd_sc_hd__tapvpwrvgnd_1
X_5859_ _6097_/CLK _5859_/D VGND VGND VPWR VPWR _5859_/Q sky130_fd_sc_hd__dfxtp_1
XANTENNA__4348__A1 _5051_/A1 VGND VGND VPWR VPWR sky130_fd_sc_hd__diode_2
XTAP_TAPCELL_ROW_32_780 VGND VPWR sky130_fd_sc_hd__tapvpwrvgnd_1
XFILLER_108_813 VPWR VGND VPWR VGND sky130_ef_sc_hd__decap_40_12
XFILLER_5_417 VGND VGND VPWR VPWR sky130_fd_sc_hd__fill_2
XFILLER_119_87 VGND VGND VPWR VPWR sky130_fd_sc_hd__fill_1
XFILLER_135_665 VGND VGND VPWR VPWR sky130_fd_sc_hd__fill_4
XFILLER_134_197 VGND VGND VPWR VPWR sky130_fd_sc_hd__fill_1
Xhold970 _5408_/Q VGND VGND VPWR VPWR hold970/X sky130_fd_sc_hd__dlygate4sd3_1
XFILLER_89_741 VPWR VGND VPWR VGND sky130_ef_sc_hd__decap_40_12
Xhold981 _5740_/Q VGND VGND VPWR VPWR hold981/X sky130_fd_sc_hd__dlygate4sd3_1
XFILLER_0_111 VGND VGND VPWR VPWR sky130_fd_sc_hd__fill_1
XFILLER_122_359 VGND VGND VPWR VPWR sky130_fd_sc_hd__fill_2
Xhold992 _3566_/X VGND VGND VPWR VPWR _5603_/D sky130_fd_sc_hd__dlygate4sd3_1
XANTENNA__4520__A1 _5214_/A1 VGND VGND VPWR VPWR sky130_fd_sc_hd__diode_2
XFILLER_103_573 VPWR VGND VPWR VGND sky130_ef_sc_hd__decap_40_12
XFILLER_89_785 VPWR VGND VPWR VGND sky130_ef_sc_hd__decap_40_12
XTAP_TAPCELL_ROW_73_1395 VGND VPWR sky130_fd_sc_hd__tapvpwrvgnd_1
XFILLER_130_392 VGND VGND VPWR VPWR sky130_fd_sc_hd__fill_2
Xhold1670 _5565_/Q VGND VGND VPWR VPWR _3522_/A1 sky130_fd_sc_hd__dlygate4sd3_1
XANTENNA_input15_A s_axil_wdata[12] VGND VGND VPWR VPWR sky130_fd_sc_hd__diode_2
XFILLER_57_671 VGND VGND VPWR VPWR sky130_fd_sc_hd__fill_1
XFILLER_29_373 VGND VGND VPWR VPWR sky130_fd_sc_hd__fill_2
Xhold1692 _3529_/X VGND VGND VPWR VPWR _5572_/D sky130_fd_sc_hd__dlygate4sd3_1
XFILLER_45_833 VGND VGND VPWR VPWR sky130_fd_sc_hd__fill_4
Xhold1681 _6035_/Q VGND VGND VPWR VPWR _4396_/A1 sky130_fd_sc_hd__dlygate4sd3_1
Xclkbuf_leaf_83_clk clkload1/A VGND VGND VPWR VPWR _5682_/CLK sky130_fd_sc_hd__clkbuf_8
XFILLER_72_663 VGND VGND VPWR VPWR sky130_fd_sc_hd__fill_1
XFILLER_71_140 VPWR VGND VPWR VGND sky130_ef_sc_hd__decap_40_12
XFILLER_44_354 VGND VGND VPWR VPWR sky130_fd_sc_hd__fill_2
XFILLER_17_557 VGND VGND VPWR VPWR sky130_fd_sc_hd__fill_2
XANTENNA__2814__A _3044_/A VGND VGND VPWR VPWR sky130_fd_sc_hd__diode_2
XFILLER_60_825 VPWR VGND VPWR VGND sky130_ef_sc_hd__decap_40_12
XFILLER_32_549 VGND VGND VPWR VPWR sky130_fd_sc_hd__fill_2
XANTENNA__4682__S1 _4789_/A VGND VGND VPWR VPWR sky130_fd_sc_hd__diode_2
XFILLER_13_741 VPWR VGND VPWR VGND sky130_ef_sc_hd__decap_40_12
XFILLER_13_785 VPWR VGND VPWR VGND sky130_ef_sc_hd__decap_40_12
XFILLER_74_8 VPWR VGND VPWR VGND sky130_ef_sc_hd__decap_40_12
XANTENNA__4339__A1 _5053_/A1 VGND VGND VPWR VPWR sky130_fd_sc_hd__diode_2
XFILLER_67_7 VGND VGND VPWR VPWR sky130_fd_sc_hd__fill_2
XFILLER_60_71 VGND VGND VPWR VPWR sky130_fd_sc_hd__fill_1
XTAP_TAPCELL_ROW_10_452 VGND VPWR sky130_fd_sc_hd__tapvpwrvgnd_1
XFILLER_126_643 VGND VGND VPWR VPWR sky130_fd_sc_hd__fill_1
XFILLER_114_805 VGND VGND VPWR VPWR sky130_fd_sc_hd__fill_4
XFILLER_5_55 VGND VGND VPWR VPWR sky130_fd_sc_hd__fill_1
XFILLER_99_549 VGND VGND VPWR VPWR sky130_fd_sc_hd__fill_8
X_3210_ _5820_/Q _3210_/A1 _3220_/S VGND VGND VPWR VPWR _3210_/X sky130_fd_sc_hd__mux2_1
XFILLER_79_251 VGND VGND VPWR VPWR sky130_fd_sc_hd__fill_1
X_4190_ hold708/X hold986/X _4190_/A2 hold843/X _4250_/S _4251_/A VGND VGND VPWR VPWR
+ _4190_/X sky130_fd_sc_hd__mux4_1
XANTENNA__4511__A1 _4521_/A1 VGND VGND VPWR VPWR sky130_fd_sc_hd__diode_2
XFILLER_79_262 VGND VGND VPWR VPWR sky130_fd_sc_hd__fill_2
X_3141_ _5324_/Q _5323_/Q _5322_/Q VGND VGND VPWR VPWR _5038_/A sky130_fd_sc_hd__nand3_4
XANTENNA__5071__S _5081_/S VGND VGND VPWR VPWR sky130_fd_sc_hd__diode_2
XFILLER_95_777 VGND VGND VPWR VPWR sky130_fd_sc_hd__fill_4
XFILLER_67_446 VGND VGND VPWR VPWR sky130_fd_sc_hd__fill_2
XFILLER_67_435 VGND VGND VPWR VPWR sky130_fd_sc_hd__fill_1
XFILLER_10_3 VPWR VGND VPWR VGND sky130_ef_sc_hd__decap_40_12
X_3072_ _6080_/Q _6372_/Q _3072_/S VGND VGND VPWR VPWR _3072_/X sky130_fd_sc_hd__mux2_1
XFILLER_48_693 VGND VGND VPWR VPWR sky130_fd_sc_hd__fill_4
Xclkbuf_leaf_74_clk clkload1/A VGND VGND VPWR VPWR _6120_/CLK sky130_fd_sc_hd__clkbuf_8
XFILLER_23_505 VGND VGND VPWR VPWR sky130_fd_sc_hd__fill_1
XTAP_TAPCELL_ROW_102_1823 VGND VPWR sky130_fd_sc_hd__tapvpwrvgnd_1
XFILLER_63_685 VGND VGND VPWR VPWR sky130_fd_sc_hd__fill_1
XANTENNA__4415__S _4416_/S VGND VGND VPWR VPWR sky130_fd_sc_hd__diode_2
XANTENNA__5224__C1 _5034_/B VGND VGND VPWR VPWR sky130_fd_sc_hd__diode_2
XTAP_TAPCELL_ROW_18_563 VGND VPWR sky130_fd_sc_hd__tapvpwrvgnd_1
XTAP_TAPCELL_ROW_18_574 VGND VPWR sky130_fd_sc_hd__tapvpwrvgnd_1
XTAP_TAPCELL_ROW_102_1834 VGND VPWR sky130_fd_sc_hd__tapvpwrvgnd_1
X_3974_ _6408_/Q _3974_/B VGND VGND VPWR VPWR _3974_/Y sky130_fd_sc_hd__nand2_1
XFILLER_50_335 VPWR VGND VPWR VGND sky130_ef_sc_hd__decap_40_12
X_2925_ hold867/X _2924_/X _2925_/S VGND VGND VPWR VPWR _2925_/X sky130_fd_sc_hd__mux2_1
XANTENNA__4673__S1 _4809_/A VGND VGND VPWR VPWR sky130_fd_sc_hd__diode_2
X_5713_ _5902_/CLK _5713_/D VGND VGND VPWR VPWR _5713_/Q sky130_fd_sc_hd__dfxtp_1
XTAP_TAPCELL_ROW_135_2322 VGND VPWR sky130_fd_sc_hd__tapvpwrvgnd_1
X_2856_ _3044_/A _2856_/B VGND VGND VPWR VPWR _2856_/X sky130_fd_sc_hd__or2_1
X_5644_ _6290_/CLK _5644_/D VGND VGND VPWR VPWR _5644_/Q sky130_fd_sc_hd__dfxtp_1
XANTENNA__3002__A1 _3031_/A1 VGND VGND VPWR VPWR sky130_fd_sc_hd__diode_2
Xhold211 _3453_/X VGND VGND VPWR VPWR _5502_/D sky130_fd_sc_hd__dlygate4sd3_1
X_2787_ _3052_/A1 _2786_/X _3075_/C1 VGND VGND VPWR VPWR _2787_/X sky130_fd_sc_hd__o21a_1
X_5575_ _6369_/CLK _5575_/D VGND VGND VPWR VPWR _5575_/Q sky130_fd_sc_hd__dfxtp_1
XANTENNA__4150__S _4262_/S VGND VGND VPWR VPWR sky130_fd_sc_hd__diode_2
Xhold200 _3395_/X VGND VGND VPWR VPWR _5452_/D sky130_fd_sc_hd__dlygate4sd3_1
XFILLER_132_613 VPWR VGND VPWR VGND sky130_ef_sc_hd__decap_40_12
XFILLER_117_665 VGND VGND VPWR VPWR sky130_fd_sc_hd__fill_4
Xhold233 _5349_/Q VGND VGND VPWR VPWR hold233/X sky130_fd_sc_hd__dlygate4sd3_1
X_4526_ hold522/X _5228_/A0 _4535_/S VGND VGND VPWR VPWR _4526_/X sky130_fd_sc_hd__mux2_1
XANTENNA_fanout202_A _2682_/A VGND VGND VPWR VPWR sky130_fd_sc_hd__diode_2
Xhold222 _5862_/Q VGND VGND VPWR VPWR hold222/X sky130_fd_sc_hd__dlygate4sd3_1
Xhold244 _5653_/Q VGND VGND VPWR VPWR hold244/X sky130_fd_sc_hd__dlygate4sd3_1
Xhold277 _5240_/X VGND VGND VPWR VPWR _6437_/D sky130_fd_sc_hd__dlygate4sd3_1
Xhold266 _6158_/Q VGND VGND VPWR VPWR hold266/X sky130_fd_sc_hd__dlygate4sd3_1
X_4457_ hold397/X _4456_/X _4457_/S VGND VGND VPWR VPWR _4457_/X sky130_fd_sc_hd__mux2_1
Xhold255 _5052_/X VGND VGND VPWR VPWR _6345_/D sky130_fd_sc_hd__dlygate4sd3_1
XFILLER_132_657 VPWR VGND VPWR VGND sky130_ef_sc_hd__decap_40_12
Xhold299 _6340_/Q VGND VGND VPWR VPWR hold299/X sky130_fd_sc_hd__dlygate4sd3_1
Xhold288 _4510_/X VGND VGND VPWR VPWR _6114_/D sky130_fd_sc_hd__dlygate4sd3_1
X_3408_ _5043_/A1 _4134_/A1 _3412_/S VGND VGND VPWR VPWR _5463_/D sky130_fd_sc_hd__mux2_1
XANTENNA__4502__A1 _5202_/A1 VGND VGND VPWR VPWR sky130_fd_sc_hd__diode_2
XTAP_TAPCELL_ROW_113_1996 VGND VPWR sky130_fd_sc_hd__tapvpwrvgnd_1
X_6127_ _6399_/CLK _6127_/D VGND VGND VPWR VPWR _6127_/Q sky130_fd_sc_hd__dfxtp_1
XANTENNA_input7_A s_axil_awaddr[2] VGND VGND VPWR VPWR sky130_fd_sc_hd__diode_2
X_4388_ _4976_/A1 _4388_/A1 _4396_/S VGND VGND VPWR VPWR _4388_/X sky130_fd_sc_hd__mux2_1
XANTENNA_fanout192_X _2984_/S VGND VGND VPWR VPWR sky130_fd_sc_hd__diode_2
X_3339_ _3339_/A _3974_/B VGND VGND VPWR VPWR _3343_/B sky130_fd_sc_hd__nand2_1
XFILLER_100_587 VGND VGND VPWR VPWR sky130_fd_sc_hd__fill_1
X_6058_ _6422_/CLK _6058_/D VGND VGND VPWR VPWR _6058_/Q sky130_fd_sc_hd__dfxtp_1
XFILLER_39_671 VGND VGND VPWR VPWR sky130_fd_sc_hd__fill_1
XANTENNA__2816__A1 _3031_/A1 VGND VGND VPWR VPWR sky130_fd_sc_hd__diode_2
XPHY_EDGE_ROW_134_Right_134 VGND VGND VPWR VPWR sky130_fd_sc_hd__decap_3
Xclkbuf_leaf_65_clk clkload5/A VGND VGND VPWR VPWR _6095_/CLK sky130_fd_sc_hd__clkbuf_8
XFILLER_73_449 VGND VGND VPWR VPWR sky130_fd_sc_hd__fill_2
X_5009_ _5917_/Q _5008_/B _4014_/B _5123_/B VGND VGND VPWR VPWR _5012_/B sky130_fd_sc_hd__a211o_1
XFILLER_27_833 VGND VGND VPWR VPWR sky130_fd_sc_hd__fill_4
XFILLER_26_365 VPWR VGND VPWR VGND sky130_ef_sc_hd__decap_40_12
XTAP_TAPCELL_ROW_37_850 VGND VPWR sky130_fd_sc_hd__tapvpwrvgnd_1
XTAP_TAPCELL_ROW_37_861 VGND VPWR sky130_fd_sc_hd__tapvpwrvgnd_1
XFILLER_121_55 VGND VGND VPWR VPWR sky130_fd_sc_hd__fill_1
XFILLER_42_825 VPWR VGND VPWR VGND sky130_ef_sc_hd__decap_40_12
XFILLER_121_88 VGND VGND VPWR VPWR sky130_fd_sc_hd__fill_2
XANTENNA__2634__A _5343_/Q VGND VGND VPWR VPWR sky130_fd_sc_hd__diode_2
XFILLER_127_429 VGND VGND VPWR VPWR sky130_fd_sc_hd__fill_1
XFILLER_10_755 VGND VGND VPWR VPWR sky130_fd_sc_hd__fill_1
XFILLER_6_737 VPWR VGND VPWR VGND sky130_ef_sc_hd__decap_40_12
XFILLER_135_451 VPWR VGND VPWR VGND sky130_ef_sc_hd__decap_40_12
XFILLER_123_613 VGND VGND VPWR VPWR sky130_fd_sc_hd__fill_2
XANTENNA__2978__S1 _3044_/A VGND VGND VPWR VPWR sky130_fd_sc_hd__diode_2
XTAP_TAPCELL_ROW_75_1424 VGND VPWR sky130_fd_sc_hd__tapvpwrvgnd_1
XFILLER_1_442 VGND VGND VPWR VPWR sky130_fd_sc_hd__fill_4
XFILLER_77_744 VPWR VGND VPWR VGND sky130_ef_sc_hd__decap_40_12
XFILLER_76_221 VGND VGND VPWR VPWR sky130_fd_sc_hd__fill_4
XFILLER_1_497 VGND VGND VPWR VPWR sky130_fd_sc_hd__fill_4
XFILLER_92_725 VPWR VGND VPWR VGND sky130_ef_sc_hd__decap_40_12
XFILLER_76_265 VGND VGND VPWR VPWR sky130_fd_sc_hd__fill_1
Xhold2190 _5265_/Q VGND VGND VPWR VPWR _3328_/A sky130_fd_sc_hd__dlygate4sd3_1
XFILLER_49_468 VGND VGND VPWR VPWR sky130_fd_sc_hd__fill_1
XFILLER_18_811 VGND VGND VPWR VPWR sky130_fd_sc_hd__fill_1
XPHY_EDGE_ROW_101_Right_101 VGND VGND VPWR VPWR sky130_fd_sc_hd__decap_3
Xclkbuf_leaf_56_clk clkload6/A VGND VGND VPWR VPWR _6241_/CLK sky130_fd_sc_hd__clkbuf_8
XFILLER_92_769 VPWR VGND VPWR VGND sky130_ef_sc_hd__decap_40_12
XFILLER_64_438 VGND VGND VPWR VPWR sky130_fd_sc_hd__fill_8
XFILLER_45_630 VGND VGND VPWR VPWR sky130_fd_sc_hd__fill_1
XFILLER_91_257 VGND VGND VPWR VPWR sky130_fd_sc_hd__fill_1
XANTENNA__3480__A1 _5239_/A1 VGND VGND VPWR VPWR sky130_fd_sc_hd__diode_2
XTAP_TAPCELL_ROW_86_1597 VGND VPWR sky130_fd_sc_hd__tapvpwrvgnd_1
XTAP_TAPCELL_ROW_86_1586 VGND VPWR sky130_fd_sc_hd__tapvpwrvgnd_1
XANTENNA__5206__C1 _5034_/B VGND VGND VPWR VPWR sky130_fd_sc_hd__diode_2
XFILLER_17_365 VPWR VGND VPWR VGND sky130_ef_sc_hd__decap_40_12
XANTENNA__4235__S _4237_/S VGND VGND VPWR VPWR sky130_fd_sc_hd__diode_2
XANTENNA__4104__S0 _4237_/S VGND VGND VPWR VPWR sky130_fd_sc_hd__diode_2
XTAP_TAPCELL_ROW_15_522 VGND VPWR sky130_fd_sc_hd__tapvpwrvgnd_1
XFILLER_60_699 VGND VGND VPWR VPWR sky130_fd_sc_hd__fill_1
X_2710_ _5053_/A1 _2710_/A1 _2716_/S VGND VGND VPWR VPWR _2710_/X sky130_fd_sc_hd__mux2_1
XFILLER_9_553 VGND VGND VPWR VPWR sky130_fd_sc_hd__fill_4
XANTENNA__4980__A1 _4980_/A1 VGND VGND VPWR VPWR sky130_fd_sc_hd__diode_2
XFILLER_118_429 VGND VGND VPWR VPWR sky130_fd_sc_hd__fill_4
XFILLER_118_418 VGND VGND VPWR VPWR sky130_fd_sc_hd__fill_2
X_3690_ hold57/X _4484_/A0 _3698_/S VGND VGND VPWR VPWR hold58/A sky130_fd_sc_hd__mux2_1
X_2641_ _3027_/A VGND VGND VPWR VPWR _2641_/Y sky130_fd_sc_hd__inv_2
XTAP_TAPCELL_ROW_117_2052 VGND VPWR sky130_fd_sc_hd__tapvpwrvgnd_1
XFILLER_9_597 VPWR VGND VPWR VGND sky130_ef_sc_hd__decap_40_12
X_5360_ _6143_/CLK _5360_/D VGND VGND VPWR VPWR _5360_/Q sky130_fd_sc_hd__dfxtp_1
XFILLER_58_3 VGND VGND VPWR VPWR sky130_fd_sc_hd__fill_1
XTAP_TAPCELL_ROW_130_2252 VGND VPWR sky130_fd_sc_hd__tapvpwrvgnd_1
XFILLER_114_613 VPWR VGND VPWR VGND sky130_ef_sc_hd__decap_40_12
X_5291_ _6398_/CLK _5291_/D VGND VGND VPWR VPWR _5291_/Q sky130_fd_sc_hd__dfxtp_1
X_4311_ hold483/X _5043_/A1 _4315_/S VGND VGND VPWR VPWR _4311_/X sky130_fd_sc_hd__mux2_1
XFILLER_5_781 VGND VGND VPWR VPWR sky130_fd_sc_hd__fill_2
XFILLER_114_657 VPWR VGND VPWR VGND sky130_ef_sc_hd__decap_40_12
XFILLER_87_519 VGND VGND VPWR VPWR sky130_fd_sc_hd__fill_1
X_4242_ _6279_/Q _6270_/Q _4258_/S VGND VGND VPWR VPWR _4242_/X sky130_fd_sc_hd__mux2_1
XANTENNA__3299__A1 _5228_/A0 VGND VGND VPWR VPWR sky130_fd_sc_hd__diode_2
XFILLER_110_841 VGND VGND VPWR VPWR sky130_fd_sc_hd__fill_1
X_4173_ _5969_/Q _5960_/Q _4262_/S VGND VGND VPWR VPWR _4173_/X sky130_fd_sc_hd__mux2_1
X_3124_ hold549/X _5235_/A0 _3126_/S VGND VGND VPWR VPWR _3124_/X sky130_fd_sc_hd__mux2_1
XFILLER_95_585 VPWR VGND VPWR VGND sky130_ef_sc_hd__decap_40_12
XFILLER_83_725 VGND VGND VPWR VPWR sky130_fd_sc_hd__fill_2
XFILLER_67_254 VGND VGND VPWR VPWR sky130_fd_sc_hd__fill_1
XFILLER_55_416 VGND VGND VPWR VPWR sky130_fd_sc_hd__fill_2
X_3055_ _5425_/Q _5499_/Q _5355_/Q _5583_/Q _2963_/S _2962_/A VGND VGND VPWR VPWR
+ _3055_/X sky130_fd_sc_hd__mux4_1
Xclkbuf_leaf_47_clk clkload4/A VGND VGND VPWR VPWR _6254_/CLK sky130_fd_sc_hd__clkbuf_8
XFILLER_24_825 VPWR VGND VPWR VGND sky130_ef_sc_hd__decap_40_12
XANTENNA_fanout152_A _4778_/S VGND VGND VPWR VPWR sky130_fd_sc_hd__diode_2
XFILLER_51_655 VGND VGND VPWR VPWR sky130_fd_sc_hd__fill_1
XFILLER_23_335 VGND VGND VPWR VPWR sky130_fd_sc_hd__fill_1
X_3957_ _5034_/A _3957_/B VGND VGND VPWR VPWR _4007_/A sky130_fd_sc_hd__or2_2
X_2908_ _6131_/Q _5554_/Q _5753_/Q _5277_/Q _2963_/S _2962_/A VGND VGND VPWR VPWR
+ _2908_/X sky130_fd_sc_hd__mux4_1
XANTENNA__4420__B1 _3801_/B VGND VGND VPWR VPWR sky130_fd_sc_hd__diode_2
XFILLER_51_29 VGND VGND VPWR VPWR sky130_fd_sc_hd__fill_1
XFILLER_137_727 VGND VGND VPWR VPWR sky130_fd_sc_hd__fill_1
X_3888_ hold724/X _6417_/Q _3889_/S VGND VGND VPWR VPWR _3888_/X sky130_fd_sc_hd__mux2_1
X_2839_ _2735_/A _2824_/X _2838_/Y _2925_/S VGND VGND VPWR VPWR _2839_/X sky130_fd_sc_hd__o211a_1
X_5627_ _5849_/CLK _5627_/D VGND VGND VPWR VPWR _5627_/Q sky130_fd_sc_hd__dfxtp_1
X_5558_ _6137_/CLK _5558_/D VGND VGND VPWR VPWR _5558_/Q sky130_fd_sc_hd__dfxtp_1
XANTENNA_fanout205_X _5085_/A VGND VGND VPWR VPWR sky130_fd_sc_hd__diode_2
XFILLER_132_421 VGND VGND VPWR VPWR sky130_fd_sc_hd__fill_2
XFILLER_117_495 VGND VGND VPWR VPWR sky130_fd_sc_hd__fill_8
XFILLER_105_613 VGND VGND VPWR VPWR sky130_fd_sc_hd__fill_2
XTAP_TAPCELL_ROW_57_1154 VGND VPWR sky130_fd_sc_hd__tapvpwrvgnd_1
XFILLER_3_729 VPWR VGND VPWR VGND sky130_ef_sc_hd__decap_40_12
X_4509_ hold777/X _5213_/A1 _4512_/S VGND VGND VPWR VPWR _4509_/X sky130_fd_sc_hd__mux2_1
X_5489_ _5841_/CLK _5489_/D VGND VGND VPWR VPWR _5489_/Q sky130_fd_sc_hd__dfxtp_1
XFILLER_104_189 VGND VGND VPWR VPWR sky130_fd_sc_hd__fill_1
XANTENNA__4487__A0 _6413_/Q VGND VGND VPWR VPWR sky130_fd_sc_hd__diode_2
XFILLER_101_841 VGND VGND VPWR VPWR sky130_fd_sc_hd__fill_1
XTAP_TAPCELL_ROW_70_1354 VGND VPWR sky130_fd_sc_hd__tapvpwrvgnd_1
XTAP_TAPCELL_ROW_70_1343 VGND VPWR sky130_fd_sc_hd__tapvpwrvgnd_1
XANTENNA__2629__A _4809_/A VGND VGND VPWR VPWR sky130_fd_sc_hd__diode_2
XANTENNA_fanout65_A _2641_/Y VGND VGND VPWR VPWR sky130_fd_sc_hd__diode_2
XFILLER_73_202 VGND VGND VPWR VPWR sky130_fd_sc_hd__fill_2
Xclkbuf_leaf_38_clk clkload4/A VGND VGND VPWR VPWR _6428_/CLK sky130_fd_sc_hd__clkbuf_8
XANTENNA__3462__A1 _4905_/A0 VGND VGND VPWR VPWR sky130_fd_sc_hd__diode_2
XANTENNA__2635__Y _2635_/Y VGND VGND VPWR VPWR sky130_fd_sc_hd__diode_2
XFILLER_26_151 VGND VGND VPWR VPWR sky130_fd_sc_hd__fill_2
XFILLER_42_688 VGND VGND VPWR VPWR sky130_fd_sc_hd__fill_1
XANTENNA__4411__A0 _5826_/Q VGND VGND VPWR VPWR sky130_fd_sc_hd__diode_2
XANTENNA__3894__S _3899_/S VGND VGND VPWR VPWR sky130_fd_sc_hd__diode_2
XFILLER_6_501 VPWR VGND VPWR VGND sky130_ef_sc_hd__decap_40_12
XFILLER_128_749 VGND VGND VPWR VPWR sky130_fd_sc_hd__fill_4
XFILLER_10_585 VGND VGND VPWR VPWR sky130_fd_sc_hd__fill_2
XFILLER_6_545 VPWR VGND VPWR VGND sky130_ef_sc_hd__decap_40_12
XFILLER_136_793 VPWR VGND VPWR VGND sky130_ef_sc_hd__decap_40_12
XFILLER_6_589 VPWR VGND VPWR VGND sky130_ef_sc_hd__decap_40_12
XFILLER_123_487 VPWR VGND VPWR VGND sky130_ef_sc_hd__decap_40_12
XFILLER_97_839 VGND VGND VPWR VPWR sky130_fd_sc_hd__fill_1
XTAP_TAPCELL_ROW_88_1615 VGND VPWR sky130_fd_sc_hd__tapvpwrvgnd_1
XFILLER_65_703 VGND VGND VPWR VPWR sky130_fd_sc_hd__fill_1
XFILLER_92_533 VPWR VGND VPWR VGND sky130_ef_sc_hd__decap_40_12
XTAP_TAPCELL_ROW_88_1626 VGND VPWR sky130_fd_sc_hd__tapvpwrvgnd_1
XFILLER_77_585 VGND VGND VPWR VPWR sky130_fd_sc_hd__fill_4
Xclkbuf_leaf_29_clk clkload3/A VGND VGND VPWR VPWR _5583_/CLK sky130_fd_sc_hd__clkbuf_8
XFILLER_64_268 VGND VGND VPWR VPWR sky130_fd_sc_hd__fill_1
XFILLER_52_408 VGND VGND VPWR VPWR sky130_fd_sc_hd__fill_2
XFILLER_18_641 VGND VGND VPWR VPWR sky130_fd_sc_hd__fill_2
XANTENNA__3453__A1 _5239_/A1 VGND VGND VPWR VPWR sky130_fd_sc_hd__diode_2
X_4860_ _4886_/A1 _4860_/A1 _4867_/S VGND VGND VPWR VPWR _6211_/D sky130_fd_sc_hd__mux2_1
XANTENNA__3205__A1 _5080_/A0 VGND VGND VPWR VPWR sky130_fd_sc_hd__diode_2
X_3811_ _3834_/B _3811_/B VGND VGND VPWR VPWR _4922_/B sky130_fd_sc_hd__nand2_2
XANTENNA__4628__S1 _4794_/A VGND VGND VPWR VPWR sky130_fd_sc_hd__diode_2
XANTENNA__4402__A0 _4980_/A1 VGND VGND VPWR VPWR sky130_fd_sc_hd__diode_2
X_4791_ _4791_/A1 _4790_/X _4791_/B1 VGND VGND VPWR VPWR _4791_/X sky130_fd_sc_hd__o21a_1
XFILLER_21_839 VGND VGND VPWR VPWR sky130_fd_sc_hd__fill_1
XFILLER_119_727 VGND VGND VPWR VPWR sky130_fd_sc_hd__fill_1
X_3742_ hold429/X _5234_/A0 _3745_/S VGND VGND VPWR VPWR _3742_/X sky130_fd_sc_hd__mux2_1
XFILLER_13_390 VGND VGND VPWR VPWR sky130_fd_sc_hd__fill_2
XTAP_TAPCELL_ROW_99_1788 VGND VPWR sky130_fd_sc_hd__tapvpwrvgnd_1
XANTENNA__2964__B1 _3085_/A VGND VGND VPWR VPWR sky130_fd_sc_hd__diode_2
X_6461_ _6461_/A VGND VGND VPWR VPWR _6461_/X sky130_fd_sc_hd__clkbuf_1
X_3673_ _4517_/A1 _3673_/A1 _3678_/S VGND VGND VPWR VPWR _3673_/X sky130_fd_sc_hd__mux2_1
X_5412_ _6252_/CLK _5412_/D VGND VGND VPWR VPWR _5412_/Q sky130_fd_sc_hd__dfxtp_1
X_6392_ _6402_/CLK _6392_/D VGND VGND VPWR VPWR _6392_/Q sky130_fd_sc_hd__dfxtp_1
X_2624_ _2624_/A VGND VGND VPWR VPWR _5102_/A sky130_fd_sc_hd__inv_2
XFILLER_114_421 VGND VGND VPWR VPWR sky130_fd_sc_hd__fill_1
XANTENNA__2716__A0 _5047_/A1 VGND VGND VPWR VPWR sky130_fd_sc_hd__diode_2
X_5343_ _6313_/CLK _5343_/D VGND VGND VPWR VPWR _5343_/Q sky130_fd_sc_hd__dfxtp_4
XPHY_EDGE_ROW_120_Left_259 VGND VGND VPWR VPWR sky130_fd_sc_hd__decap_3
XANTENNA__3833__A _5085_/A VGND VGND VPWR VPWR sky130_fd_sc_hd__diode_2
XANTENNA__4469__A0 _5234_/A0 VGND VGND VPWR VPWR sky130_fd_sc_hd__diode_2
X_5274_ _6129_/CLK _5274_/D VGND VGND VPWR VPWR _5274_/Q sky130_fd_sc_hd__dfxtp_1
XTAP_TAPCELL_ROW_110_1955 VGND VPWR sky130_fd_sc_hd__tapvpwrvgnd_1
XTAP_TAPCELL_ROW_110_1944 VGND VPWR sky130_fd_sc_hd__tapvpwrvgnd_1
XANTENNA__5821__Q _5821_/Q VGND VGND VPWR VPWR sky130_fd_sc_hd__diode_2
XFILLER_68_541 VGND VGND VPWR VPWR sky130_fd_sc_hd__fill_2
X_4225_ _4205_/A _4220_/X _4224_/X VGND VGND VPWR VPWR _4225_/Y sky130_fd_sc_hd__a21oi_1
XFILLER_83_500 VGND VGND VPWR VPWR sky130_fd_sc_hd__fill_2
XTAP_TAPCELL_ROW_52_1084 VGND VPWR sky130_fd_sc_hd__tapvpwrvgnd_1
XTAP_TAPCELL_ROW_52_1073 VGND VPWR sky130_fd_sc_hd__tapvpwrvgnd_1
X_4156_ _4212_/A _4156_/B VGND VGND VPWR VPWR _4156_/Y sky130_fd_sc_hd__nor2_1
X_3107_ hold940/X _5232_/A0 _3112_/S VGND VGND VPWR VPWR _3107_/X sky130_fd_sc_hd__mux2_1
XFILLER_110_693 VGND VGND VPWR VPWR sky130_fd_sc_hd__fill_4
XFILLER_46_29 VGND VGND VPWR VPWR sky130_fd_sc_hd__fill_4
XANTENNA__3692__A1 _4958_/A0 VGND VGND VPWR VPWR sky130_fd_sc_hd__diode_2
X_4087_ _6301_/Q _6283_/Q _4258_/S VGND VGND VPWR VPWR _4087_/X sky130_fd_sc_hd__mux2_1
X_3038_ _3096_/A1 _3037_/X _3034_/Y _3036_/Y VGND VGND VPWR VPWR _3038_/X sky130_fd_sc_hd__o2bb2a_1
XANTENNA__3444__A1 _5075_/A0 VGND VGND VPWR VPWR sky130_fd_sc_hd__diode_2
XFILLER_83_588 VGND VGND VPWR VPWR sky130_fd_sc_hd__fill_1
XFILLER_70_205 VGND VGND VPWR VPWR sky130_fd_sc_hd__fill_4
XANTENNA_fanout155_X _4272_/S VGND VGND VPWR VPWR sky130_fd_sc_hd__diode_2
XFILLER_24_677 VGND VGND VPWR VPWR sky130_fd_sc_hd__fill_4
X_4989_ hold121/X _5043_/A1 _4993_/S VGND VGND VPWR VPWR _4989_/X sky130_fd_sc_hd__mux2_1
XFILLER_11_316 VGND VGND VPWR VPWR sky130_fd_sc_hd__fill_4
XFILLER_24_699 VGND VGND VPWR VPWR sky130_fd_sc_hd__fill_1
XFILLER_137_557 VGND VGND VPWR VPWR sky130_fd_sc_hd__fill_2
XANTENNA__3219__S _3220_/S VGND VGND VPWR VPWR sky130_fd_sc_hd__diode_2
XFILLER_118_793 VPWR VGND VPWR VGND sky130_ef_sc_hd__decap_40_12
XANTENNA__3055__S0 _2963_/S VGND VGND VPWR VPWR sky130_fd_sc_hd__diode_2
XFILLER_133_741 VPWR VGND VPWR VGND sky130_ef_sc_hd__decap_40_12
XFILLER_117_281 VGND VGND VPWR VPWR sky130_fd_sc_hd__fill_1
XANTENNA__3380__B1 _4445_/B VGND VGND VPWR VPWR sky130_fd_sc_hd__diode_2
XFILLER_3_559 VGND VGND VPWR VPWR sky130_fd_sc_hd__fill_1
XFILLER_133_785 VPWR VGND VPWR VGND sky130_ef_sc_hd__decap_40_12
XFILLER_79_839 VGND VGND VPWR VPWR sky130_fd_sc_hd__fill_1
XFILLER_94_809 VGND VGND VPWR VPWR sky130_fd_sc_hd__fill_2
XFILLER_59_541 VGND VGND VPWR VPWR sky130_fd_sc_hd__fill_2
XTAP_TAPCELL_ROW_6_386 VGND VPWR sky130_fd_sc_hd__tapvpwrvgnd_1
XFILLER_19_405 VPWR VGND VPWR VGND sky130_ef_sc_hd__decap_40_12
XFILLER_101_671 VGND VGND VPWR VPWR sky130_fd_sc_hd__fill_1
XFILLER_100_170 VGND VGND VPWR VPWR sky130_fd_sc_hd__fill_4
XFILLER_59_596 VGND VGND VPWR VPWR sky130_fd_sc_hd__fill_1
XTAP_TAPCELL_ROW_6_397 VGND VPWR sky130_fd_sc_hd__tapvpwrvgnd_1
XANTENNA_fanout68_X _4252_/A1 VGND VGND VPWR VPWR sky130_fd_sc_hd__diode_2
XFILLER_47_758 VPWR VGND VPWR VGND sky130_ef_sc_hd__decap_40_12
XFILLER_19_449 VPWR VGND VPWR VGND sky130_ef_sc_hd__decap_40_12
XANTENNA__2869__S0 _2984_/S VGND VGND VPWR VPWR sky130_fd_sc_hd__diode_2
XANTENNA__3435__A1 _4904_/A0 VGND VGND VPWR VPWR sky130_fd_sc_hd__diode_2
XTAP_TAPCELL_ROW_83_1545 VGND VPWR sky130_fd_sc_hd__tapvpwrvgnd_1
XFILLER_42_430 VGND VGND VPWR VPWR sky130_fd_sc_hd__fill_4
XFILLER_70_783 VGND VGND VPWR VPWR sky130_fd_sc_hd__fill_1
XTAP_TAPCELL_ROW_25_672 VGND VPWR sky130_fd_sc_hd__tapvpwrvgnd_1
Xinput15 s_axil_wdata[12] VGND VGND VPWR VPWR _4916_/A sky130_fd_sc_hd__buf_1
Xinput26 s_axil_wdata[8] VGND VGND VPWR VPWR _4908_/A sky130_fd_sc_hd__buf_1
XFILLER_10_360 VGND VGND VPWR VPWR sky130_fd_sc_hd__fill_4
XFILLER_7_821 VPWR VGND VPWR VGND sky130_ef_sc_hd__decap_40_12
XFILLER_6_320 VGND VGND VPWR VPWR sky130_fd_sc_hd__fill_1
XFILLER_128_557 VPWR VGND VPWR VGND sky130_ef_sc_hd__decap_40_12
XTAP_TAPCELL_ROW_114_2011 VGND VPWR sky130_fd_sc_hd__tapvpwrvgnd_1
XANTENNA__3371__B1 _3370_/X VGND VGND VPWR VPWR sky130_fd_sc_hd__diode_2
XFILLER_97_669 VGND VGND VPWR VPWR sky130_fd_sc_hd__fill_2
XFILLER_85_809 VPWR VGND VPWR VGND sky130_ef_sc_hd__decap_40_12
XANTENNA__3372__B input4/X VGND VGND VPWR VPWR sky130_fd_sc_hd__diode_2
XFILLER_2_581 VGND VGND VPWR VPWR sky130_fd_sc_hd__fill_4
XFILLER_96_179 VGND VGND VPWR VPWR sky130_fd_sc_hd__fill_4
X_4010_ _4010_/A _4010_/B VGND VGND VPWR VPWR _4010_/Y sky130_fd_sc_hd__nor2_1
XTAP_TAPCELL_ROW_125_2173 VGND VPWR sky130_fd_sc_hd__tapvpwrvgnd_1
XANTENNA__3426__A1 _4882_/A1 VGND VGND VPWR VPWR sky130_fd_sc_hd__diode_2
XFILLER_80_503 VGND VGND VPWR VPWR sky130_fd_sc_hd__fill_1
X_5961_ _6347_/CLK _5961_/D VGND VGND VPWR VPWR _5961_/Q sky130_fd_sc_hd__dfxtp_1
XFILLER_37_279 VGND VGND VPWR VPWR sky130_fd_sc_hd__fill_1
X_4912_ _4912_/A _4922_/B _4922_/C VGND VGND VPWR VPWR _4912_/X sky130_fd_sc_hd__or3_1
XANTENNA__5179__A1 _3958_/A VGND VGND VPWR VPWR sky130_fd_sc_hd__diode_2
X_5892_ _6414_/CLK _5892_/D VGND VGND VPWR VPWR _5892_/Q sky130_fd_sc_hd__dfxtp_1
X_4843_ _5238_/A1 _4843_/A1 _4854_/S VGND VGND VPWR VPWR _4843_/X sky130_fd_sc_hd__mux2_1
XFILLER_119_513 VPWR VGND VPWR VGND sky130_ef_sc_hd__decap_40_12
X_4774_ _4789_/A _4774_/B VGND VGND VPWR VPWR _4774_/X sky130_fd_sc_hd__or2_1
XANTENNA__4926__A1 _4976_/A1 VGND VGND VPWR VPWR sky130_fd_sc_hd__diode_2
XANTENNA__5816__Q _5816_/Q VGND VGND VPWR VPWR sky130_fd_sc_hd__diode_2
X_3725_ hold797/X _5044_/A1 _3728_/S VGND VGND VPWR VPWR _3725_/X sky130_fd_sc_hd__mux2_1
XFILLER_119_557 VGND VGND VPWR VPWR sky130_fd_sc_hd__fill_2
Xclkbuf_leaf_9_clk clkbuf_leaf_9_clk/A VGND VGND VPWR VPWR _6404_/CLK sky130_fd_sc_hd__clkbuf_8
XANTENNA__3037__S0 _3062_/S VGND VGND VPWR VPWR sky130_fd_sc_hd__diode_2
XANTENNA_fanout115_A _5820_/Q VGND VGND VPWR VPWR sky130_fd_sc_hd__diode_2
X_3656_ hold431/X _4521_/A1 _3657_/S VGND VGND VPWR VPWR _3656_/X sky130_fd_sc_hd__mux2_1
XFILLER_115_741 VPWR VGND VPWR VGND sky130_ef_sc_hd__decap_40_12
X_3587_ hold520/X _4484_/A0 _3595_/S VGND VGND VPWR VPWR _3587_/X sky130_fd_sc_hd__mux2_1
X_6375_ _6382_/CLK _6375_/D VGND VGND VPWR VPWR _6375_/Q sky130_fd_sc_hd__dfxtp_1
XFILLER_115_785 VPWR VGND VPWR VGND sky130_ef_sc_hd__decap_40_12
X_5326_ _6405_/CLK _5326_/D VGND VGND VPWR VPWR _5326_/Q sky130_fd_sc_hd__dfxtp_1
XTAP_TAPCELL_ROW_54_1113 VGND VPWR sky130_fd_sc_hd__tapvpwrvgnd_1
XFILLER_0_529 VGND VGND VPWR VPWR sky130_fd_sc_hd__fill_2
XANTENNA__3362__B1 _5201_/B VGND VGND VPWR VPWR sky130_fd_sc_hd__diode_2
XFILLER_130_755 VGND VGND VPWR VPWR sky130_fd_sc_hd__fill_1
XFILLER_88_658 VGND VGND VPWR VPWR sky130_fd_sc_hd__fill_2
X_5257_ _6409_/CLK _5257_/D VGND VGND VPWR VPWR _5257_/Q sky130_fd_sc_hd__dfxtp_1
X_4208_ hold123/X hold558/X _4262_/S VGND VGND VPWR VPWR _4208_/X sky130_fd_sc_hd__mux2_1
XANTENNA__4862__A0 _4901_/A0 VGND VGND VPWR VPWR sky130_fd_sc_hd__diode_2
X_5188_ _5186_/Y _5188_/A2 _5085_/A VGND VGND VPWR VPWR _5188_/Y sky130_fd_sc_hd__a21oi_1
XTAP_TAPCELL_ROW_3_345 VGND VPWR sky130_fd_sc_hd__tapvpwrvgnd_1
XANTENNA__3502__S _3503_/S VGND VGND VPWR VPWR sky130_fd_sc_hd__diode_2
XFILLER_95_190 VGND VGND VPWR VPWR sky130_fd_sc_hd__fill_1
X_4139_ _4149_/A _4134_/X _4136_/X _4138_/X VGND VGND VPWR VPWR _4139_/X sky130_fd_sc_hd__a22o_1
XFILLER_28_235 VGND VGND VPWR VPWR sky130_fd_sc_hd__fill_1
XANTENNA__3417__A1 _5210_/A1 VGND VGND VPWR VPWR sky130_fd_sc_hd__diode_2
XFILLER_16_419 VGND VGND VPWR VPWR sky130_fd_sc_hd__fill_1
XTAP_TAPCELL_ROW_42_929 VGND VPWR sky130_fd_sc_hd__tapvpwrvgnd_1
XFILLER_24_463 VGND VGND VPWR VPWR sky130_fd_sc_hd__fill_1
XTAP_TAPCELL_ROW_65_1275 VGND VPWR sky130_fd_sc_hd__tapvpwrvgnd_1
XFILLER_12_625 VPWR VGND VPWR VGND sky130_ef_sc_hd__decap_40_12
XFILLER_24_485 VGND VGND VPWR VPWR sky130_fd_sc_hd__fill_1
XANTENNA__2642__A _3044_/A VGND VGND VPWR VPWR sky130_fd_sc_hd__diode_2
XFILLER_12_669 VPWR VGND VPWR VGND sky130_ef_sc_hd__decap_40_12
XTAP_TAPCELL_ROW_22_631 VGND VPWR sky130_fd_sc_hd__tapvpwrvgnd_1
XFILLER_22_31 VGND VGND VPWR VPWR sky130_fd_sc_hd__fill_1
XFILLER_125_505 VPWR VGND VPWR VGND sky130_ef_sc_hd__decap_40_12
XFILLER_125_3 VPWR VGND VPWR VGND sky130_ef_sc_hd__decap_40_12
XFILLER_22_64 VGND VGND VPWR VPWR sky130_fd_sc_hd__fill_4
XFILLER_138_53 VGND VGND VPWR VPWR sky130_fd_sc_hd__fill_2
XFILLER_4_813 VPWR VGND VPWR VGND sky130_ef_sc_hd__decap_40_12
XANTENNA__4569__A _4794_/A VGND VGND VPWR VPWR sky130_fd_sc_hd__diode_2
XFILLER_3_334 VGND VGND VPWR VPWR sky130_fd_sc_hd__fill_2
XFILLER_3_389 VGND VGND VPWR VPWR sky130_fd_sc_hd__fill_2
XFILLER_121_777 VGND VGND VPWR VPWR sky130_fd_sc_hd__fill_4
XFILLER_79_669 VGND VGND VPWR VPWR sky130_fd_sc_hd__fill_1
XFILLER_78_157 VGND VGND VPWR VPWR sky130_fd_sc_hd__fill_1
Xfanout192 _3016_/S VGND VGND VPWR VPWR _2984_/S sky130_fd_sc_hd__buf_6
XANTENNA__4853__A0 _4905_/A0 VGND VGND VPWR VPWR sky130_fd_sc_hd__diode_2
Xfanout181 _5267_/Q VGND VGND VPWR VPWR _2962_/A sky130_fd_sc_hd__buf_4
XFILLER_59_371 VGND VGND VPWR VPWR sky130_fd_sc_hd__fill_1
XANTENNA__3656__A1 _4521_/A1 VGND VGND VPWR VPWR sky130_fd_sc_hd__diode_2
Xfanout170 _4221_/S VGND VGND VPWR VPWR _4228_/S sky130_fd_sc_hd__clkbuf_8
XFILLER_101_490 VGND VGND VPWR VPWR sky130_fd_sc_hd__fill_1
XFILLER_74_341 VGND VGND VPWR VPWR sky130_fd_sc_hd__fill_2
XFILLER_47_61 VGND VGND VPWR VPWR sky130_fd_sc_hd__fill_2
XFILLER_62_503 VGND VGND VPWR VPWR sky130_fd_sc_hd__fill_1
XFILLER_47_599 VGND VGND VPWR VPWR sky130_fd_sc_hd__fill_1
XFILLER_35_717 VGND VGND VPWR VPWR sky130_fd_sc_hd__fill_2
XANTENNA__4081__A1 _4252_/A1 VGND VGND VPWR VPWR sky130_fd_sc_hd__diode_2
XFILLER_15_441 VGND VGND VPWR VPWR sky130_fd_sc_hd__fill_4
XFILLER_27_290 VGND VGND VPWR VPWR sky130_fd_sc_hd__fill_2
Xclkbuf_3_4__f_clk clkbuf_0_clk/X VGND VGND VPWR VPWR clkload3/A sky130_fd_sc_hd__clkbuf_16
XFILLER_70_591 VGND VGND VPWR VPWR sky130_fd_sc_hd__fill_1
XFILLER_43_783 VGND VGND VPWR VPWR sky130_fd_sc_hd__fill_1
XFILLER_15_485 VPWR VGND VPWR VGND sky130_ef_sc_hd__decap_40_12
XFILLER_8_33 VGND VGND VPWR VPWR sky130_fd_sc_hd__fill_1
XFILLER_30_433 VPWR VGND VPWR VGND sky130_ef_sc_hd__decap_40_12
XFILLER_129_833 VGND VGND VPWR VPWR sky130_fd_sc_hd__fill_4
XTAP_TAPCELL_ROW_96_1736 VGND VPWR sky130_fd_sc_hd__tapvpwrvgnd_1
X_3510_ _5075_/A0 _3510_/A1 _3516_/S VGND VGND VPWR VPWR _3510_/X sky130_fd_sc_hd__mux2_1
XTAP_TAPCELL_ROW_96_1747 VGND VPWR sky130_fd_sc_hd__tapvpwrvgnd_1
X_4490_ _6416_/Q _4490_/A1 _4492_/S VGND VGND VPWR VPWR _4490_/X sky130_fd_sc_hd__mux2_1
Xhold607 _3420_/X VGND VGND VPWR VPWR _5473_/D sky130_fd_sc_hd__dlygate4sd3_1
Xhold618 _5475_/Q VGND VGND VPWR VPWR hold618/X sky130_fd_sc_hd__dlygate4sd3_1
XFILLER_7_673 VPWR VGND VPWR VGND sky130_ef_sc_hd__decap_40_12
XFILLER_6_150 VGND VGND VPWR VPWR sky130_fd_sc_hd__fill_1
XANTENNA__5074__S _5081_/S VGND VGND VPWR VPWR sky130_fd_sc_hd__diode_2
X_3441_ hold133/X _5228_/A0 _3450_/S VGND VGND VPWR VPWR _3441_/X sky130_fd_sc_hd__mux2_1
Xhold629 _5938_/Q VGND VGND VPWR VPWR hold629/X sky130_fd_sc_hd__dlygate4sd3_1
X_6160_ _6241_/CLK _6160_/D VGND VGND VPWR VPWR _6160_/Q sky130_fd_sc_hd__dfxtp_1
X_3372_ input5/X input4/X VGND VGND VPWR VPWR _4445_/B sky130_fd_sc_hd__and2b_4
XFILLER_40_3 VGND VGND VPWR VPWR sky130_fd_sc_hd__fill_1
Xhold2008 _6164_/Q VGND VGND VPWR VPWR _4647_/A1 sky130_fd_sc_hd__dlygate4sd3_1
XANTENNA__3895__A1 _4488_/A0 VGND VGND VPWR VPWR sky130_fd_sc_hd__diode_2
X_5111_ _3975_/C _5099_/B _5110_/X _4997_/A _5034_/B VGND VGND VPWR VPWR _5111_/X
+ sky130_fd_sc_hd__o221a_1
Xhold1307 _5540_/Q VGND VGND VPWR VPWR _3495_/A1 sky130_fd_sc_hd__dlygate4sd3_1
XTAP_TAPCELL_ROW_127_2202 VGND VPWR sky130_fd_sc_hd__tapvpwrvgnd_1
XFILLER_112_755 VGND VGND VPWR VPWR sky130_fd_sc_hd__fill_1
Xhold2019 _5197_/Y VGND VGND VPWR VPWR _6404_/D sky130_fd_sc_hd__dlygate4sd3_1
X_6091_ _6094_/CLK _6091_/D VGND VGND VPWR VPWR _6091_/Q sky130_fd_sc_hd__dfxtp_1
XANTENNA__4844__A0 _5239_/A1 VGND VGND VPWR VPWR sky130_fd_sc_hd__diode_2
X_5042_ hold193/X _5042_/A1 _5047_/S VGND VGND VPWR VPWR _5042_/X sky130_fd_sc_hd__mux2_1
Xhold1329 _2713_/X VGND VGND VPWR VPWR _5261_/D sky130_fd_sc_hd__dlygate4sd3_1
Xhold1318 _6272_/Q VGND VGND VPWR VPWR _4936_/A1 sky130_fd_sc_hd__dlygate4sd3_1
XANTENNA__3647__A1 _5202_/A1 VGND VGND VPWR VPWR sky130_fd_sc_hd__diode_2
XFILLER_84_149 VGND VGND VPWR VPWR sky130_fd_sc_hd__fill_2
XFILLER_53_503 VGND VGND VPWR VPWR sky130_fd_sc_hd__fill_1
XTAP_TAPCELL_ROW_0_304 VGND VPWR sky130_fd_sc_hd__tapvpwrvgnd_1
XFILLER_80_311 VGND VGND VPWR VPWR sky130_fd_sc_hd__fill_1
XFILLER_80_377 VGND VGND VPWR VPWR sky130_fd_sc_hd__fill_1
XANTENNA__4072__A1 _4264_/A1 VGND VGND VPWR VPWR sky130_fd_sc_hd__diode_2
X_5944_ _6315_/CLK _5944_/D VGND VGND VPWR VPWR _5944_/Q sky130_fd_sc_hd__dfxtp_1
XTAP_TAPCELL_ROW_105_1876 VGND VPWR sky130_fd_sc_hd__tapvpwrvgnd_1
X_5875_ _6095_/CLK _5875_/D VGND VGND VPWR VPWR _5875_/Q sky130_fd_sc_hd__dfxtp_1
X_4826_ _4904_/A0 hold769/X _4828_/S VGND VGND VPWR VPWR _4826_/X sky130_fd_sc_hd__mux2_1
XTAP_TAPCELL_ROW_138_2375 VGND VPWR sky130_fd_sc_hd__tapvpwrvgnd_1
XTAP_TAPCELL_ROW_138_2364 VGND VPWR sky130_fd_sc_hd__tapvpwrvgnd_1
XTAP_TAPCELL_ROW_138_2386 VGND VPWR sky130_fd_sc_hd__tapvpwrvgnd_1
XFILLER_119_343 VGND VGND VPWR VPWR sky130_fd_sc_hd__fill_1
X_4757_ _3278_/A _4756_/X _4676_/A VGND VGND VPWR VPWR _4757_/Y sky130_fd_sc_hd__a21oi_1
XTAP_TAPCELL_ROW_60_1194 VGND VPWR sky130_fd_sc_hd__tapvpwrvgnd_1
XANTENNA_fanout118_X _5241_/A1 VGND VGND VPWR VPWR sky130_fd_sc_hd__diode_2
X_4688_ _4684_/X _4685_/X _4686_/X _4687_/X _4791_/A1 _4792_/A1 VGND VGND VPWR VPWR
+ _4688_/X sky130_fd_sc_hd__mux4_1
X_3708_ _4965_/A _3708_/B VGND VGND VPWR VPWR _3717_/S sky130_fd_sc_hd__nor2_4
X_6427_ _6428_/CLK _6427_/D VGND VGND VPWR VPWR _6427_/Q sky130_fd_sc_hd__dfxtp_1
XFILLER_107_549 VGND VGND VPWR VPWR sky130_fd_sc_hd__fill_8
X_3639_ hold608/X _4484_/A0 _3647_/S VGND VGND VPWR VPWR _3639_/X sky130_fd_sc_hd__mux2_1
X_6358_ _6386_/CLK _6358_/D VGND VGND VPWR VPWR _6358_/Q sky130_fd_sc_hd__dfxtp_1
XTAP_TAPCELL_ROW_8_426 VGND VPWR sky130_fd_sc_hd__tapvpwrvgnd_1
XTAP_TAPCELL_ROW_8_415 VGND VPWR sky130_fd_sc_hd__tapvpwrvgnd_1
X_5309_ _6432_/CLK _5309_/D VGND VGND VPWR VPWR _5309_/Q sky130_fd_sc_hd__dfxtp_1
XFILLER_108_89 VGND VGND VPWR VPWR sky130_fd_sc_hd__fill_2
XANTENNA__3886__A1 _6415_/Q VGND VGND VPWR VPWR sky130_fd_sc_hd__diode_2
XFILLER_68_27 VGND VGND VPWR VPWR sky130_fd_sc_hd__fill_1
XFILLER_0_337 VGND VGND VPWR VPWR sky130_fd_sc_hd__fill_8
XFILLER_103_777 VGND VGND VPWR VPWR sky130_fd_sc_hd__fill_4
XFILLER_49_809 VPWR VGND VPWR VGND sky130_ef_sc_hd__decap_40_12
X_6289_ _6307_/CLK _6289_/D VGND VGND VPWR VPWR _6289_/Q sky130_fd_sc_hd__dfxtp_1
XFILLER_130_585 VGND VGND VPWR VPWR sky130_fd_sc_hd__fill_2
XFILLER_102_276 VGND VGND VPWR VPWR sky130_fd_sc_hd__fill_1
XANTENNA__4835__A0 _4887_/A1 VGND VGND VPWR VPWR sky130_fd_sc_hd__diode_2
Xhold1863 _5567_/Q VGND VGND VPWR VPWR _3524_/A1 sky130_fd_sc_hd__dlygate4sd3_1
XFILLER_91_609 VGND VGND VPWR VPWR sky130_fd_sc_hd__fill_4
Xhold1852 _4835_/X VGND VGND VPWR VPWR _6188_/D sky130_fd_sc_hd__dlygate4sd3_1
Xhold1841 _5090_/X VGND VGND VPWR VPWR _6378_/D sky130_fd_sc_hd__dlygate4sd3_1
XFILLER_75_138 VGND VGND VPWR VPWR sky130_fd_sc_hd__fill_8
Xhold1830 _6029_/Q VGND VGND VPWR VPWR _4390_/A1 sky130_fd_sc_hd__dlygate4sd3_1
XFILLER_29_544 VGND VGND VPWR VPWR sky130_fd_sc_hd__fill_1
Xhold1874 _4490_/X VGND VGND VPWR VPWR _6096_/D sky130_fd_sc_hd__dlygate4sd3_1
XFILLER_84_672 VGND VGND VPWR VPWR sky130_fd_sc_hd__fill_1
Xhold1896 _6376_/Q VGND VGND VPWR VPWR _5088_/A0 sky130_fd_sc_hd__dlygate4sd3_1
XTAP_TAPCELL_ROW_67_1304 VGND VPWR sky130_fd_sc_hd__tapvpwrvgnd_1
Xhold1885 _5464_/Q VGND VGND VPWR VPWR _3409_/A1 sky130_fd_sc_hd__dlygate4sd3_1
XTAP_TAPCELL_ROW_27_701 VGND VPWR sky130_fd_sc_hd__tapvpwrvgnd_1
XFILLER_17_53 VGND VGND VPWR VPWR sky130_fd_sc_hd__fill_2
XTAP_TAPCELL_ROW_27_712 VGND VPWR sky130_fd_sc_hd__tapvpwrvgnd_1
XANTENNA__2643__Y _3092_/A VGND VGND VPWR VPWR sky130_fd_sc_hd__diode_2
XTAP_TAPCELL_ROW_80_1504 VGND VPWR sky130_fd_sc_hd__tapvpwrvgnd_1
XANTENNA__3810__A1 _5237_/A0 VGND VGND VPWR VPWR sky130_fd_sc_hd__diode_2
XFILLER_129_107 VGND VGND VPWR VPWR sky130_fd_sc_hd__fill_4
XFILLER_12_433 VPWR VGND VPWR VGND sky130_ef_sc_hd__decap_40_12
XFILLER_12_477 VPWR VGND VPWR VGND sky130_ef_sc_hd__decap_40_12
XFILLER_138_641 VGND VGND VPWR VPWR sky130_fd_sc_hd__fill_2
XFILLER_138_685 VPWR VGND VPWR VGND sky130_ef_sc_hd__decap_40_12
XFILLER_126_825 VPWR VGND VPWR VGND sky130_ef_sc_hd__decap_40_12
XFILLER_99_709 VPWR VGND VPWR VGND sky130_ef_sc_hd__decap_40_12
XTAP_TAPCELL_ROW_78_1477 VGND VPWR sky130_fd_sc_hd__tapvpwrvgnd_1
XTAP_TAPCELL_ROW_78_1466 VGND VPWR sky130_fd_sc_hd__tapvpwrvgnd_1
XFILLER_4_643 VGND VGND VPWR VPWR sky130_fd_sc_hd__fill_1
XTAP_TAPCELL_ROW_91_1666 VGND VPWR sky130_fd_sc_hd__tapvpwrvgnd_1
XANTENNA__5079__A0 _5235_/A0 VGND VGND VPWR VPWR sky130_fd_sc_hd__diode_2
XFILLER_67_617 VGND VGND VPWR VPWR sky130_fd_sc_hd__fill_2
XFILLER_121_585 VPWR VGND VPWR VGND sky130_ef_sc_hd__decap_40_12
XANTENNA__4826__A0 _4904_/A0 VGND VGND VPWR VPWR sky130_fd_sc_hd__diode_2
XFILLER_79_499 VGND VGND VPWR VPWR sky130_fd_sc_hd__fill_2
Xhold4 hold4/A VGND VGND VPWR VPWR hold4/X sky130_fd_sc_hd__dlygate4sd3_1
XANTENNA__3629__A1 _4484_/A0 VGND VGND VPWR VPWR sky130_fd_sc_hd__diode_2
XFILLER_81_119 VGND VGND VPWR VPWR sky130_fd_sc_hd__fill_1
XFILLER_75_650 VGND VGND VPWR VPWR sky130_fd_sc_hd__fill_1
XFILLER_47_374 VGND VGND VPWR VPWR sky130_fd_sc_hd__fill_8
XFILLER_35_503 VGND VGND VPWR VPWR sky130_fd_sc_hd__fill_1
XTAP_TAPCELL_ROW_122_2132 VGND VPWR sky130_fd_sc_hd__tapvpwrvgnd_1
X_3990_ _3980_/Y _5010_/A _3958_/Y VGND VGND VPWR VPWR _3991_/B sky130_fd_sc_hd__o21ai_1
XFILLER_35_558 VGND VGND VPWR VPWR sky130_fd_sc_hd__fill_2
X_2941_ _6132_/Q _5555_/Q _3030_/S VGND VGND VPWR VPWR _2942_/B sky130_fd_sc_hd__mux2_1
XFILLER_62_399 VGND VGND VPWR VPWR sky130_fd_sc_hd__fill_2
X_5660_ _5681_/CLK _5660_/D VGND VGND VPWR VPWR _5660_/Q sky130_fd_sc_hd__dfxtp_1
X_2872_ _6427_/Q _5312_/Q _3072_/S VGND VGND VPWR VPWR _2872_/X sky130_fd_sc_hd__mux2_1
X_4611_ _4794_/A _4611_/B VGND VGND VPWR VPWR _4611_/X sky130_fd_sc_hd__or2_1
XFILLER_31_797 VPWR VGND VPWR VGND sky130_ef_sc_hd__decap_40_12
XFILLER_129_641 VPWR VGND VPWR VGND sky130_ef_sc_hd__decap_40_12
XTAP_TAPCELL_ROW_100_1795 VGND VPWR sky130_fd_sc_hd__tapvpwrvgnd_1
X_5591_ _6098_/CLK _5591_/D VGND VGND VPWR VPWR _5591_/Q sky130_fd_sc_hd__dfxtp_1
XTAP_TAPCELL_ROW_13_494 VGND VPWR sky130_fd_sc_hd__tapvpwrvgnd_1
XFILLER_129_685 VPWR VGND VPWR VGND sky130_ef_sc_hd__decap_40_12
X_4542_ hold256/X _5232_/A0 _4547_/S VGND VGND VPWR VPWR _4542_/X sky130_fd_sc_hd__mux2_1
Xhold426 _2745_/X VGND VGND VPWR VPWR _5275_/D sky130_fd_sc_hd__dlygate4sd3_1
X_4473_ _4493_/A _4513_/A VGND VGND VPWR VPWR _4482_/S sky130_fd_sc_hd__nor2_4
Xhold415 _5998_/Q VGND VGND VPWR VPWR hold415/X sky130_fd_sc_hd__dlygate4sd3_1
Xhold404 _3759_/X VGND VGND VPWR VPWR _5770_/D sky130_fd_sc_hd__dlygate4sd3_1
Xhold437 _5312_/Q VGND VGND VPWR VPWR hold437/X sky130_fd_sc_hd__dlygate4sd3_1
XTAP_TAPCELL_ROW_133_2294 VGND VPWR sky130_fd_sc_hd__tapvpwrvgnd_1
X_3424_ _4548_/A _3464_/B _3424_/C VGND VGND VPWR VPWR _4842_/B sky130_fd_sc_hd__or3_4
X_6212_ _6237_/CLK _6212_/D VGND VGND VPWR VPWR _6212_/Q sky130_fd_sc_hd__dfxtp_1
Xhold448 _4515_/X VGND VGND VPWR VPWR _6118_/D sky130_fd_sc_hd__dlygate4sd3_1
Xhold459 _5715_/Q VGND VGND VPWR VPWR hold459/X sky130_fd_sc_hd__dlygate4sd3_1
XPHY_EDGE_ROW_115_Right_115 VGND VGND VPWR VPWR sky130_fd_sc_hd__decap_3
X_6143_ _6143_/CLK _6143_/D VGND VGND VPWR VPWR _6143_/Q sky130_fd_sc_hd__dfxtp_1
XFILLER_98_753 VGND VGND VPWR VPWR sky130_fd_sc_hd__fill_2
X_3355_ _5214_/A0 _3354_/X _3365_/S VGND VGND VPWR VPWR _3355_/X sky130_fd_sc_hd__mux2_1
X_3286_ _3286_/A0 _4445_/A _3295_/S VGND VGND VPWR VPWR _3286_/X sky130_fd_sc_hd__mux2_1
X_6074_ _6365_/CLK _6074_/D VGND VGND VPWR VPWR _6074_/Q sky130_fd_sc_hd__dfxtp_1
XFILLER_112_585 VGND VGND VPWR VPWR sky130_fd_sc_hd__fill_2
XFILLER_100_725 VPWR VGND VPWR VGND sky130_ef_sc_hd__decap_40_12
Xhold1115 _3508_/X VGND VGND VPWR VPWR _5552_/D sky130_fd_sc_hd__dlygate4sd3_1
XFILLER_97_285 VGND VGND VPWR VPWR sky130_fd_sc_hd__fill_1
XFILLER_97_274 VGND VGND VPWR VPWR sky130_fd_sc_hd__fill_4
XANTENNA__4817__A0 _4882_/A1 VGND VGND VPWR VPWR sky130_fd_sc_hd__diode_2
Xhold1104 _5848_/Q VGND VGND VPWR VPWR _3866_/A1 sky130_fd_sc_hd__dlygate4sd3_1
XFILLER_100_769 VPWR VGND VPWR VGND sky130_ef_sc_hd__decap_40_12
Xhold1137 _2715_/X VGND VGND VPWR VPWR _5263_/D sky130_fd_sc_hd__dlygate4sd3_1
X_5025_ _6359_/Q _6330_/Q VGND VGND VPWR VPWR _5025_/Y sky130_fd_sc_hd__nand2_1
Xhold1126 _5467_/Q VGND VGND VPWR VPWR _3412_/A1 sky130_fd_sc_hd__dlygate4sd3_1
Xhold1148 _5996_/Q VGND VGND VPWR VPWR _4353_/A0 sky130_fd_sc_hd__dlygate4sd3_1
XTAP_TAPCELL_ROW_107_1905 VGND VPWR sky130_fd_sc_hd__tapvpwrvgnd_1
XFILLER_72_119 VGND VGND VPWR VPWR sky130_fd_sc_hd__fill_2
XFILLER_54_801 VGND VGND VPWR VPWR sky130_fd_sc_hd__fill_8
XANTENNA__4293__A1 _4983_/A1 VGND VGND VPWR VPWR sky130_fd_sc_hd__diode_2
Xhold1159 _3900_/X VGND VGND VPWR VPWR _5879_/D sky130_fd_sc_hd__dlygate4sd3_1
XTAP_TAPCELL_ROW_49_1034 VGND VPWR sky130_fd_sc_hd__tapvpwrvgnd_1
XANTENNA__2891__S _3091_/S VGND VGND VPWR VPWR sky130_fd_sc_hd__diode_2
XFILLER_80_141 VGND VGND VPWR VPWR sky130_fd_sc_hd__fill_2
X_5927_ _6420_/CLK _5927_/D VGND VGND VPWR VPWR _5927_/Q sky130_fd_sc_hd__dfxtp_1
XTAP_TAPCELL_ROW_62_1234 VGND VPWR sky130_fd_sc_hd__tapvpwrvgnd_1
XTAP_TAPCELL_ROW_62_1223 VGND VPWR sky130_fd_sc_hd__tapvpwrvgnd_1
XFILLER_22_753 VGND VGND VPWR VPWR sky130_fd_sc_hd__fill_2
X_5858_ _5870_/CLK _5858_/D VGND VGND VPWR VPWR _5858_/Q sky130_fd_sc_hd__dfxtp_1
XPHY_EDGE_ROW_17_Right_17 VGND VGND VPWR VPWR sky130_fd_sc_hd__decap_3
XTAP_TAPCELL_ROW_32_781 VGND VPWR sky130_fd_sc_hd__tapvpwrvgnd_1
X_5789_ _6121_/CLK _5789_/D VGND VGND VPWR VPWR _5789_/Q sky130_fd_sc_hd__dfxtp_1
X_4809_ _4809_/A _4809_/B VGND VGND VPWR VPWR _4809_/X sky130_fd_sc_hd__or2_1
XFILLER_108_825 VPWR VGND VPWR VGND sky130_ef_sc_hd__decap_40_12
XFILLER_134_165 VGND VGND VPWR VPWR sky130_fd_sc_hd__fill_1
Xhold971 _3289_/X VGND VGND VPWR VPWR _5408_/D sky130_fd_sc_hd__dlygate4sd3_1
XFILLER_123_839 VGND VGND VPWR VPWR sky130_fd_sc_hd__fill_1
Xhold960 _5793_/Q VGND VGND VPWR VPWR hold960/X sky130_fd_sc_hd__dlygate4sd3_1
Xhold982 _3722_/X VGND VGND VPWR VPWR _5740_/D sky130_fd_sc_hd__dlygate4sd3_1
XFILLER_1_613 VGND VGND VPWR VPWR sky130_fd_sc_hd__fill_2
XANTENNA_fanout95_A _5832_/Q VGND VGND VPWR VPWR sky130_fd_sc_hd__diode_2
XFILLER_135_65 VGND VGND VPWR VPWR sky130_fd_sc_hd__fill_1
Xhold993 _6187_/Q VGND VGND VPWR VPWR hold993/X sky130_fd_sc_hd__dlygate4sd3_1
XFILLER_89_753 VPWR VGND VPWR VGND sky130_ef_sc_hd__decap_40_12
XFILLER_130_360 VGND VGND VPWR VPWR sky130_fd_sc_hd__fill_1
XFILLER_103_585 VPWR VGND VPWR VGND sky130_ef_sc_hd__decap_40_12
XFILLER_89_797 VPWR VGND VPWR VGND sky130_ef_sc_hd__decap_40_12
XTAP_TAPCELL_ROW_73_1396 VGND VPWR sky130_fd_sc_hd__tapvpwrvgnd_1
XPHY_EDGE_ROW_26_Right_26 VGND VGND VPWR VPWR sky130_fd_sc_hd__decap_3
Xhold1671 _3522_/X VGND VGND VPWR VPWR _5565_/D sky130_fd_sc_hd__dlygate4sd3_1
XFILLER_76_469 VGND VGND VPWR VPWR sky130_fd_sc_hd__fill_4
XANTENNA__4284__A1 _5047_/A1 VGND VGND VPWR VPWR sky130_fd_sc_hd__diode_2
Xhold1660 _5779_/Q VGND VGND VPWR VPWR _4049_/A0 sky130_fd_sc_hd__dlygate4sd3_1
XFILLER_17_503 VGND VGND VPWR VPWR sky130_fd_sc_hd__fill_1
XANTENNA__3897__S _3899_/S VGND VGND VPWR VPWR sky130_fd_sc_hd__diode_2
Xhold1693 _5466_/Q VGND VGND VPWR VPWR _3411_/A1 sky130_fd_sc_hd__dlygate4sd3_1
Xhold1682 _4396_/X VGND VGND VPWR VPWR _6035_/D sky130_fd_sc_hd__dlygate4sd3_1
XANTENNA__5233__A0 _5233_/A0 VGND VGND VPWR VPWR sky130_fd_sc_hd__diode_2
XFILLER_71_152 VPWR VGND VPWR VGND sky130_ef_sc_hd__decap_40_12
XFILLER_60_837 VGND VGND VPWR VPWR sky130_fd_sc_hd__fill_4
XFILLER_44_62 VPWR VGND VPWR VGND sky130_ef_sc_hd__decap_40_12
XFILLER_44_40 VGND VGND VPWR VPWR sky130_fd_sc_hd__fill_1
XFILLER_13_753 VPWR VGND VPWR VGND sky130_ef_sc_hd__decap_40_12
XFILLER_12_241 VGND VGND VPWR VPWR sky130_fd_sc_hd__fill_1
XPHY_EDGE_ROW_35_Right_35 VGND VGND VPWR VPWR sky130_fd_sc_hd__decap_3
XFILLER_13_797 VPWR VGND VPWR VGND sky130_ef_sc_hd__decap_40_12
XFILLER_60_83 VGND VGND VPWR VPWR sky130_fd_sc_hd__fill_1
XTAP_TAPCELL_ROW_10_453 VGND VPWR sky130_fd_sc_hd__tapvpwrvgnd_1
XFILLER_126_699 VGND VGND VPWR VPWR sky130_fd_sc_hd__fill_1
XFILLER_4_473 VGND VGND VPWR VPWR sky130_fd_sc_hd__fill_2
XPHY_EDGE_ROW_44_Right_44 VGND VGND VPWR VPWR sky130_fd_sc_hd__decap_3
X_3140_ _3138_/B _3136_/Y _3390_/S _5200_/A VGND VGND VPWR VPWR _3140_/X sky130_fd_sc_hd__a22o_1
XFILLER_121_393 VGND VGND VPWR VPWR sky130_fd_sc_hd__fill_1
X_3071_ hold91/A _5380_/Q _5368_/Q _6149_/Q _2984_/S _2985_/A VGND VGND VPWR VPWR
+ _3071_/X sky130_fd_sc_hd__mux4_1
XFILLER_35_355 VGND VGND VPWR VPWR sky130_fd_sc_hd__fill_1
XFILLER_51_837 VGND VGND VPWR VPWR sky130_fd_sc_hd__fill_2
XTAP_TAPCELL_ROW_18_564 VGND VPWR sky130_fd_sc_hd__tapvpwrvgnd_1
XTAP_TAPCELL_ROW_18_575 VGND VPWR sky130_fd_sc_hd__tapvpwrvgnd_1
XTAP_TAPCELL_ROW_102_1835 VGND VPWR sky130_fd_sc_hd__tapvpwrvgnd_1
XTAP_TAPCELL_ROW_102_1824 VGND VPWR sky130_fd_sc_hd__tapvpwrvgnd_1
X_3973_ _6388_/Q _3973_/B _6386_/Q _6385_/Q VGND VGND VPWR VPWR _5099_/D sky130_fd_sc_hd__or4_1
XPHY_EDGE_ROW_53_Right_53 VGND VGND VPWR VPWR sky130_fd_sc_hd__decap_3
X_5712_ _5898_/CLK _5712_/D VGND VGND VPWR VPWR _5712_/Q sky130_fd_sc_hd__dfxtp_1
XFILLER_50_347 VGND VGND VPWR VPWR sky130_fd_sc_hd__fill_4
X_2924_ _2910_/X _2923_/X _2981_/S VGND VGND VPWR VPWR _2924_/X sky130_fd_sc_hd__mux2_1
XFILLER_31_572 VGND VGND VPWR VPWR sky130_fd_sc_hd__fill_1
X_2855_ _6072_/Q _6364_/Q _3072_/S VGND VGND VPWR VPWR _2856_/B sky130_fd_sc_hd__mux2_1
XTAP_TAPCELL_ROW_135_2323 VGND VPWR sky130_fd_sc_hd__tapvpwrvgnd_1
X_5643_ _6382_/CLK _5643_/D VGND VGND VPWR VPWR _5643_/Q sky130_fd_sc_hd__dfxtp_1
X_5574_ _5583_/CLK _5574_/D VGND VGND VPWR VPWR _5574_/Q sky130_fd_sc_hd__dfxtp_1
X_2786_ _6424_/Q _5309_/Q _3016_/S VGND VGND VPWR VPWR _2786_/X sky130_fd_sc_hd__mux2_1
X_4525_ hold620/X _4883_/A1 _4532_/S VGND VGND VPWR VPWR _6127_/D sky130_fd_sc_hd__mux2_1
Xhold201 _5948_/Q VGND VGND VPWR VPWR hold201/X sky130_fd_sc_hd__dlygate4sd3_1
Xhold234 _6141_/Q VGND VGND VPWR VPWR hold234/X sky130_fd_sc_hd__dlygate4sd3_1
XFILLER_116_143 VGND VGND VPWR VPWR sky130_fd_sc_hd__fill_1
XFILLER_104_305 VGND VGND VPWR VPWR sky130_fd_sc_hd__fill_1
XANTENNA__5824__Q _5824_/Q VGND VGND VPWR VPWR sky130_fd_sc_hd__diode_2
Xhold223 _3882_/X VGND VGND VPWR VPWR _5862_/D sky130_fd_sc_hd__dlygate4sd3_1
Xhold212 _5444_/Q VGND VGND VPWR VPWR hold212/X sky130_fd_sc_hd__dlygate4sd3_1
Xhold278 _6062_/Q VGND VGND VPWR VPWR hold278/X sky130_fd_sc_hd__dlygate4sd3_1
XFILLER_132_625 VPWR VGND VPWR VGND sky130_ef_sc_hd__decap_40_12
Xhold256 _6144_/Q VGND VGND VPWR VPWR hold256/X sky130_fd_sc_hd__dlygate4sd3_1
XFILLER_105_839 VGND VGND VPWR VPWR sky130_fd_sc_hd__fill_1
Xhold267 _4558_/X VGND VGND VPWR VPWR _6158_/D sky130_fd_sc_hd__dlygate4sd3_1
X_4456_ _5396_/Q _4451_/B _3366_/X _6261_/Q VGND VGND VPWR VPWR _4456_/X sky130_fd_sc_hd__a2bb2o_1
XPHY_EDGE_ROW_62_Right_62 VGND VGND VPWR VPWR sky130_fd_sc_hd__decap_3
Xhold245 _3624_/X VGND VGND VPWR VPWR _5653_/D sky130_fd_sc_hd__dlygate4sd3_1
XFILLER_132_669 VPWR VGND VPWR VGND sky130_ef_sc_hd__decap_40_12
XFILLER_131_157 VGND VGND VPWR VPWR sky130_fd_sc_hd__fill_1
XFILLER_120_809 VGND VGND VPWR VPWR sky130_fd_sc_hd__fill_2
XANTENNA__2886__S _3030_/S VGND VGND VPWR VPWR sky130_fd_sc_hd__diode_2
Xhold289 _5645_/Q VGND VGND VPWR VPWR hold289/X sky130_fd_sc_hd__dlygate4sd3_1
X_3407_ _4929_/A1 _4104_/A1 _3412_/S VGND VGND VPWR VPWR _5462_/D sky130_fd_sc_hd__mux2_1
X_4387_ _5038_/B _4975_/B VGND VGND VPWR VPWR _4396_/S sky130_fd_sc_hd__or2_4
XTAP_TAPCELL_ROW_113_1997 VGND VPWR sky130_fd_sc_hd__tapvpwrvgnd_1
XFILLER_100_511 VPWR VGND VPWR VGND sky130_ef_sc_hd__decap_40_12
X_6126_ _6399_/CLK _6126_/D VGND VGND VPWR VPWR _6126_/Q sky130_fd_sc_hd__dfxtp_1
X_3338_ _3338_/A _3338_/B VGND VGND VPWR VPWR _4997_/A sky130_fd_sc_hd__or2_1
XFILLER_58_425 VGND VGND VPWR VPWR sky130_fd_sc_hd__fill_2
XFILLER_100_533 VPWR VGND VPWR VGND sky130_ef_sc_hd__decap_40_12
XANTENNA_fanout185_X _3005_/A VGND VGND VPWR VPWR sky130_fd_sc_hd__diode_2
X_6057_ _6057_/CLK _6057_/D VGND VGND VPWR VPWR _6057_/Q sky130_fd_sc_hd__dfxtp_1
X_3269_ _4802_/A _3272_/C VGND VGND VPWR VPWR _3270_/B sky130_fd_sc_hd__and2_1
XANTENNA__4266__B2 _4205_/A VGND VGND VPWR VPWR sky130_fd_sc_hd__diode_2
XFILLER_73_439 VGND VGND VPWR VPWR sky130_fd_sc_hd__fill_1
X_5008_ _5918_/Q _5008_/B VGND VGND VPWR VPWR _5123_/B sky130_fd_sc_hd__nor2_1
XFILLER_39_694 VGND VGND VPWR VPWR sky130_fd_sc_hd__fill_2
XANTENNA_clkbuf_leaf_72_clk_A clkload2/A VGND VGND VPWR VPWR sky130_fd_sc_hd__diode_2
XTAP_TAPCELL_ROW_37_851 VGND VPWR sky130_fd_sc_hd__tapvpwrvgnd_1
XANTENNA__3510__S _3516_/S VGND VGND VPWR VPWR sky130_fd_sc_hd__diode_2
XPHY_EDGE_ROW_71_Right_71 VGND VGND VPWR VPWR sky130_fd_sc_hd__decap_3
XFILLER_42_837 VGND VGND VPWR VPWR sky130_fd_sc_hd__fill_4
XFILLER_26_377 VPWR VGND VPWR VGND sky130_ef_sc_hd__decap_40_12
XTAP_TAPCELL_ROW_37_862 VGND VPWR sky130_fd_sc_hd__tapvpwrvgnd_1
XFILLER_10_701 VPWR VGND VPWR VGND sky130_ef_sc_hd__decap_40_12
XFILLER_14_43 VGND VGND VPWR VPWR sky130_fd_sc_hd__fill_1
XANTENNA_clkbuf_leaf_87_clk_A clkload1/A VGND VGND VPWR VPWR sky130_fd_sc_hd__diode_2
XANTENNA__3529__A0 _4906_/A0 VGND VGND VPWR VPWR sky130_fd_sc_hd__diode_2
XFILLER_107_110 VGND VGND VPWR VPWR sky130_fd_sc_hd__fill_2
XANTENNA_clkbuf_leaf_10_clk_A clkbuf_leaf_9_clk/A VGND VGND VPWR VPWR sky130_fd_sc_hd__diode_2
XFILLER_6_749 VGND VGND VPWR VPWR sky130_fd_sc_hd__fill_4
XFILLER_135_463 VPWR VGND VPWR VGND sky130_ef_sc_hd__decap_40_12
XANTENNA__2752__A1 _5080_/A0 VGND VGND VPWR VPWR sky130_fd_sc_hd__diode_2
XPHY_EDGE_ROW_80_Right_80 VGND VGND VPWR VPWR sky130_fd_sc_hd__decap_3
XTAP_TAPCELL_ROW_75_1425 VGND VPWR sky130_fd_sc_hd__tapvpwrvgnd_1
XPHY_EDGE_ROW_15_Left_154 VGND VGND VPWR VPWR sky130_fd_sc_hd__decap_3
XFILLER_108_699 VGND VGND VPWR VPWR sky130_fd_sc_hd__fill_1
XANTENNA_fanout98_X _4982_/A1 VGND VGND VPWR VPWR sky130_fd_sc_hd__diode_2
XFILLER_123_669 VGND VGND VPWR VPWR sky130_fd_sc_hd__fill_2
XFILLER_111_809 VPWR VGND VPWR VGND sky130_ef_sc_hd__decap_40_12
Xhold790 _5353_/Q VGND VGND VPWR VPWR hold790/X sky130_fd_sc_hd__dlygate4sd3_1
XANTENNA__5151__C1 _2682_/A VGND VGND VPWR VPWR sky130_fd_sc_hd__diode_2
XANTENNA__4577__A _4663_/A VGND VGND VPWR VPWR sky130_fd_sc_hd__diode_2
XFILLER_77_701 VGND VGND VPWR VPWR sky130_fd_sc_hd__fill_1
XANTENNA_clkbuf_leaf_25_clk_A clkload3/A VGND VGND VPWR VPWR sky130_fd_sc_hd__diode_2
XANTENNA__3701__A0 _5210_/A1 VGND VGND VPWR VPWR sky130_fd_sc_hd__diode_2
XFILLER_39_51 VGND VGND VPWR VPWR sky130_fd_sc_hd__fill_4
XFILLER_77_756 VPWR VGND VPWR VGND sky130_ef_sc_hd__decap_40_12
XFILLER_49_447 VGND VGND VPWR VPWR sky130_fd_sc_hd__fill_1
Xhold2180 _5252_/Q VGND VGND VPWR VPWR _2658_/B sky130_fd_sc_hd__dlygate4sd3_1
Xhold2191 _3337_/A VGND VGND VPWR VPWR _3346_/B sky130_fd_sc_hd__dlygate4sd3_1
XFILLER_92_737 VPWR VGND VPWR VGND sky130_ef_sc_hd__decap_40_12
XPHY_EDGE_ROW_24_Left_163 VGND VGND VPWR VPWR sky130_fd_sc_hd__decap_3
Xhold1490 _5511_/Q VGND VGND VPWR VPWR _3462_/A0 sky130_fd_sc_hd__dlygate4sd3_1
XTAP_TAPCELL_ROW_86_1587 VGND VPWR sky130_fd_sc_hd__tapvpwrvgnd_1
XFILLER_17_377 VPWR VGND VPWR VGND sky130_ef_sc_hd__decap_40_12
XFILLER_33_837 VGND VGND VPWR VPWR sky130_fd_sc_hd__fill_2
XANTENNA__3768__A0 _4976_/A1 VGND VGND VPWR VPWR sky130_fd_sc_hd__diode_2
XANTENNA__4104__S1 _4251_/A VGND VGND VPWR VPWR sky130_fd_sc_hd__diode_2
XTAP_TAPCELL_ROW_15_523 VGND VPWR sky130_fd_sc_hd__tapvpwrvgnd_1
XFILLER_32_325 VGND VGND VPWR VPWR sky130_fd_sc_hd__fill_4
XFILLER_13_561 VPWR VGND VPWR VGND sky130_ef_sc_hd__decap_40_12
XFILLER_71_82 VGND VGND VPWR VPWR sky130_fd_sc_hd__fill_1
X_2640_ _2967_/S VGND VGND VPWR VPWR _3083_/S sky130_fd_sc_hd__clkinv_4
XTAP_TAPCELL_ROW_117_2053 VGND VPWR sky130_fd_sc_hd__tapvpwrvgnd_1
XPHY_EDGE_ROW_33_Left_172 VGND VGND VPWR VPWR sky130_fd_sc_hd__decap_3
XFILLER_126_452 VGND VGND VPWR VPWR sky130_fd_sc_hd__fill_1
XTAP_TAPCELL_ROW_130_2253 VGND VPWR sky130_fd_sc_hd__tapvpwrvgnd_1
XFILLER_126_474 VGND VGND VPWR VPWR sky130_fd_sc_hd__fill_2
XFILLER_114_625 VPWR VGND VPWR VGND sky130_ef_sc_hd__decap_40_12
XANTENNA__2743__A1 _5239_/A1 VGND VGND VPWR VPWR sky130_fd_sc_hd__diode_2
X_5290_ _6172_/CLK _5290_/D VGND VGND VPWR VPWR _5290_/Q sky130_fd_sc_hd__dfxtp_1
X_4310_ _4310_/A0 _4929_/A1 _4315_/S VGND VGND VPWR VPWR _4310_/X sky130_fd_sc_hd__mux2_1
XFILLER_114_669 VPWR VGND VPWR VGND sky130_ef_sc_hd__decap_40_12
XFILLER_113_135 VGND VGND VPWR VPWR sky130_fd_sc_hd__fill_1
XFILLER_102_809 VGND VGND VPWR VPWR sky130_fd_sc_hd__fill_2
X_4241_ _4241_/A _4241_/B VGND VGND VPWR VPWR _4241_/Y sky130_fd_sc_hd__nor2_1
XFILLER_113_157 VGND VGND VPWR VPWR sky130_fd_sc_hd__fill_1
XFILLER_101_308 VGND VGND VPWR VPWR sky130_fd_sc_hd__fill_1
XFILLER_67_200 VGND VGND VPWR VPWR sky130_fd_sc_hd__fill_2
XANTENNA__4496__A1 _5210_/A1 VGND VGND VPWR VPWR sky130_fd_sc_hd__diode_2
X_4172_ _4251_/A _4172_/B VGND VGND VPWR VPWR _4172_/X sky130_fd_sc_hd__or2_1
X_3123_ hold329/X _5234_/A0 _3126_/S VGND VGND VPWR VPWR _3123_/X sky130_fd_sc_hd__mux2_1
XFILLER_67_244 VGND VGND VPWR VPWR sky130_fd_sc_hd__fill_8
XPHY_EDGE_ROW_42_Left_181 VGND VGND VPWR VPWR sky130_fd_sc_hd__decap_3
X_3054_ _3047_/X _3053_/X _3083_/S VGND VGND VPWR VPWR _3054_/X sky130_fd_sc_hd__mux2_1
XFILLER_95_597 VPWR VGND VPWR VGND sky130_ef_sc_hd__decap_40_12
XFILLER_27_108 VGND VGND VPWR VPWR sky130_fd_sc_hd__fill_2
XFILLER_91_781 VGND VGND VPWR VPWR sky130_fd_sc_hd__fill_2
XFILLER_24_837 VGND VGND VPWR VPWR sky130_fd_sc_hd__fill_4
XTAP_TAPCELL_ROW_34_810 VGND VPWR sky130_fd_sc_hd__tapvpwrvgnd_1
XFILLER_36_686 VGND VGND VPWR VPWR sky130_fd_sc_hd__fill_1
XFILLER_90_291 VGND VGND VPWR VPWR sky130_fd_sc_hd__fill_2
XANTENNA__5819__Q _5819_/Q VGND VGND VPWR VPWR sky130_fd_sc_hd__diode_2
XANTENNA__4420__A1 _4887_/A1 VGND VGND VPWR VPWR sky130_fd_sc_hd__diode_2
X_3956_ _3958_/A VGND VGND VPWR VPWR _3956_/Y sky130_fd_sc_hd__inv_2
X_2907_ _3031_/A1 _2906_/X _3085_/A VGND VGND VPWR VPWR _2907_/X sky130_fd_sc_hd__o21a_1
X_3887_ hold942/X _3926_/A1 _3889_/S VGND VGND VPWR VPWR _3887_/X sky130_fd_sc_hd__mux2_1
X_5626_ _6095_/CLK _5626_/D VGND VGND VPWR VPWR _5626_/Q sky130_fd_sc_hd__dfxtp_1
XPHY_EDGE_ROW_51_Left_190 VGND VGND VPWR VPWR sky130_fd_sc_hd__decap_3
XFILLER_31_391 VGND VGND VPWR VPWR sky130_fd_sc_hd__fill_1
X_2838_ _2967_/S _2837_/X _2831_/Y _5270_/Q VGND VGND VPWR VPWR _2838_/Y sky130_fd_sc_hd__o211ai_1
XFILLER_117_430 VGND VGND VPWR VPWR sky130_fd_sc_hd__fill_2
X_2769_ _6126_/Q _5549_/Q _3030_/S VGND VGND VPWR VPWR _2770_/B sky130_fd_sc_hd__mux2_1
X_5557_ _6398_/CLK _5557_/D VGND VGND VPWR VPWR _5557_/Q sky130_fd_sc_hd__dfxtp_1
X_5488_ _6238_/CLK _5488_/D VGND VGND VPWR VPWR _5488_/Q sky130_fd_sc_hd__dfxtp_1
XTAP_TAPCELL_ROW_57_1155 VGND VPWR sky130_fd_sc_hd__tapvpwrvgnd_1
XANTENNA__3931__A0 _5040_/A1 VGND VGND VPWR VPWR sky130_fd_sc_hd__diode_2
XANTENNA_fanout100_X _4981_/A1 VGND VGND VPWR VPWR sky130_fd_sc_hd__diode_2
X_4508_ hold747/X _5212_/A1 _4512_/S VGND VGND VPWR VPWR _4508_/X sky130_fd_sc_hd__mux2_1
XFILLER_105_669 VGND VGND VPWR VPWR sky130_fd_sc_hd__fill_2
X_4439_ _5265_/Q _4451_/B VGND VGND VPWR VPWR _4439_/Y sky130_fd_sc_hd__nor2_1
XFILLER_132_477 VPWR VGND VPWR VGND sky130_ef_sc_hd__decap_40_12
XANTENNA__3505__S _3516_/S VGND VGND VPWR VPWR sky130_fd_sc_hd__diode_2
XTAP_TAPCELL_ROW_70_1355 VGND VPWR sky130_fd_sc_hd__tapvpwrvgnd_1
XTAP_TAPCELL_ROW_70_1344 VGND VPWR sky130_fd_sc_hd__tapvpwrvgnd_1
XFILLER_59_745 VGND VGND VPWR VPWR sky130_fd_sc_hd__fill_1
XFILLER_58_200 VGND VGND VPWR VPWR sky130_fd_sc_hd__fill_1
X_6109_ _6123_/CLK _6109_/D VGND VGND VPWR VPWR _6109_/Q sky130_fd_sc_hd__dfxtp_1
XFILLER_19_609 VGND VGND VPWR VPWR sky130_fd_sc_hd__fill_4
XFILLER_132_33 VGND VGND VPWR VPWR sky130_fd_sc_hd__fill_2
XANTENNA_fanout58_A _3959_/A VGND VGND VPWR VPWR sky130_fd_sc_hd__diode_2
XFILLER_92_59 VGND VGND VPWR VPWR sky130_fd_sc_hd__fill_1
XFILLER_92_37 VGND VGND VPWR VPWR sky130_fd_sc_hd__fill_2
XFILLER_15_837 VGND VGND VPWR VPWR sky130_fd_sc_hd__fill_2
XFILLER_25_53 VGND VGND VPWR VPWR sky130_fd_sc_hd__fill_1
XFILLER_41_111 VGND VGND VPWR VPWR sky130_fd_sc_hd__fill_1
XANTENNA__2973__A1 _3076_/A1 VGND VGND VPWR VPWR sky130_fd_sc_hd__diode_2
XFILLER_10_531 VGND VGND VPWR VPWR sky130_fd_sc_hd__fill_1
XFILLER_6_513 VPWR VGND VPWR VGND sky130_ef_sc_hd__decap_40_12
XFILLER_41_63 VGND VGND VPWR VPWR sky130_fd_sc_hd__fill_1
XFILLER_6_557 VPWR VGND VPWR VGND sky130_ef_sc_hd__decap_40_12
XFILLER_123_411 VGND VGND VPWR VPWR sky130_fd_sc_hd__fill_1
XANTENNA__2725__A1 _3030_/S VGND VGND VPWR VPWR sky130_fd_sc_hd__diode_2
XFILLER_111_617 VPWR VGND VPWR VGND sky130_ef_sc_hd__decap_40_12
XFILLER_96_306 VGND VGND VPWR VPWR sky130_fd_sc_hd__fill_2
XANTENNA__4478__A1 _5212_/A1 VGND VGND VPWR VPWR sky130_fd_sc_hd__diode_2
XFILLER_123_499 VGND VGND VPWR VPWR sky130_fd_sc_hd__fill_4
XFILLER_89_391 VGND VGND VPWR VPWR sky130_fd_sc_hd__fill_1
XFILLER_1_262 VGND VGND VPWR VPWR sky130_fd_sc_hd__fill_2
XTAP_TAPCELL_ROW_88_1616 VGND VPWR sky130_fd_sc_hd__tapvpwrvgnd_1
XFILLER_37_406 VGND VGND VPWR VPWR sky130_fd_sc_hd__fill_1
XTAP_TAPCELL_ROW_88_1627 VGND VPWR sky130_fd_sc_hd__tapvpwrvgnd_1
XFILLER_65_737 VGND VGND VPWR VPWR sky130_fd_sc_hd__fill_2
XFILLER_49_277 VGND VGND VPWR VPWR sky130_fd_sc_hd__fill_2
XFILLER_92_545 VPWR VGND VPWR VGND sky130_ef_sc_hd__decap_40_12
XFILLER_66_82 VGND VGND VPWR VPWR sky130_fd_sc_hd__fill_2
XANTENNA__4246__S _4260_/S VGND VGND VPWR VPWR sky130_fd_sc_hd__diode_2
XFILLER_92_589 VPWR VGND VPWR VGND sky130_ef_sc_hd__decap_40_12
XFILLER_80_729 VGND VGND VPWR VPWR sky130_fd_sc_hd__fill_2
XFILLER_73_781 VGND VGND VPWR VPWR sky130_fd_sc_hd__fill_2
XFILLER_18_697 VGND VGND VPWR VPWR sky130_fd_sc_hd__fill_2
XFILLER_32_122 VGND VGND VPWR VPWR sky130_fd_sc_hd__fill_1
X_4790_ _4790_/A0 hold775/X _4790_/S VGND VGND VPWR VPWR _4790_/X sky130_fd_sc_hd__mux2_1
X_3810_ input24/X _5237_/A0 _3810_/S VGND VGND VPWR VPWR _5816_/D sky130_fd_sc_hd__mux2_1
XFILLER_33_689 VGND VGND VPWR VPWR sky130_fd_sc_hd__fill_1
X_3741_ hold677/X _5233_/A0 _3745_/S VGND VGND VPWR VPWR _3741_/X sky130_fd_sc_hd__mux2_1
XFILLER_60_475 VGND VGND VPWR VPWR sky130_fd_sc_hd__fill_1
XANTENNA__5077__S _5081_/S VGND VGND VPWR VPWR sky130_fd_sc_hd__diode_2
XANTENNA__2964__A1 _3031_/A1 VGND VGND VPWR VPWR sky130_fd_sc_hd__diode_2
XTAP_TAPCELL_ROW_99_1778 VGND VPWR sky130_fd_sc_hd__tapvpwrvgnd_1
X_6460_ _6460_/A VGND VGND VPWR VPWR _6460_/X sky130_fd_sc_hd__clkbuf_1
X_3672_ _4958_/A0 _3672_/A1 _3678_/S VGND VGND VPWR VPWR _3672_/X sky130_fd_sc_hd__mux2_1
XFILLER_118_249 VGND VGND VPWR VPWR sky130_fd_sc_hd__fill_1
X_5411_ _6254_/CLK _5411_/D VGND VGND VPWR VPWR _5411_/Q sky130_fd_sc_hd__dfxtp_1
XTAP_TAPCELL_ROW_99_1789 VGND VPWR sky130_fd_sc_hd__tapvpwrvgnd_1
X_6391_ _6394_/CLK _6391_/D VGND VGND VPWR VPWR _6391_/Q sky130_fd_sc_hd__dfxtp_1
X_2623_ _3975_/C VGND VGND VPWR VPWR _3973_/B sky130_fd_sc_hd__inv_2
XFILLER_127_783 VGND VGND VPWR VPWR sky130_fd_sc_hd__fill_1
X_5342_ _6313_/CLK _5342_/D VGND VGND VPWR VPWR _5342_/Q sky130_fd_sc_hd__dfxtp_1
XFILLER_99_122 VGND VGND VPWR VPWR sky130_fd_sc_hd__fill_2
XANTENNA__5115__C1 _3237_/A VGND VGND VPWR VPWR sky130_fd_sc_hd__diode_2
X_5273_ _6137_/CLK _5273_/D VGND VGND VPWR VPWR _5273_/Q sky130_fd_sc_hd__dfxtp_1
XTAP_TAPCELL_ROW_110_1956 VGND VPWR sky130_fd_sc_hd__tapvpwrvgnd_1
XTAP_TAPCELL_ROW_110_1945 VGND VPWR sky130_fd_sc_hd__tapvpwrvgnd_1
X_4224_ _4264_/A1 _4223_/X _4222_/X _4271_/S1 VGND VGND VPWR VPWR _4224_/X sky130_fd_sc_hd__o211a_1
XTAP_TAPCELL_ROW_52_1085 VGND VPWR sky130_fd_sc_hd__tapvpwrvgnd_1
XTAP_TAPCELL_ROW_52_1074 VGND VPWR sky130_fd_sc_hd__tapvpwrvgnd_1
X_4155_ _6022_/Q _6013_/Q _4270_/S VGND VGND VPWR VPWR _4156_/B sky130_fd_sc_hd__mux2_1
X_3106_ hold129/X _5075_/A0 _3112_/S VGND VGND VPWR VPWR _3106_/X sky130_fd_sc_hd__mux2_1
XFILLER_28_417 VGND VGND VPWR VPWR sky130_fd_sc_hd__fill_2
XFILLER_83_556 VGND VGND VPWR VPWR sky130_fd_sc_hd__fill_2
X_4086_ _6274_/Q _6265_/Q _4258_/S VGND VGND VPWR VPWR _4086_/X sky130_fd_sc_hd__mux2_1
X_3037_ _6180_/Q _6204_/Q _6192_/Q _5486_/Q _3062_/S _3034_/A VGND VGND VPWR VPWR
+ _3037_/X sky130_fd_sc_hd__mux4_1
XFILLER_71_729 VGND VGND VPWR VPWR sky130_fd_sc_hd__fill_1
XFILLER_64_781 VPWR VGND VPWR VGND sky130_ef_sc_hd__decap_40_12
XFILLER_23_111 VGND VGND VPWR VPWR sky130_fd_sc_hd__fill_1
XANTENNA__4680__A _4789_/A VGND VGND VPWR VPWR sky130_fd_sc_hd__diode_2
XFILLER_24_656 VGND VGND VPWR VPWR sky130_fd_sc_hd__fill_2
X_4988_ hold189/X _5042_/A1 _4993_/S VGND VGND VPWR VPWR _4988_/X sky130_fd_sc_hd__mux2_1
XFILLER_137_503 VGND VGND VPWR VPWR sky130_fd_sc_hd__fill_1
XANTENNA__3296__A _4881_/A VGND VGND VPWR VPWR sky130_fd_sc_hd__diode_2
X_3939_ _5127_/A _6389_/Q VGND VGND VPWR VPWR _3940_/B sky130_fd_sc_hd__or2_1
XFILLER_125_709 VPWR VGND VPWR VGND sky130_ef_sc_hd__decap_40_12
X_5609_ _6098_/CLK _5609_/D VGND VGND VPWR VPWR _5609_/Q sky130_fd_sc_hd__dfxtp_1
XANTENNA__3055__S1 _2962_/A VGND VGND VPWR VPWR sky130_fd_sc_hd__diode_2
XFILLER_3_505 VPWR VGND VPWR VGND sky130_ef_sc_hd__decap_40_12
XFILLER_133_753 VPWR VGND VPWR VGND sky130_ef_sc_hd__decap_40_12
XFILLER_133_797 VPWR VGND VPWR VGND sky130_ef_sc_hd__decap_40_12
XFILLER_87_37 VGND VGND VPWR VPWR sky130_fd_sc_hd__fill_1
XANTENNA__3380__B2 _4904_/A0 VGND VGND VPWR VPWR sky130_fd_sc_hd__diode_2
XANTENNA__5106__C1 _5201_/B VGND VGND VPWR VPWR sky130_fd_sc_hd__diode_2
XANTENNA__4855__A _5069_/B VGND VGND VPWR VPWR sky130_fd_sc_hd__diode_2
XANTENNA__4880__A1 _4906_/A0 VGND VGND VPWR VPWR sky130_fd_sc_hd__diode_2
XFILLER_59_586 VGND VGND VPWR VPWR sky130_fd_sc_hd__fill_1
XTAP_TAPCELL_ROW_6_387 VGND VPWR sky130_fd_sc_hd__tapvpwrvgnd_1
XFILLER_19_417 VPWR VGND VPWR VGND sky130_ef_sc_hd__decap_40_12
XANTENNA__4066__S _4262_/S VGND VGND VPWR VPWR sky130_fd_sc_hd__diode_2
XTAP_TAPCELL_ROW_83_1546 VGND VPWR sky130_fd_sc_hd__tapvpwrvgnd_1
XFILLER_36_85 VGND VGND VPWR VPWR sky130_fd_sc_hd__fill_2
XANTENNA__3199__A1 _4899_/A0 VGND VGND VPWR VPWR sky130_fd_sc_hd__diode_2
XANTENNA__4396__A0 _4984_/A1 VGND VGND VPWR VPWR sky130_fd_sc_hd__diode_2
XTAP_TAPCELL_ROW_25_673 VGND VPWR sky130_fd_sc_hd__tapvpwrvgnd_1
XFILLER_30_615 VGND VGND VPWR VPWR sky130_fd_sc_hd__fill_1
XFILLER_128_503 VPWR VGND VPWR VGND sky130_ef_sc_hd__decap_40_12
Xinput27 s_axil_wdata[9] VGND VGND VPWR VPWR _4910_/A sky130_fd_sc_hd__buf_1
Xinput16 s_axil_wdata[13] VGND VGND VPWR VPWR _4918_/A sky130_fd_sc_hd__buf_1
XFILLER_7_833 VGND VGND VPWR VPWR sky130_fd_sc_hd__fill_4
XFILLER_128_569 VPWR VGND VPWR VGND sky130_ef_sc_hd__decap_40_12
XTAP_TAPCELL_ROW_114_2012 VGND VPWR sky130_fd_sc_hd__tapvpwrvgnd_1
XFILLER_109_783 VGND VGND VPWR VPWR sky130_fd_sc_hd__fill_1
XFILLER_6_365 VPWR VGND VPWR VGND sky130_ef_sc_hd__decap_40_12
XFILLER_124_753 VGND VGND VPWR VPWR sky130_fd_sc_hd__fill_2
XFILLER_97_615 VGND VGND VPWR VPWR sky130_fd_sc_hd__fill_1
XFILLER_69_306 VGND VGND VPWR VPWR sky130_fd_sc_hd__fill_1
XFILLER_42_7 VGND VGND VPWR VPWR sky130_fd_sc_hd__fill_2
XFILLER_111_425 VGND VGND VPWR VPWR sky130_fd_sc_hd__fill_4
XANTENNA__2984__S _2984_/S VGND VGND VPWR VPWR sky130_fd_sc_hd__diode_2
XANTENNA__3123__A1 _5234_/A0 VGND VGND VPWR VPWR sky130_fd_sc_hd__diode_2
XFILLER_111_458 VGND VGND VPWR VPWR sky130_fd_sc_hd__fill_2
XFILLER_111_447 VGND VGND VPWR VPWR sky130_fd_sc_hd__fill_1
XANTENNA__4871__A1 _5819_/Q VGND VGND VPWR VPWR sky130_fd_sc_hd__diode_2
XFILLER_93_821 VPWR VGND VPWR VGND sky130_ef_sc_hd__decap_40_12
XFILLER_37_225 VGND VGND VPWR VPWR sky130_fd_sc_hd__fill_4
XTAP_TAPCELL_ROW_125_2174 VGND VPWR sky130_fd_sc_hd__tapvpwrvgnd_1
XANTENNA__4623__A1 _4792_/A1 VGND VGND VPWR VPWR sky130_fd_sc_hd__diode_2
XFILLER_53_729 VGND VGND VPWR VPWR sky130_fd_sc_hd__fill_4
X_5960_ clkload7/A _5960_/D VGND VGND VPWR VPWR _5960_/Q sky130_fd_sc_hd__dfxtp_1
X_4911_ _5172_/A1 _4907_/Y _4910_/X _5176_/A VGND VGND VPWR VPWR _6256_/D sky130_fd_sc_hd__o211a_1
XFILLER_52_239 VGND VGND VPWR VPWR sky130_fd_sc_hd__fill_1
X_5891_ _6417_/CLK hold28/X VGND VGND VPWR VPWR hold27/A sky130_fd_sc_hd__dfxtp_1
XTAP_TAPCELL_ROW_44_960 VGND VPWR sky130_fd_sc_hd__tapvpwrvgnd_1
X_4842_ _5069_/B _4842_/B VGND VGND VPWR VPWR _4854_/S sky130_fd_sc_hd__or2_4
XFILLER_21_615 VGND VGND VPWR VPWR sky130_fd_sc_hd__fill_1
XANTENNA__2732__B _3085_/A VGND VGND VPWR VPWR sky130_fd_sc_hd__diode_2
X_4773_ _5619_/Q _6297_/Q _4773_/S VGND VGND VPWR VPWR _4774_/B sky130_fd_sc_hd__mux2_1
XFILLER_119_525 VPWR VGND VPWR VGND sky130_ef_sc_hd__decap_40_12
XANTENNA__2937__B2 _3096_/A1 VGND VGND VPWR VPWR sky130_fd_sc_hd__diode_2
X_3724_ _4137_/A1 _5043_/A1 _3728_/S VGND VGND VPWR VPWR _3724_/X sky130_fd_sc_hd__mux2_1
XFILLER_107_709 VPWR VGND VPWR VGND sky130_ef_sc_hd__decap_40_12
X_3655_ hold197/X _3926_/A1 _3657_/S VGND VGND VPWR VPWR _3655_/X sky130_fd_sc_hd__mux2_1
XANTENNA__4234__S0 _4237_/S VGND VGND VPWR VPWR sky130_fd_sc_hd__diode_2
XFILLER_115_753 VPWR VGND VPWR VGND sky130_ef_sc_hd__decap_40_12
X_6374_ _6382_/CLK _6374_/D VGND VGND VPWR VPWR _6374_/Q sky130_fd_sc_hd__dfxtp_1
XANTENNA_fanout108_A _5052_/A1 VGND VGND VPWR VPWR sky130_fd_sc_hd__diode_2
X_3586_ _4503_/A _3880_/B VGND VGND VPWR VPWR _3595_/S sky130_fd_sc_hd__nor2_4
XFILLER_130_701 VPWR VGND VPWR VGND sky130_ef_sc_hd__decap_40_12
XANTENNA__2796__S0 _2963_/S VGND VGND VPWR VPWR sky130_fd_sc_hd__diode_2
XANTENNA__5832__Q _5832_/Q VGND VGND VPWR VPWR sky130_fd_sc_hd__diode_2
XTAP_TAPCELL_ROW_54_1114 VGND VPWR sky130_fd_sc_hd__tapvpwrvgnd_1
XTAP_TAPCELL_ROW_54_1103 VGND VPWR sky130_fd_sc_hd__tapvpwrvgnd_1
X_5325_ _5988_/CLK _5325_/D VGND VGND VPWR VPWR _5325_/Q sky130_fd_sc_hd__dfxtp_1
XFILLER_115_797 VPWR VGND VPWR VGND sky130_ef_sc_hd__decap_40_12
X_5256_ _6409_/CLK _5256_/D VGND VGND VPWR VPWR _5256_/Q sky130_fd_sc_hd__dfxtp_1
XFILLER_102_447 VGND VGND VPWR VPWR sky130_fd_sc_hd__fill_4
X_4207_ _4263_/A _4207_/B VGND VGND VPWR VPWR _4207_/X sky130_fd_sc_hd__or2_1
XFILLER_96_681 VPWR VGND VPWR VGND sky130_ef_sc_hd__decap_40_12
XFILLER_84_810 VGND VGND VPWR VPWR sky130_fd_sc_hd__fill_2
X_5187_ _2622_/Y _3951_/Y _5175_/S _2621_/Y VGND VGND VPWR VPWR _5187_/X sky130_fd_sc_hd__a31o_1
XFILLER_29_726 VGND VGND VPWR VPWR sky130_fd_sc_hd__fill_2
XANTENNA__2873__B1 _3075_/C1 VGND VGND VPWR VPWR sky130_fd_sc_hd__diode_2
XTAP_TAPCELL_ROW_3_346 VGND VPWR sky130_fd_sc_hd__tapvpwrvgnd_1
X_4138_ _4252_/A1 _4137_/X _4252_/B1 VGND VGND VPWR VPWR _4138_/X sky130_fd_sc_hd__o21a_1
XFILLER_28_225 VGND VGND VPWR VPWR sky130_fd_sc_hd__fill_1
XFILLER_113_57 VGND VGND VPWR VPWR sky130_fd_sc_hd__fill_2
X_4069_ hold43/A _6010_/Q _4213_/S VGND VGND VPWR VPWR _4070_/B sky130_fd_sc_hd__mux2_1
XFILLER_16_409 VGND VGND VPWR VPWR sky130_fd_sc_hd__fill_8
XANTENNA__4075__C1 _5343_/Q VGND VGND VPWR VPWR sky130_fd_sc_hd__diode_2
XFILLER_43_239 VGND VGND VPWR VPWR sky130_fd_sc_hd__fill_4
XFILLER_43_217 VGND VGND VPWR VPWR sky130_fd_sc_hd__fill_2
XANTENNA__3822__C1 _5176_/A VGND VGND VPWR VPWR sky130_fd_sc_hd__diode_2
XTAP_TAPCELL_ROW_65_1276 VGND VPWR sky130_fd_sc_hd__tapvpwrvgnd_1
XFILLER_12_637 VGND VGND VPWR VPWR sky130_fd_sc_hd__fill_4
XFILLER_24_475 VGND VGND VPWR VPWR sky130_fd_sc_hd__fill_1
XTAP_TAPCELL_ROW_22_632 VGND VPWR sky130_fd_sc_hd__tapvpwrvgnd_1
XFILLER_11_158 VGND VGND VPWR VPWR sky130_fd_sc_hd__fill_2
XFILLER_11_169 VGND VGND VPWR VPWR sky130_fd_sc_hd__fill_4
XPHY_EDGE_ROW_129_Right_129 VGND VGND VPWR VPWR sky130_fd_sc_hd__decap_3
XFILLER_20_681 VPWR VGND VPWR VGND sky130_ef_sc_hd__decap_40_12
XFILLER_125_517 VPWR VGND VPWR VGND sky130_ef_sc_hd__decap_40_12
XFILLER_118_3 VPWR VGND VPWR VGND sky130_ef_sc_hd__decap_40_12
XFILLER_4_825 VPWR VGND VPWR VGND sky130_ef_sc_hd__decap_40_12
XFILLER_133_561 VPWR VGND VPWR VGND sky130_ef_sc_hd__decap_40_12
XFILLER_106_753 VGND VGND VPWR VPWR sky130_fd_sc_hd__fill_2
XFILLER_0_3 VPWR VGND VPWR VGND sky130_ef_sc_hd__decap_40_12
XANTENNA_fanout80_X _5213_/A1 VGND VGND VPWR VPWR sky130_fd_sc_hd__diode_2
XANTENNA__3105__A1 _4899_/A0 VGND VGND VPWR VPWR sky130_fd_sc_hd__diode_2
XFILLER_66_309 VGND VGND VPWR VPWR sky130_fd_sc_hd__fill_8
Xfanout182 hold2220/X VGND VGND VPWR VPWR _3029_/A sky130_fd_sc_hd__clkbuf_4
XFILLER_75_821 VPWR VGND VPWR VGND sky130_ef_sc_hd__decap_40_12
XFILLER_59_383 VGND VGND VPWR VPWR sky130_fd_sc_hd__fill_8
Xfanout160 _4178_/A VGND VGND VPWR VPWR _4251_/A sky130_fd_sc_hd__buf_4
Xfanout171 _4221_/S VGND VGND VPWR VPWR _4213_/S sky130_fd_sc_hd__clkbuf_8
Xfanout193 _3016_/S VGND VGND VPWR VPWR _3072_/S sky130_fd_sc_hd__clkbuf_8
XFILLER_19_225 VGND VGND VPWR VPWR sky130_fd_sc_hd__fill_1
XFILLER_90_813 VPWR VGND VPWR VGND sky130_ef_sc_hd__decap_40_12
XFILLER_74_397 VPWR VGND VPWR VGND sky130_ef_sc_hd__decap_40_12
XFILLER_28_781 VPWR VGND VPWR VGND sky130_ef_sc_hd__decap_40_12
XANTENNA__4369__A0 _5052_/A1 VGND VGND VPWR VPWR sky130_fd_sc_hd__diode_2
XTAP_TAPCELL_ROW_120_2093 VGND VPWR sky130_fd_sc_hd__tapvpwrvgnd_1
XFILLER_15_497 VGND VGND VPWR VPWR sky130_fd_sc_hd__fill_4
XFILLER_30_445 VPWR VGND VPWR VGND sky130_ef_sc_hd__decap_40_12
XPHY_EDGE_ROW_7_Left_146 VGND VGND VPWR VPWR sky130_fd_sc_hd__decap_3
XANTENNA__3592__A1 _4961_/A0 VGND VGND VPWR VPWR sky130_fd_sc_hd__diode_2
XFILLER_7_641 VPWR VGND VPWR VGND sky130_ef_sc_hd__decap_40_12
XTAP_TAPCELL_ROW_96_1737 VGND VPWR sky130_fd_sc_hd__tapvpwrvgnd_1
XFILLER_7_685 VPWR VGND VPWR VGND sky130_ef_sc_hd__decap_40_12
Xhold608 _5666_/Q VGND VGND VPWR VPWR hold608/X sky130_fd_sc_hd__dlygate4sd3_1
X_3440_ hold103/X _4883_/A1 _3450_/S VGND VGND VPWR VPWR _3440_/X sky130_fd_sc_hd__mux2_1
Xhold619 _3422_/X VGND VGND VPWR VPWR _5475_/D sky130_fd_sc_hd__dlygate4sd3_1
XFILLER_6_195 VGND VGND VPWR VPWR sky130_fd_sc_hd__fill_1
XFILLER_112_701 VPWR VGND VPWR VGND sky130_ef_sc_hd__decap_40_12
XANTENNA__2778__S0 _3091_/S VGND VGND VPWR VPWR sky130_fd_sc_hd__diode_2
X_3371_ hold393/X _4457_/S _3370_/X VGND VGND VPWR VPWR _3371_/X sky130_fd_sc_hd__o21a_1
XFILLER_88_80 VGND VGND VPWR VPWR sky130_fd_sc_hd__fill_4
X_6090_ _6095_/CLK _6090_/D VGND VGND VPWR VPWR _6090_/Q sky130_fd_sc_hd__dfxtp_1
Xhold2009 _4647_/X VGND VGND VPWR VPWR _6164_/D sky130_fd_sc_hd__dlygate4sd3_1
X_5110_ _5110_/A _5110_/B _4010_/B VGND VGND VPWR VPWR _5110_/X sky130_fd_sc_hd__or3b_1
XFILLER_33_3 VGND VGND VPWR VPWR sky130_fd_sc_hd__fill_4
XTAP_TAPCELL_ROW_127_2203 VGND VPWR sky130_fd_sc_hd__tapvpwrvgnd_1
X_5041_ _5041_/A0 _5053_/A1 _5047_/S VGND VGND VPWR VPWR _5041_/X sky130_fd_sc_hd__mux2_1
Xhold1308 _3495_/X VGND VGND VPWR VPWR _5540_/D sky130_fd_sc_hd__dlygate4sd3_1
Xhold1319 _4936_/X VGND VGND VPWR VPWR _6272_/D sky130_fd_sc_hd__dlygate4sd3_1
XANTENNA__2727__B _3030_/S VGND VGND VPWR VPWR sky130_fd_sc_hd__diode_2
XFILLER_93_673 VPWR VGND VPWR VGND sky130_ef_sc_hd__decap_40_12
XANTENNA__2950__S0 _3062_/S VGND VGND VPWR VPWR sky130_fd_sc_hd__diode_2
XTAP_TAPCELL_ROW_0_305 VGND VPWR sky130_fd_sc_hd__tapvpwrvgnd_1
XANTENNA__4201__A1_N _4252_/B1 VGND VGND VPWR VPWR sky130_fd_sc_hd__diode_2
XFILLER_53_526 VGND VGND VPWR VPWR sky130_fd_sc_hd__fill_1
XFILLER_19_781 VGND VGND VPWR VPWR sky130_fd_sc_hd__fill_2
XANTENNA__3839__A _5085_/A VGND VGND VPWR VPWR sky130_fd_sc_hd__diode_2
X_5943_ _6314_/CLK _5943_/D VGND VGND VPWR VPWR _5943_/Q sky130_fd_sc_hd__dfxtp_1
XTAP_TAPCELL_ROW_105_1877 VGND VPWR sky130_fd_sc_hd__tapvpwrvgnd_1
X_5874_ _6094_/CLK _5874_/D VGND VGND VPWR VPWR _5874_/Q sky130_fd_sc_hd__dfxtp_1
X_4825_ _5813_/Q _4825_/A1 _4828_/S VGND VGND VPWR VPWR _4825_/X sky130_fd_sc_hd__mux2_1
XANTENNA__4216__A1_N _2635_/Y VGND VGND VPWR VPWR sky130_fd_sc_hd__diode_2
XFILLER_21_445 VGND VGND VPWR VPWR sky130_fd_sc_hd__fill_2
XTAP_TAPCELL_ROW_138_2365 VGND VPWR sky130_fd_sc_hd__tapvpwrvgnd_1
XANTENNA__3032__B1 _2995_/A VGND VGND VPWR VPWR sky130_fd_sc_hd__diode_2
XTAP_TAPCELL_ROW_138_2387 VGND VPWR sky130_fd_sc_hd__tapvpwrvgnd_1
XTAP_TAPCELL_ROW_138_2376 VGND VPWR sky130_fd_sc_hd__tapvpwrvgnd_1
XANTENNA__3583__A1 _5215_/A1 VGND VGND VPWR VPWR sky130_fd_sc_hd__diode_2
XTAP_TAPCELL_ROW_60_1195 VGND VPWR sky130_fd_sc_hd__tapvpwrvgnd_1
X_4756_ _4755_/Y _4749_/Y _4813_/S VGND VGND VPWR VPWR _4756_/X sky130_fd_sc_hd__mux2_1
XFILLER_135_837 VGND VGND VPWR VPWR sky130_fd_sc_hd__fill_2
XANTENNA__2889__S _3091_/S VGND VGND VPWR VPWR sky130_fd_sc_hd__diode_2
X_3707_ _4964_/A0 _4787_/A3 _3707_/S VGND VGND VPWR VPWR _3707_/X sky130_fd_sc_hd__mux2_1
X_4687_ _5865_/Q _5856_/Q _4778_/S VGND VGND VPWR VPWR _4687_/X sky130_fd_sc_hd__mux2_1
X_6426_ _6428_/CLK _6426_/D VGND VGND VPWR VPWR _6426_/Q sky130_fd_sc_hd__dfxtp_1
X_3638_ _4503_/A _3648_/B VGND VGND VPWR VPWR _3647_/S sky130_fd_sc_hd__nor2_4
XFILLER_122_509 VPWR VGND VPWR VGND sky130_ef_sc_hd__decap_40_12
XFILLER_115_561 VPWR VGND VPWR VGND sky130_ef_sc_hd__decap_40_12
X_3569_ hold31/X _4517_/A1 _3574_/S VGND VGND VPWR VPWR hold32/A sky130_fd_sc_hd__mux2_1
X_6357_ _6380_/CLK _6357_/D VGND VGND VPWR VPWR _6357_/Q sky130_fd_sc_hd__dfxtp_1
XTAP_TAPCELL_ROW_8_427 VGND VPWR sky130_fd_sc_hd__tapvpwrvgnd_1
XTAP_TAPCELL_ROW_8_416 VGND VPWR sky130_fd_sc_hd__tapvpwrvgnd_1
X_5308_ _6428_/CLK _5308_/D VGND VGND VPWR VPWR _5308_/Q sky130_fd_sc_hd__dfxtp_1
XFILLER_0_305 VGND VGND VPWR VPWR sky130_fd_sc_hd__fill_2
XFILLER_1_839 VGND VGND VPWR VPWR sky130_fd_sc_hd__fill_1
XFILLER_130_531 VGND VGND VPWR VPWR sky130_fd_sc_hd__fill_1
X_6288_ _6315_/CLK _6288_/D VGND VGND VPWR VPWR _6288_/Q sky130_fd_sc_hd__dfxtp_1
XFILLER_0_349 VGND VGND VPWR VPWR sky130_fd_sc_hd__fill_8
XANTENNA__2918__A _3050_/A VGND VGND VPWR VPWR sky130_fd_sc_hd__diode_2
X_5239_ hold153/X _5239_/A1 _5241_/S VGND VGND VPWR VPWR _5239_/X sky130_fd_sc_hd__mux2_1
XANTENNA__3513__S _3516_/S VGND VGND VPWR VPWR sky130_fd_sc_hd__diode_2
XFILLER_76_629 VGND VGND VPWR VPWR sky130_fd_sc_hd__fill_1
XFILLER_75_106 VGND VGND VPWR VPWR sky130_fd_sc_hd__fill_4
Xhold1820 _5856_/Q VGND VGND VPWR VPWR _3875_/A1 sky130_fd_sc_hd__dlygate4sd3_1
XFILLER_57_821 VPWR VGND VPWR VGND sky130_ef_sc_hd__decap_40_12
XFILLER_48_309 VGND VGND VPWR VPWR sky130_fd_sc_hd__fill_4
XFILLER_84_27 VGND VGND VPWR VPWR sky130_fd_sc_hd__fill_1
Xhold1842 _5291_/Q VGND VGND VPWR VPWR _3152_/A1 sky130_fd_sc_hd__dlygate4sd3_1
Xhold1831 _4390_/X VGND VGND VPWR VPWR _6029_/D sky130_fd_sc_hd__dlygate4sd3_1
Xhold1853 _5706_/Q VGND VGND VPWR VPWR _3684_/A1 sky130_fd_sc_hd__dlygate4sd3_1
XFILLER_29_523 VGND VGND VPWR VPWR sky130_fd_sc_hd__fill_4
Xhold1864 _3524_/X VGND VGND VPWR VPWR _5567_/D sky130_fd_sc_hd__dlygate4sd3_1
Xhold1875 _5560_/Q VGND VGND VPWR VPWR _3516_/A1 sky130_fd_sc_hd__dlygate4sd3_1
XTAP_TAPCELL_ROW_67_1305 VGND VPWR sky130_fd_sc_hd__tapvpwrvgnd_1
XFILLER_17_729 VPWR VGND VPWR VGND sky130_ef_sc_hd__decap_40_12
Xhold1886 _3409_/X VGND VGND VPWR VPWR _5464_/D sky130_fd_sc_hd__dlygate4sd3_1
XTAP_TAPCELL_ROW_27_702 VGND VPWR sky130_fd_sc_hd__tapvpwrvgnd_1
XFILLER_29_556 VGND VGND VPWR VPWR sky130_fd_sc_hd__fill_2
XFILLER_71_323 VGND VGND VPWR VPWR sky130_fd_sc_hd__fill_1
Xhold1897 _5088_/X VGND VGND VPWR VPWR _6376_/D sky130_fd_sc_hd__dlygate4sd3_1
Xi2c_master_axil_220 VGND VGND VPWR VPWR i2c_master_axil_220/HI s_axil_rdata[26] sky130_fd_sc_hd__conb_1
XANTENNA__4694__S0 _4811_/A1 VGND VGND VPWR VPWR sky130_fd_sc_hd__diode_2
XTAP_TAPCELL_ROW_80_1505 VGND VPWR sky130_fd_sc_hd__tapvpwrvgnd_1
XFILLER_12_401 VPWR VGND VPWR VGND sky130_ef_sc_hd__decap_40_12
XFILLER_40_710 VGND VGND VPWR VPWR sky130_fd_sc_hd__fill_2
XFILLER_12_445 VPWR VGND VPWR VGND sky130_ef_sc_hd__decap_40_12
XFILLER_33_31 VGND VGND VPWR VPWR sky130_fd_sc_hd__fill_2
XFILLER_33_53 VGND VGND VPWR VPWR sky130_fd_sc_hd__fill_2
XFILLER_40_765 VPWR VGND VPWR VGND sky130_ef_sc_hd__decap_40_12
XANTENNA__3574__A1 _4964_/A0 VGND VGND VPWR VPWR sky130_fd_sc_hd__diode_2
XFILLER_12_489 VPWR VGND VPWR VGND sky130_ef_sc_hd__decap_40_12
XFILLER_138_697 VGND VGND VPWR VPWR sky130_fd_sc_hd__fill_2
XFILLER_126_837 VGND VGND VPWR VPWR sky130_fd_sc_hd__fill_4
XFILLER_125_314 VGND VGND VPWR VPWR sky130_fd_sc_hd__fill_2
XFILLER_137_185 VGND VGND VPWR VPWR sky130_fd_sc_hd__fill_1
XTAP_TAPCELL_ROW_78_1467 VGND VPWR sky130_fd_sc_hd__tapvpwrvgnd_1
XFILLER_98_209 VGND VGND VPWR VPWR sky130_fd_sc_hd__fill_1
XFILLER_4_699 VGND VGND VPWR VPWR sky130_fd_sc_hd__fill_1
XTAP_TAPCELL_ROW_91_1667 VGND VPWR sky130_fd_sc_hd__tapvpwrvgnd_1
XANTENNA__2828__A _2962_/A VGND VGND VPWR VPWR sky130_fd_sc_hd__diode_2
XFILLER_121_597 VPWR VGND VPWR VGND sky130_ef_sc_hd__decap_40_12
Xhold5 hold5/A VGND VGND VPWR VPWR hold5/X sky130_fd_sc_hd__dlygate4sd3_1
XFILLER_47_353 VGND VGND VPWR VPWR sky130_fd_sc_hd__fill_1
XTAP_TAPCELL_ROW_122_2133 VGND VPWR sky130_fd_sc_hd__tapvpwrvgnd_1
XANTENNA_clkload3_A clkload3/A VGND VGND VPWR VPWR sky130_fd_sc_hd__diode_2
XFILLER_74_60 VGND VGND VPWR VPWR sky130_fd_sc_hd__fill_1
XFILLER_90_643 VGND VGND VPWR VPWR sky130_fd_sc_hd__fill_1
XFILLER_74_71 VGND VGND VPWR VPWR sky130_fd_sc_hd__fill_1
XFILLER_62_367 VGND VGND VPWR VPWR sky130_fd_sc_hd__fill_4
X_2940_ _3085_/A _2940_/B VGND VGND VPWR VPWR _2940_/X sky130_fd_sc_hd__and2_1
XANTENNA__3262__B1 _3237_/A VGND VGND VPWR VPWR sky130_fd_sc_hd__diode_2
X_2871_ _3044_/A _2871_/B VGND VGND VPWR VPWR _2871_/X sky130_fd_sc_hd__or2_1
X_4610_ _5862_/Q _5853_/Q _4778_/S VGND VGND VPWR VPWR _4611_/B sky130_fd_sc_hd__mux2_1
XFILLER_129_653 VPWR VGND VPWR VGND sky130_ef_sc_hd__decap_40_12
XTAP_TAPCELL_ROW_100_1796 VGND VPWR sky130_fd_sc_hd__tapvpwrvgnd_1
X_5590_ _6095_/CLK _5590_/D VGND VGND VPWR VPWR _5590_/Q sky130_fd_sc_hd__dfxtp_1
X_4541_ hold325/X _5075_/A0 _4547_/S VGND VGND VPWR VPWR _4541_/X sky130_fd_sc_hd__mux2_1
XFILLER_117_837 VGND VGND VPWR VPWR sky130_fd_sc_hd__fill_2
XTAP_TAPCELL_ROW_13_495 VGND VPWR sky130_fd_sc_hd__tapvpwrvgnd_1
XANTENNA__4762__B1 _2628_/A VGND VGND VPWR VPWR sky130_fd_sc_hd__diode_2
XFILLER_129_697 VPWR VGND VPWR VGND sky130_ef_sc_hd__decap_40_12
X_4472_ _5237_/A0 _4472_/A1 _4472_/S VGND VGND VPWR VPWR _4472_/X sky130_fd_sc_hd__mux2_1
Xhold427 _5486_/Q VGND VGND VPWR VPWR hold427/X sky130_fd_sc_hd__dlygate4sd3_1
Xhold405 _5749_/Q VGND VGND VPWR VPWR hold405/X sky130_fd_sc_hd__dlygate4sd3_1
Xhold416 _4355_/X VGND VGND VPWR VPWR _5998_/D sky130_fd_sc_hd__dlygate4sd3_1
Xhold438 _3119_/X VGND VGND VPWR VPWR _5312_/D sky130_fd_sc_hd__dlygate4sd3_1
XTAP_TAPCELL_ROW_133_2295 VGND VPWR sky130_fd_sc_hd__tapvpwrvgnd_1
Xhold449 _5366_/Q VGND VGND VPWR VPWR hold449/X sky130_fd_sc_hd__dlygate4sd3_1
X_6211_ _6242_/CLK _6211_/D VGND VGND VPWR VPWR _6211_/Q sky130_fd_sc_hd__dfxtp_1
X_3423_ hold714/X _4964_/A0 _3423_/S VGND VGND VPWR VPWR _3423_/X sky130_fd_sc_hd__mux2_1
X_6142_ _6143_/CLK _6142_/D VGND VGND VPWR VPWR _6142_/Q sky130_fd_sc_hd__dfxtp_1
XFILLER_112_531 VGND VGND VPWR VPWR sky130_fd_sc_hd__fill_1
X_3354_ _3354_/A1 _5035_/C _5201_/B _5432_/Q VGND VGND VPWR VPWR _3354_/X sky130_fd_sc_hd__a22o_1
X_6073_ _6365_/CLK _6073_/D VGND VGND VPWR VPWR _6073_/Q sky130_fd_sc_hd__dfxtp_1
X_3285_ hold71/X _5239_/A1 _3295_/S VGND VGND VPWR VPWR hold72/A sky130_fd_sc_hd__mux2_1
Xhold1105 _3866_/X VGND VGND VPWR VPWR _5848_/D sky130_fd_sc_hd__dlygate4sd3_1
XFILLER_57_117 VGND VGND VPWR VPWR sky130_fd_sc_hd__fill_1
XFILLER_39_821 VPWR VGND VPWR VGND sky130_ef_sc_hd__decap_40_12
Xhold1138 _5373_/Q VGND VGND VPWR VPWR _3213_/A1 sky130_fd_sc_hd__dlygate4sd3_1
XFILLER_100_737 VPWR VGND VPWR VGND sky130_ef_sc_hd__decap_40_12
X_5024_ _5022_/X _5023_/X _6328_/Q VGND VGND VPWR VPWR _5024_/X sky130_fd_sc_hd__mux2_1
XFILLER_66_640 VGND VGND VPWR VPWR sky130_fd_sc_hd__fill_4
XFILLER_57_128 VGND VGND VPWR VPWR sky130_fd_sc_hd__fill_1
Xhold1127 _3412_/X VGND VGND VPWR VPWR _5467_/D sky130_fd_sc_hd__dlygate4sd3_1
Xhold1116 _6277_/Q VGND VGND VPWR VPWR _4941_/A1 sky130_fd_sc_hd__dlygate4sd3_1
Xhold1149 _4353_/X VGND VGND VPWR VPWR _5996_/D sky130_fd_sc_hd__dlygate4sd3_1
XTAP_TAPCELL_ROW_107_1906 VGND VPWR sky130_fd_sc_hd__tapvpwrvgnd_1
XFILLER_65_150 VGND VGND VPWR VPWR sky130_fd_sc_hd__fill_2
XFILLER_54_813 VPWR VGND VPWR VGND sky130_ef_sc_hd__decap_40_12
XANTENNA_fanout175_A _2995_/A VGND VGND VPWR VPWR sky130_fd_sc_hd__diode_2
XTAP_TAPCELL_ROW_49_1035 VGND VPWR sky130_fd_sc_hd__tapvpwrvgnd_1
XFILLER_53_356 VGND VGND VPWR VPWR sky130_fd_sc_hd__fill_1
X_5926_ _6349_/CLK _5926_/D VGND VGND VPWR VPWR _5926_/Q sky130_fd_sc_hd__dfxtp_1
XANTENNA__4164__S _4213_/S VGND VGND VPWR VPWR sky130_fd_sc_hd__diode_2
XFILLER_110_47 VGND VGND VPWR VPWR sky130_fd_sc_hd__fill_1
XTAP_TAPCELL_ROW_62_1235 VGND VPWR sky130_fd_sc_hd__tapvpwrvgnd_1
XTAP_TAPCELL_ROW_62_1224 VGND VPWR sky130_fd_sc_hd__tapvpwrvgnd_1
X_5857_ _6095_/CLK _5857_/D VGND VGND VPWR VPWR _5857_/Q sky130_fd_sc_hd__dfxtp_1
XFILLER_70_29 VGND VGND VPWR VPWR sky130_fd_sc_hd__fill_8
XANTENNA_fanout130_X _5233_/A0 VGND VGND VPWR VPWR sky130_fd_sc_hd__diode_2
X_5788_ _6123_/CLK _5788_/D VGND VGND VPWR VPWR _5788_/Q sky130_fd_sc_hd__dfxtp_1
XTAP_TAPCELL_ROW_32_782 VGND VPWR sky130_fd_sc_hd__tapvpwrvgnd_1
X_4808_ _5719_/Q _5710_/Q _4808_/S VGND VGND VPWR VPWR _4809_/B sky130_fd_sc_hd__mux2_1
XANTENNA__3508__S _3516_/S VGND VGND VPWR VPWR sky130_fd_sc_hd__diode_2
X_4739_ _4791_/A1 _4738_/X _4792_/A1 VGND VGND VPWR VPWR _4739_/Y sky130_fd_sc_hd__o21ai_1
XFILLER_5_419 VGND VGND VPWR VPWR sky130_fd_sc_hd__fill_1
XFILLER_108_837 VGND VGND VPWR VPWR sky130_fd_sc_hd__fill_4
XANTENNA__3308__A1 _5237_/A0 VGND VGND VPWR VPWR sky130_fd_sc_hd__diode_2
X_6409_ _6409_/CLK _6409_/D VGND VGND VPWR VPWR _6409_/Q sky130_fd_sc_hd__dfxtp_1
Xhold972 _5415_/Q VGND VGND VPWR VPWR hold972/X sky130_fd_sc_hd__dlygate4sd3_1
XPHY_EDGE_ROW_79_Left_218 VGND VGND VPWR VPWR sky130_fd_sc_hd__decap_3
Xhold961 _3785_/X VGND VGND VPWR VPWR _5793_/D sky130_fd_sc_hd__dlygate4sd3_1
Xhold950 _5673_/Q VGND VGND VPWR VPWR hold950/X sky130_fd_sc_hd__dlygate4sd3_1
XFILLER_135_55 VGND VGND VPWR VPWR sky130_fd_sc_hd__fill_1
Xhold994 _5378_/Q VGND VGND VPWR VPWR hold994/X sky130_fd_sc_hd__dlygate4sd3_1
XFILLER_115_391 VGND VGND VPWR VPWR sky130_fd_sc_hd__fill_1
XFILLER_89_765 VPWR VGND VPWR VGND sky130_ef_sc_hd__decap_40_12
XANTENNA_fanout88_A _5209_/A1 VGND VGND VPWR VPWR sky130_fd_sc_hd__diode_2
Xhold983 _6100_/Q VGND VGND VPWR VPWR hold983/X sky130_fd_sc_hd__dlygate4sd3_1
XFILLER_1_669 VGND VGND VPWR VPWR sky130_fd_sc_hd__fill_2
XANTENNA__2648__A _3801_/A VGND VGND VPWR VPWR sky130_fd_sc_hd__diode_2
XFILLER_95_15 VPWR VGND VPWR VGND sky130_ef_sc_hd__decap_40_12
XFILLER_88_253 VGND VGND VPWR VPWR sky130_fd_sc_hd__fill_1
XTAP_TAPCELL_ROW_73_1397 VGND VPWR sky130_fd_sc_hd__tapvpwrvgnd_1
XFILLER_130_394 VGND VGND VPWR VPWR sky130_fd_sc_hd__fill_1
XFILLER_103_597 VPWR VGND VPWR VGND sky130_ef_sc_hd__decap_40_12
XFILLER_48_139 VGND VGND VPWR VPWR sky130_fd_sc_hd__fill_1
XFILLER_28_31 VGND VGND VPWR VPWR sky130_fd_sc_hd__fill_2
Xhold1650 _5485_/Q VGND VGND VPWR VPWR _3434_/A0 sky130_fd_sc_hd__dlygate4sd3_1
Xhold1661 _3769_/X VGND VGND VPWR VPWR _5779_/D sky130_fd_sc_hd__dlygate4sd3_1
Xhold1683 _6247_/Q VGND VGND VPWR VPWR _4899_/A1 sky130_fd_sc_hd__dlygate4sd3_1
XANTENNA__3492__A0 _5238_/A1 VGND VGND VPWR VPWR sky130_fd_sc_hd__diode_2
Xhold1672 _6430_/Q VGND VGND VPWR VPWR _5233_/A1 sky130_fd_sc_hd__dlygate4sd3_1
Xhold1694 _3411_/X VGND VGND VPWR VPWR _5466_/D sky130_fd_sc_hd__dlygate4sd3_1
XFILLER_29_375 VGND VGND VPWR VPWR sky130_fd_sc_hd__fill_1
XFILLER_44_356 VGND VGND VPWR VPWR sky130_fd_sc_hd__fill_1
XFILLER_17_559 VGND VGND VPWR VPWR sky130_fd_sc_hd__fill_1
XPHY_EDGE_ROW_88_Left_227 VGND VGND VPWR VPWR sky130_fd_sc_hd__decap_3
XFILLER_71_164 VGND VGND VPWR VPWR sky130_fd_sc_hd__fill_4
XFILLER_71_186 VGND VGND VPWR VPWR sky130_fd_sc_hd__fill_1
XANTENNA__3795__A1 _5214_/A1 VGND VGND VPWR VPWR sky130_fd_sc_hd__diode_2
XFILLER_44_74 VGND VGND VPWR VPWR sky130_fd_sc_hd__fill_8
XFILLER_13_721 VGND VGND VPWR VPWR sky130_fd_sc_hd__fill_4
XFILLER_9_725 VGND VGND VPWR VPWR sky130_fd_sc_hd__fill_2
XFILLER_12_253 VGND VGND VPWR VPWR sky130_fd_sc_hd__fill_1
XFILLER_13_765 VPWR VGND VPWR VGND sky130_ef_sc_hd__decap_40_12
XFILLER_40_584 VGND VGND VPWR VPWR sky130_fd_sc_hd__fill_4
XFILLER_126_601 VPWR VGND VPWR VGND sky130_ef_sc_hd__decap_40_12
XANTENNA__3547__A1 _4517_/A1 VGND VGND VPWR VPWR sky130_fd_sc_hd__diode_2
XTAP_TAPCELL_ROW_10_443 VGND VPWR sky130_fd_sc_hd__tapvpwrvgnd_1
XFILLER_126_645 VPWR VGND VPWR VGND sky130_ef_sc_hd__decap_40_12
XFILLER_125_111 VGND VGND VPWR VPWR sky130_fd_sc_hd__fill_1
XTAP_TAPCELL_ROW_10_454 VGND VPWR sky130_fd_sc_hd__tapvpwrvgnd_1
XFILLER_125_133 VPWR VGND VPWR VGND sky130_ef_sc_hd__decap_40_12
XPHY_EDGE_ROW_97_Left_236 VGND VGND VPWR VPWR sky130_fd_sc_hd__decap_3
XFILLER_4_441 VPWR VGND VPWR VGND sky130_ef_sc_hd__decap_40_12
XFILLER_5_57 VGND VGND VPWR VPWR sky130_fd_sc_hd__fill_8
X_3070_ hold6/X _3011_/A _3069_/X VGND VGND VPWR VPWR hold7/A sky130_fd_sc_hd__a21o_1
XFILLER_94_278 VGND VGND VPWR VPWR sky130_fd_sc_hd__fill_1
XFILLER_36_813 VPWR VGND VPWR VGND sky130_ef_sc_hd__decap_40_12
XTAP_TAPCELL_ROW_18_565 VGND VPWR sky130_fd_sc_hd__tapvpwrvgnd_1
XTAP_TAPCELL_ROW_18_576 VGND VPWR sky130_fd_sc_hd__tapvpwrvgnd_1
XTAP_TAPCELL_ROW_102_1836 VGND VPWR sky130_fd_sc_hd__tapvpwrvgnd_1
XTAP_TAPCELL_ROW_102_1825 VGND VPWR sky130_fd_sc_hd__tapvpwrvgnd_1
XFILLER_62_197 VGND VGND VPWR VPWR sky130_fd_sc_hd__fill_4
X_3972_ _3972_/A _3972_/B _3972_/C VGND VGND VPWR VPWR _5029_/B sky130_fd_sc_hd__or3_2
XFILLER_16_581 VGND VGND VPWR VPWR sky130_fd_sc_hd__fill_4
XANTENNA__3786__A1 _5215_/A1 VGND VGND VPWR VPWR sky130_fd_sc_hd__diode_2
X_5711_ _5714_/CLK hold58/X VGND VGND VPWR VPWR hold57/A sky130_fd_sc_hd__dfxtp_1
X_2923_ _2916_/X _2922_/X _3083_/S VGND VGND VPWR VPWR _2923_/X sky130_fd_sc_hd__mux2_1
X_2854_ _5299_/Q _5372_/Q _5360_/Q _6141_/Q _2984_/S _2985_/A VGND VGND VPWR VPWR
+ _2854_/X sky130_fd_sc_hd__mux4_1
X_5642_ _6237_/CLK _5642_/D VGND VGND VPWR VPWR _5642_/Q sky130_fd_sc_hd__dfxtp_1
XTAP_TAPCELL_ROW_135_2324 VGND VPWR sky130_fd_sc_hd__tapvpwrvgnd_1
X_2785_ _2985_/A _2785_/B VGND VGND VPWR VPWR _2785_/X sky130_fd_sc_hd__or2_1
X_5573_ _5820_/CLK _5573_/D VGND VGND VPWR VPWR _5573_/Q sky130_fd_sc_hd__dfxtp_1
XANTENNA__3538__A1 _5234_/A0 VGND VGND VPWR VPWR sky130_fd_sc_hd__diode_2
X_4524_ hold789/X _4882_/A1 _4532_/S VGND VGND VPWR VPWR _6126_/D sky130_fd_sc_hd__mux2_1
Xhold202 _4298_/X VGND VGND VPWR VPWR _5948_/D sky130_fd_sc_hd__dlygate4sd3_1
Xhold235 _4539_/X VGND VGND VPWR VPWR _6141_/D sky130_fd_sc_hd__dlygate4sd3_1
Xhold224 _6151_/Q VGND VGND VPWR VPWR hold224/X sky130_fd_sc_hd__dlygate4sd3_1
Xhold213 _3385_/X VGND VGND VPWR VPWR _5444_/D sky130_fd_sc_hd__dlygate4sd3_1
XFILLER_132_637 VGND VGND VPWR VPWR sky130_fd_sc_hd__fill_4
Xhold257 _4542_/X VGND VGND VPWR VPWR _6144_/D sky130_fd_sc_hd__dlygate4sd3_1
X_4455_ _4455_/A1 _4457_/S _4454_/X VGND VGND VPWR VPWR _4455_/X sky130_fd_sc_hd__o21a_1
Xhold246 _5880_/Q VGND VGND VPWR VPWR hold246/X sky130_fd_sc_hd__dlygate4sd3_1
Xhold268 _5672_/Q VGND VGND VPWR VPWR hold268/X sky130_fd_sc_hd__dlygate4sd3_1
Xhold279 _4444_/X VGND VGND VPWR VPWR _6062_/D sky130_fd_sc_hd__dlygate4sd3_1
X_4386_ hold53/X _5047_/A1 _4386_/S VGND VGND VPWR VPWR hold54/A sky130_fd_sc_hd__mux2_1
X_3406_ _4978_/A1 _3406_/A1 _3412_/S VGND VGND VPWR VPWR _3406_/X sky130_fd_sc_hd__mux2_1
XTAP_TAPCELL_ROW_113_1998 VGND VPWR sky130_fd_sc_hd__tapvpwrvgnd_1
XANTENNA__5840__Q _5840_/Q VGND VGND VPWR VPWR sky130_fd_sc_hd__diode_2
X_3337_ _3337_/A _3337_/B VGND VGND VPWR VPWR _3338_/B sky130_fd_sc_hd__nor2_1
XFILLER_58_404 VGND VGND VPWR VPWR sky130_fd_sc_hd__fill_2
XANTENNA__3710__A1 _5040_/A1 VGND VGND VPWR VPWR sky130_fd_sc_hd__diode_2
X_6125_ _6125_/CLK _6125_/D VGND VGND VPWR VPWR _6125_/Q sky130_fd_sc_hd__dfxtp_1
XFILLER_100_545 VPWR VGND VPWR VGND sky130_ef_sc_hd__decap_40_12
XFILLER_100_523 VGND VGND VPWR VPWR sky130_fd_sc_hd__fill_8
XFILLER_86_757 VPWR VGND VPWR VGND sky130_ef_sc_hd__decap_40_12
X_6056_ _6382_/CLK _6056_/D VGND VGND VPWR VPWR _6056_/Q sky130_fd_sc_hd__dfxtp_1
X_3268_ _3801_/A _3268_/B _3272_/C VGND VGND VPWR VPWR _3268_/Y sky130_fd_sc_hd__nor3_1
X_3199_ _3199_/A0 _4899_/A0 _3206_/S VGND VGND VPWR VPWR _3199_/X sky130_fd_sc_hd__mux2_1
XANTENNA_fanout178_X _3076_/A1 VGND VGND VPWR VPWR sky130_fd_sc_hd__diode_2
XANTENNA__3474__A0 _4903_/A0 VGND VGND VPWR VPWR sky130_fd_sc_hd__diode_2
XFILLER_100_589 VPWR VGND VPWR VGND sky130_ef_sc_hd__decap_40_12
X_5007_ _4010_/A _4998_/Y _5006_/Y _4997_/X _2652_/Y VGND VGND VPWR VPWR _5007_/Y
+ sky130_fd_sc_hd__a32oi_1
XFILLER_54_643 VGND VGND VPWR VPWR sky130_fd_sc_hd__fill_1
XFILLER_26_356 VGND VGND VPWR VPWR sky130_fd_sc_hd__fill_8
XTAP_TAPCELL_ROW_37_852 VGND VPWR sky130_fd_sc_hd__tapvpwrvgnd_1
XFILLER_121_57 VGND VGND VPWR VPWR sky130_fd_sc_hd__fill_2
XFILLER_14_529 VGND VGND VPWR VPWR sky130_fd_sc_hd__fill_2
XFILLER_26_389 VPWR VGND VPWR VGND sky130_ef_sc_hd__decap_40_12
XANTENNA__5215__A1 _5215_/A1 VGND VGND VPWR VPWR sky130_fd_sc_hd__diode_2
XANTENNA__4974__A0 _4984_/A1 VGND VGND VPWR VPWR sky130_fd_sc_hd__diode_2
XFILLER_41_337 VGND VGND VPWR VPWR sky130_fd_sc_hd__fill_1
X_5909_ _6307_/CLK _5909_/D VGND VGND VPWR VPWR _5909_/Q sky130_fd_sc_hd__dfxtp_1
XFILLER_14_33 VGND VGND VPWR VPWR sky130_fd_sc_hd__fill_1
XFILLER_10_713 VPWR VGND VPWR VGND sky130_ef_sc_hd__decap_40_12
XFILLER_108_601 VPWR VGND VPWR VGND sky130_ef_sc_hd__decap_40_12
XFILLER_10_757 VPWR VGND VPWR VGND sky130_ef_sc_hd__decap_40_12
XFILLER_108_645 VPWR VGND VPWR VGND sky130_ef_sc_hd__decap_40_12
XFILLER_30_21 VGND VGND VPWR VPWR sky130_fd_sc_hd__fill_1
XTAP_TAPCELL_ROW_75_1426 VGND VPWR sky130_fd_sc_hd__tapvpwrvgnd_1
XFILLER_135_475 VPWR VGND VPWR VGND sky130_ef_sc_hd__decap_40_12
XFILLER_123_615 VGND VGND VPWR VPWR sky130_fd_sc_hd__fill_1
XFILLER_107_177 VGND VGND VPWR VPWR sky130_fd_sc_hd__fill_1
XFILLER_100_3 VPWR VGND VPWR VGND sky130_ef_sc_hd__decap_40_12
Xhold780 _4545_/X VGND VGND VPWR VPWR _6147_/D sky130_fd_sc_hd__dlygate4sd3_1
Xhold791 _6342_/Q VGND VGND VPWR VPWR hold791/X sky130_fd_sc_hd__dlygate4sd3_1
XANTENNA__4069__S _4213_/S VGND VGND VPWR VPWR sky130_fd_sc_hd__diode_2
XFILLER_103_383 VGND VGND VPWR VPWR sky130_fd_sc_hd__fill_1
Xhold2181 _2723_/B VGND VGND VPWR VPWR _4417_/A2 sky130_fd_sc_hd__dlygate4sd3_1
XFILLER_77_768 VPWR VGND VPWR VGND sky130_ef_sc_hd__decap_40_12
XANTENNA_input20_A s_axil_wdata[2] VGND VGND VPWR VPWR sky130_fd_sc_hd__diode_2
Xhold2170 _4018_/X VGND VGND VPWR VPWR _5918_/D sky130_fd_sc_hd__dlygate4sd3_1
XFILLER_92_749 VGND VGND VPWR VPWR sky130_fd_sc_hd__fill_4
XANTENNA__3701__S _3707_/S VGND VGND VPWR VPWR sky130_fd_sc_hd__diode_2
XFILLER_64_418 VGND VGND VPWR VPWR sky130_fd_sc_hd__fill_2
Xhold2192 _5427_/Q VGND VGND VPWR VPWR _3311_/B sky130_fd_sc_hd__dlygate4sd3_1
XANTENNA__4593__A _4809_/A VGND VGND VPWR VPWR sky130_fd_sc_hd__diode_2
XFILLER_18_813 VPWR VGND VPWR VGND sky130_ef_sc_hd__decap_40_12
Xhold1491 _3462_/X VGND VGND VPWR VPWR _5511_/D sky130_fd_sc_hd__dlygate4sd3_1
Xhold1480 _5089_/X VGND VGND VPWR VPWR _6377_/D sky130_fd_sc_hd__dlygate4sd3_1
XFILLER_29_194 VGND VGND VPWR VPWR sky130_fd_sc_hd__fill_2
XANTENNA__3217__A0 _4903_/A0 VGND VGND VPWR VPWR sky130_fd_sc_hd__diode_2
XTAP_TAPCELL_ROW_86_1588 VGND VPWR sky130_fd_sc_hd__tapvpwrvgnd_1
XANTENNA__5201__B _5201_/B VGND VGND VPWR VPWR sky130_fd_sc_hd__diode_2
XFILLER_55_73 VGND VGND VPWR VPWR sky130_fd_sc_hd__fill_1
XFILLER_17_389 VGND VGND VPWR VPWR sky130_fd_sc_hd__fill_2
XTAP_TAPCELL_ROW_15_524 VGND VPWR sky130_fd_sc_hd__tapvpwrvgnd_1
XFILLER_13_573 VPWR VGND VPWR VGND sky130_ef_sc_hd__decap_40_12
XTAP_TAPCELL_ROW_117_2054 VGND VPWR sky130_fd_sc_hd__tapvpwrvgnd_1
XTAP_TAPCELL_ROW_130_2243 VGND VPWR sky130_fd_sc_hd__tapvpwrvgnd_1
XFILLER_114_637 VGND VGND VPWR VPWR sky130_fd_sc_hd__fill_4
XFILLER_5_783 VGND VGND VPWR VPWR sky130_fd_sc_hd__fill_1
XTAP_TAPCELL_ROW_130_2254 VGND VPWR sky130_fd_sc_hd__tapvpwrvgnd_1
X_4240_ _6306_/Q _6288_/Q _4258_/S VGND VGND VPWR VPWR _4241_/B sky130_fd_sc_hd__mux2_1
X_4171_ _5987_/Q _5978_/Q _4262_/S VGND VGND VPWR VPWR _4172_/B sky130_fd_sc_hd__mux2_1
XFILLER_122_681 VPWR VGND VPWR VGND sky130_ef_sc_hd__decap_40_12
X_3122_ hold863/X _5233_/A0 _3126_/S VGND VGND VPWR VPWR _3122_/X sky130_fd_sc_hd__mux2_1
XFILLER_95_521 VPWR VGND VPWR VGND sky130_ef_sc_hd__decap_40_12
XANTENNA_hold2222_A _5828_/Q VGND VGND VPWR VPWR sky130_fd_sc_hd__diode_2
XFILLER_55_407 VGND VGND VPWR VPWR sky130_fd_sc_hd__fill_1
X_3053_ _3076_/A1 _3048_/X _3050_/X _3052_/X VGND VGND VPWR VPWR _3053_/X sky130_fd_sc_hd__a22o_1
XFILLER_83_749 VGND VGND VPWR VPWR sky130_fd_sc_hd__fill_1
XFILLER_83_727 VGND VGND VPWR VPWR sky130_fd_sc_hd__fill_1
XFILLER_67_278 VGND VGND VPWR VPWR sky130_fd_sc_hd__fill_2
XFILLER_55_429 VGND VGND VPWR VPWR sky130_fd_sc_hd__fill_1
XFILLER_48_492 VGND VGND VPWR VPWR sky130_fd_sc_hd__fill_4
XFILLER_36_643 VGND VGND VPWR VPWR sky130_fd_sc_hd__fill_1
XFILLER_51_613 VGND VGND VPWR VPWR sky130_fd_sc_hd__fill_2
XFILLER_24_805 VGND VGND VPWR VPWR sky130_fd_sc_hd__fill_4
XFILLER_23_337 VGND VGND VPWR VPWR sky130_fd_sc_hd__fill_4
XTAP_TAPCELL_ROW_34_811 VGND VPWR sky130_fd_sc_hd__tapvpwrvgnd_1
XANTENNA__4956__A0 _5208_/A1 VGND VGND VPWR VPWR sky130_fd_sc_hd__diode_2
X_3955_ _6405_/Q _3955_/B _5191_/A _5191_/B VGND VGND VPWR VPWR _3959_/A sky130_fd_sc_hd__or4_2
XANTENNA__3759__A1 _5052_/A1 VGND VGND VPWR VPWR sky130_fd_sc_hd__diode_2
X_2906_ hold59/A _5578_/Q _3086_/S VGND VGND VPWR VPWR _2906_/X sky130_fd_sc_hd__mux2_1
XANTENNA__4420__A2 _4445_/B VGND VGND VPWR VPWR sky130_fd_sc_hd__diode_2
XFILLER_137_729 VPWR VGND VPWR VGND sky130_ef_sc_hd__decap_40_12
X_3886_ hold252/X _6415_/Q _3889_/S VGND VGND VPWR VPWR _3886_/X sky130_fd_sc_hd__mux2_1
X_5625_ _6097_/CLK _5625_/D VGND VGND VPWR VPWR _5625_/Q sky130_fd_sc_hd__dfxtp_1
XANTENNA_fanout138_A _2628_/A VGND VGND VPWR VPWR sky130_fd_sc_hd__diode_2
X_2837_ _3096_/A1 _2836_/X _2833_/Y _2835_/Y VGND VGND VPWR VPWR _2837_/X sky130_fd_sc_hd__o2bb2a_1
XFILLER_129_291 VGND VGND VPWR VPWR sky130_fd_sc_hd__fill_1
X_2768_ _3085_/A _2768_/B VGND VGND VPWR VPWR _2768_/X sky130_fd_sc_hd__and2_1
X_5556_ _6399_/CLK _5556_/D VGND VGND VPWR VPWR _5556_/Q sky130_fd_sc_hd__dfxtp_1
XFILLER_3_709 VPWR VGND VPWR VGND sky130_ef_sc_hd__decap_40_12
XFILLER_105_615 VGND VGND VPWR VPWR sky130_fd_sc_hd__fill_1
X_5487_ _6241_/CLK _5487_/D VGND VGND VPWR VPWR _5487_/Q sky130_fd_sc_hd__dfxtp_1
X_4507_ hold683/X _4517_/A1 _4512_/S VGND VGND VPWR VPWR _4507_/X sky130_fd_sc_hd__mux2_1
X_2699_ _2697_/Y _2698_/X _2696_/X VGND VGND VPWR VPWR _3160_/A sky130_fd_sc_hd__a21o_1
X_4438_ _5396_/Q _4994_/B _3801_/B VGND VGND VPWR VPWR _4438_/X sky130_fd_sc_hd__a21o_1
XTAP_TAPCELL_ROW_57_1156 VGND VPWR sky130_fd_sc_hd__tapvpwrvgnd_1
XFILLER_132_489 VPWR VGND VPWR VGND sky130_ef_sc_hd__decap_40_12
XFILLER_116_68 VGND VGND VPWR VPWR sky130_fd_sc_hd__fill_4
XFILLER_101_821 VPWR VGND VPWR VGND sky130_ef_sc_hd__decap_40_12
XTAP_TAPCELL_ROW_70_1356 VGND VPWR sky130_fd_sc_hd__tapvpwrvgnd_1
XTAP_TAPCELL_ROW_70_1345 VGND VPWR sky130_fd_sc_hd__tapvpwrvgnd_1
X_4369_ _5052_/A1 _4369_/A1 _4376_/S VGND VGND VPWR VPWR _4369_/X sky130_fd_sc_hd__mux2_1
XANTENNA__4965__X _4974_/S VGND VGND VPWR VPWR sky130_fd_sc_hd__diode_2
X_6108_ _6125_/CLK _6108_/D VGND VGND VPWR VPWR _6108_/Q sky130_fd_sc_hd__dfxtp_1
XANTENNA__3521__S _3529_/S VGND VGND VPWR VPWR sky130_fd_sc_hd__diode_2
X_6039_ _6347_/CLK _6039_/D VGND VGND VPWR VPWR _6039_/Q sky130_fd_sc_hd__dfxtp_1
XFILLER_92_27 VGND VGND VPWR VPWR sky130_fd_sc_hd__fill_1
XANTENNA__2670__A1 _4887_/A1 VGND VGND VPWR VPWR sky130_fd_sc_hd__diode_2
XFILLER_26_197 VGND VGND VPWR VPWR sky130_fd_sc_hd__fill_1
XANTENNA__4947__A0 _5824_/Q VGND VGND VPWR VPWR sky130_fd_sc_hd__diode_2
XANTENNA__4352__S _4356_/S VGND VGND VPWR VPWR sky130_fd_sc_hd__diode_2
XFILLER_10_587 VGND VGND VPWR VPWR sky130_fd_sc_hd__fill_1
XFILLER_6_525 VGND VGND VPWR VPWR sky130_fd_sc_hd__fill_4
XANTENNA__4175__A1 _4205_/A VGND VGND VPWR VPWR sky130_fd_sc_hd__diode_2
XFILLER_6_569 VPWR VGND VPWR VGND sky130_ef_sc_hd__decap_40_12
XTAP_TAPCELL_ROW_20_593 VGND VPWR sky130_fd_sc_hd__tapvpwrvgnd_1
XANTENNA__3922__A1 _4958_/A0 VGND VGND VPWR VPWR sky130_fd_sc_hd__diode_2
XFILLER_111_629 VPWR VGND VPWR VGND sky130_ef_sc_hd__decap_40_12
XFILLER_2_753 VGND VGND VPWR VPWR sky130_fd_sc_hd__fill_2
XFILLER_1_241 VGND VGND VPWR VPWR sky130_fd_sc_hd__fill_1
XFILLER_104_681 VPWR VGND VPWR VGND sky130_ef_sc_hd__decap_40_12
XANTENNA__3686__A0 _3926_/A1 VGND VGND VPWR VPWR sky130_fd_sc_hd__diode_2
XANTENNA__4527__S _4535_/S VGND VGND VPWR VPWR sky130_fd_sc_hd__diode_2
XTAP_TAPCELL_ROW_88_1617 VGND VPWR sky130_fd_sc_hd__tapvpwrvgnd_1
XFILLER_77_598 VGND VGND VPWR VPWR sky130_fd_sc_hd__fill_4
XFILLER_92_557 VPWR VGND VPWR VGND sky130_ef_sc_hd__decap_40_12
XANTENNA__3431__S _3437_/S VGND VGND VPWR VPWR sky130_fd_sc_hd__diode_2
XFILLER_18_643 VGND VGND VPWR VPWR sky130_fd_sc_hd__fill_1
XANTENNA_clkbuf_3_1__f_clk_X clkbuf_leaf_9_clk/A VGND VGND VPWR VPWR sky130_fd_sc_hd__diode_2
XANTENNA__2661__B2 _3092_/A VGND VGND VPWR VPWR sky130_fd_sc_hd__diode_2
XFILLER_60_454 VPWR VGND VPWR VGND sky130_ef_sc_hd__decap_40_12
XANTENNA__4938__A0 _4978_/A1 VGND VGND VPWR VPWR sky130_fd_sc_hd__diode_2
X_3740_ hold339/X _5232_/A0 _3745_/S VGND VGND VPWR VPWR _3740_/X sky130_fd_sc_hd__mux2_1
XFILLER_20_307 VGND VGND VPWR VPWR sky130_fd_sc_hd__fill_1
Xclkbuf_leaf_106_clk clkload0/A VGND VGND VPWR VPWR _6313_/CLK sky130_fd_sc_hd__clkbuf_8
XANTENNA__4262__S _4262_/S VGND VGND VPWR VPWR sky130_fd_sc_hd__diode_2
XFILLER_119_729 VPWR VGND VPWR VGND sky130_ef_sc_hd__decap_40_12
XTAP_TAPCELL_ROW_99_1779 VGND VPWR sky130_fd_sc_hd__tapvpwrvgnd_1
X_3671_ _5209_/A1 _3671_/A1 _3678_/S VGND VGND VPWR VPWR _3671_/X sky130_fd_sc_hd__mux2_1
XFILLER_9_363 VPWR VGND VPWR VGND sky130_ef_sc_hd__decap_40_12
X_5410_ _6435_/CLK _5410_/D VGND VGND VPWR VPWR _5410_/Q sky130_fd_sc_hd__dfxtp_1
X_2622_ _3952_/B VGND VGND VPWR VPWR _2622_/Y sky130_fd_sc_hd__inv_2
X_6390_ _6405_/CLK _6390_/D VGND VGND VPWR VPWR _6390_/Q sky130_fd_sc_hd__dfxtp_1
XFILLER_99_101 VGND VGND VPWR VPWR sky130_fd_sc_hd__fill_1
XANTENNA__3374__C1 _3801_/B VGND VGND VPWR VPWR sky130_fd_sc_hd__diode_2
XANTENNA_clkbuf_leaf_71_clk_A clkload2/A VGND VGND VPWR VPWR sky130_fd_sc_hd__diode_2
XANTENNA__3913__A1 _5211_/A1 VGND VGND VPWR VPWR sky130_fd_sc_hd__diode_2
X_5341_ _6313_/CLK _5341_/D VGND VGND VPWR VPWR _5341_/Q sky130_fd_sc_hd__dfxtp_1
XFILLER_126_283 VGND VGND VPWR VPWR sky130_fd_sc_hd__fill_1
XFILLER_114_456 VGND VGND VPWR VPWR sky130_fd_sc_hd__fill_2
XFILLER_99_167 VGND VGND VPWR VPWR sky130_fd_sc_hd__fill_1
X_5272_ _6399_/CLK _5272_/D VGND VGND VPWR VPWR _5272_/Q sky130_fd_sc_hd__dfxtp_1
XTAP_TAPCELL_ROW_110_1957 VGND VPWR sky130_fd_sc_hd__tapvpwrvgnd_1
XTAP_TAPCELL_ROW_110_1946 VGND VPWR sky130_fd_sc_hd__tapvpwrvgnd_1
XFILLER_101_117 VGND VGND VPWR VPWR sky130_fd_sc_hd__fill_1
XFILLER_96_841 VGND VGND VPWR VPWR sky130_fd_sc_hd__fill_1
X_4223_ _6043_/Q _6351_/Q _4228_/S VGND VGND VPWR VPWR _4223_/X sky130_fd_sc_hd__mux2_1
XANTENNA__3677__A0 _4521_/A1 VGND VGND VPWR VPWR sky130_fd_sc_hd__diode_2
XFILLER_68_543 VGND VGND VPWR VPWR sky130_fd_sc_hd__fill_1
XTAP_TAPCELL_ROW_52_1075 VGND VPWR sky130_fd_sc_hd__tapvpwrvgnd_1
X_4154_ _4149_/X _4153_/X _4272_/S VGND VGND VPWR VPWR _4154_/Y sky130_fd_sc_hd__o21ai_1
X_3105_ hold514/X _4899_/A0 _3112_/S VGND VGND VPWR VPWR _3105_/X sky130_fd_sc_hd__mux2_1
XFILLER_68_587 VGND VGND VPWR VPWR sky130_fd_sc_hd__fill_1
XTAP_TAPCELL_ROW_52_1086 VGND VPWR sky130_fd_sc_hd__tapvpwrvgnd_1
X_4085_ _5771_/Q _6029_/Q _4258_/S VGND VGND VPWR VPWR _4085_/X sky130_fd_sc_hd__mux2_1
X_3036_ _3036_/A1 _3035_/X _3094_/C1 VGND VGND VPWR VPWR _3036_/Y sky130_fd_sc_hd__o21ai_1
XFILLER_71_708 VGND VGND VPWR VPWR sky130_fd_sc_hd__fill_1
XFILLER_102_15 VPWR VGND VPWR VGND sky130_ef_sc_hd__decap_40_12
XFILLER_64_793 VPWR VGND VPWR VGND sky130_ef_sc_hd__decap_40_12
XFILLER_24_635 VGND VGND VPWR VPWR sky130_fd_sc_hd__fill_1
XFILLER_51_465 VGND VGND VPWR VPWR sky130_fd_sc_hd__fill_4
XANTENNA_clkbuf_leaf_24_clk_A clkload3/A VGND VGND VPWR VPWR sky130_fd_sc_hd__diode_2
XFILLER_51_487 VGND VGND VPWR VPWR sky130_fd_sc_hd__fill_1
X_4987_ hold578/X _5053_/A1 _4993_/S VGND VGND VPWR VPWR _4987_/X sky130_fd_sc_hd__mux2_1
XFILLER_23_167 VGND VGND VPWR VPWR sky130_fd_sc_hd__fill_1
X_3938_ _4984_/A1 _3938_/A1 _3938_/S VGND VGND VPWR VPWR _3938_/X sky130_fd_sc_hd__mux2_1
XFILLER_20_841 VGND VGND VPWR VPWR sky130_fd_sc_hd__fill_1
X_3869_ _4964_/A0 _3869_/A1 _3869_/S VGND VGND VPWR VPWR _3869_/X sky130_fd_sc_hd__mux2_1
XFILLER_137_559 VGND VGND VPWR VPWR sky130_fd_sc_hd__fill_1
XANTENNA__4900__S _4906_/S VGND VGND VPWR VPWR sky130_fd_sc_hd__diode_2
X_5608_ _6095_/CLK _5608_/D VGND VGND VPWR VPWR _5608_/Q sky130_fd_sc_hd__dfxtp_1
X_5539_ _6437_/CLK _5539_/D VGND VGND VPWR VPWR _5539_/Q sky130_fd_sc_hd__dfxtp_1
XANTENNA_clkbuf_leaf_39_clk_A clkload4/A VGND VGND VPWR VPWR sky130_fd_sc_hd__diode_2
XFILLER_3_517 VPWR VGND VPWR VGND sky130_ef_sc_hd__decap_40_12
XANTENNA__3904__A1 _5212_/A1 VGND VGND VPWR VPWR sky130_fd_sc_hd__diode_2
XFILLER_133_721 VGND VGND VPWR VPWR sky130_fd_sc_hd__fill_4
XANTENNA__3516__S _3516_/S VGND VGND VPWR VPWR sky130_fd_sc_hd__diode_2
XANTENNA__3380__A2 _4994_/B VGND VGND VPWR VPWR sky130_fd_sc_hd__diode_2
XFILLER_133_765 VPWR VGND VPWR VGND sky130_ef_sc_hd__decap_40_12
XFILLER_87_841 VGND VGND VPWR VPWR sky130_fd_sc_hd__fill_1
XFILLER_59_543 VGND VGND VPWR VPWR sky130_fd_sc_hd__fill_1
XANTENNA_fanout70_A _2635_/Y VGND VGND VPWR VPWR sky130_fd_sc_hd__diode_2
XFILLER_101_673 VPWR VGND VPWR VGND sky130_ef_sc_hd__decap_40_12
XFILLER_100_161 VGND VGND VPWR VPWR sky130_fd_sc_hd__fill_1
XFILLER_86_362 VGND VGND VPWR VPWR sky130_fd_sc_hd__fill_2
XTAP_TAPCELL_ROW_6_388 VGND VPWR sky130_fd_sc_hd__tapvpwrvgnd_1
XFILLER_19_429 VPWR VGND VPWR VGND sky130_ef_sc_hd__decap_40_12
XFILLER_15_613 VGND VGND VPWR VPWR sky130_fd_sc_hd__fill_2
XTAP_TAPCELL_ROW_83_1547 VGND VPWR sky130_fd_sc_hd__tapvpwrvgnd_1
XFILLER_14_167 VGND VGND VPWR VPWR sky130_fd_sc_hd__fill_1
XFILLER_14_189 VGND VGND VPWR VPWR sky130_fd_sc_hd__fill_4
XTAP_TAPCELL_ROW_25_674 VGND VPWR sky130_fd_sc_hd__tapvpwrvgnd_1
XFILLER_11_841 VGND VGND VPWR VPWR sky130_fd_sc_hd__fill_1
XFILLER_128_515 VPWR VGND VPWR VGND sky130_ef_sc_hd__decap_40_12
Xinput28 s_axil_wstrb[0] VGND VGND VPWR VPWR _3730_/A sky130_fd_sc_hd__buf_1
Xinput17 s_axil_wdata[14] VGND VGND VPWR VPWR _4920_/A sky130_fd_sc_hd__clkbuf_1
XFILLER_10_340 VGND VGND VPWR VPWR sky130_fd_sc_hd__fill_1
XTAP_TAPCELL_ROW_114_2013 VGND VPWR sky130_fd_sc_hd__tapvpwrvgnd_1
XANTENNA__4810__S _4810_/S VGND VGND VPWR VPWR sky130_fd_sc_hd__diode_2
XFILLER_6_377 VPWR VGND VPWR VGND sky130_ef_sc_hd__decap_40_12
XFILLER_136_581 VGND VGND VPWR VPWR sky130_fd_sc_hd__fill_4
XANTENNA__3426__S _3437_/S VGND VGND VPWR VPWR sky130_fd_sc_hd__diode_2
XANTENNA__3371__A2 _4457_/S VGND VGND VPWR VPWR sky130_fd_sc_hd__diode_2
XANTENNA__4111__A _4241_/A VGND VGND VPWR VPWR sky130_fd_sc_hd__diode_2
XANTENNA__3659__A0 _6410_/Q VGND VGND VPWR VPWR sky130_fd_sc_hd__diode_2
XFILLER_78_841 VGND VGND VPWR VPWR sky130_fd_sc_hd__fill_1
XANTENNA__4320__A1 _4929_/A1 VGND VGND VPWR VPWR sky130_fd_sc_hd__diode_2
XFILLER_93_833 VGND VGND VPWR VPWR sky130_fd_sc_hd__fill_4
XANTENNA__4257__S _4257_/S VGND VGND VPWR VPWR sky130_fd_sc_hd__diode_2
XTAP_TAPCELL_ROW_125_2175 VGND VPWR sky130_fd_sc_hd__tapvpwrvgnd_1
XFILLER_92_376 VGND VGND VPWR VPWR sky130_fd_sc_hd__fill_2
XFILLER_92_365 VGND VGND VPWR VPWR sky130_fd_sc_hd__fill_4
XFILLER_92_387 VGND VGND VPWR VPWR sky130_fd_sc_hd__fill_4
X_4910_ _4910_/A _4922_/B _4922_/C VGND VGND VPWR VPWR _4910_/X sky130_fd_sc_hd__or3_1
XFILLER_18_473 VGND VGND VPWR VPWR sky130_fd_sc_hd__fill_2
X_5890_ _6414_/CLK _5890_/D VGND VGND VPWR VPWR _5890_/Q sky130_fd_sc_hd__dfxtp_1
X_4841_ _4906_/A0 _4841_/A1 _4841_/S VGND VGND VPWR VPWR _4841_/X sky130_fd_sc_hd__mux2_1
XFILLER_61_785 VPWR VGND VPWR VGND sky130_ef_sc_hd__decap_40_12
XFILLER_60_273 VGND VGND VPWR VPWR sky130_fd_sc_hd__fill_1
XTAP_TAPCELL_ROW_44_961 VGND VPWR sky130_fd_sc_hd__tapvpwrvgnd_1
X_4772_ _5475_/Q _5646_/Q _5637_/Q _5727_/Q _4773_/S _4789_/A VGND VGND VPWR VPWR
+ _4772_/X sky130_fd_sc_hd__mux4_1
XFILLER_119_537 VPWR VGND VPWR VGND sky130_ef_sc_hd__decap_40_12
X_3723_ _4107_/A1 _4929_/A1 _3728_/S VGND VGND VPWR VPWR _3723_/X sky130_fd_sc_hd__mux2_1
XFILLER_119_559 VGND VGND VPWR VPWR sky130_fd_sc_hd__fill_1
XANTENNA__4139__A1 _4149_/A VGND VGND VPWR VPWR sky130_fd_sc_hd__diode_2
X_3654_ hold67/X _5213_/A1 _3657_/S VGND VGND VPWR VPWR hold68/A sky130_fd_sc_hd__mux2_1
XFILLER_134_529 VGND VGND VPWR VPWR sky130_fd_sc_hd__fill_2
XANTENNA__4234__S1 _4251_/A VGND VGND VPWR VPWR sky130_fd_sc_hd__diode_2
XFILLER_115_721 VGND VGND VPWR VPWR sky130_fd_sc_hd__fill_4
X_3585_ _3585_/A _5384_/Q _3617_/C VGND VGND VPWR VPWR _3880_/B sky130_fd_sc_hd__or3_4
X_6373_ _6421_/CLK _6373_/D VGND VGND VPWR VPWR _6373_/Q sky130_fd_sc_hd__dfxtp_1
XFILLER_115_765 VPWR VGND VPWR VGND sky130_ef_sc_hd__decap_40_12
XFILLER_114_253 VGND VGND VPWR VPWR sky130_fd_sc_hd__fill_1
XANTENNA__2796__S1 _2962_/A VGND VGND VPWR VPWR sky130_fd_sc_hd__diode_2
XANTENNA__4021__A _4212_/A VGND VGND VPWR VPWR sky130_fd_sc_hd__diode_2
XTAP_TAPCELL_ROW_54_1115 VGND VPWR sky130_fd_sc_hd__tapvpwrvgnd_1
XTAP_TAPCELL_ROW_54_1104 VGND VPWR sky130_fd_sc_hd__tapvpwrvgnd_1
X_5324_ clkload8/A _5324_/D VGND VGND VPWR VPWR _5324_/Q sky130_fd_sc_hd__dfxtp_2
XANTENNA__3362__A2 _5035_/C VGND VGND VPWR VPWR sky130_fd_sc_hd__diode_2
XFILLER_130_713 VPWR VGND VPWR VGND sky130_ef_sc_hd__decap_40_12
X_5255_ _6199_/CLK _5255_/D VGND VGND VPWR VPWR _5255_/Q sky130_fd_sc_hd__dfxtp_1
XFILLER_130_757 VPWR VGND VPWR VGND sky130_ef_sc_hd__decap_40_12
XFILLER_87_159 VGND VGND VPWR VPWR sky130_fd_sc_hd__fill_1
XFILLER_69_841 VGND VGND VPWR VPWR sky130_fd_sc_hd__fill_1
XANTENNA__4311__A1 _5043_/A1 VGND VGND VPWR VPWR sky130_fd_sc_hd__diode_2
X_4206_ hold18/A _5979_/Q _4228_/S VGND VGND VPWR VPWR _4207_/B sky130_fd_sc_hd__mux2_1
X_5186_ _3958_/A _5185_/X _5175_/S _3953_/Y VGND VGND VPWR VPWR _5186_/Y sky130_fd_sc_hd__o211ai_1
XANTENNA__2873__A1 _3031_/A1 VGND VGND VPWR VPWR sky130_fd_sc_hd__diode_2
XFILLER_96_693 VGND VGND VPWR VPWR sky130_fd_sc_hd__fill_4
XTAP_TAPCELL_ROW_3_347 VGND VPWR sky130_fd_sc_hd__tapvpwrvgnd_1
X_4137_ _4137_/A0 _4137_/A1 _4250_/S VGND VGND VPWR VPWR _4137_/X sky130_fd_sc_hd__mux2_1
XFILLER_113_47 VGND VGND VPWR VPWR sky130_fd_sc_hd__fill_1
XFILLER_56_568 VGND VGND VPWR VPWR sky130_fd_sc_hd__fill_1
X_4068_ _4063_/X _4067_/X _4272_/S VGND VGND VPWR VPWR _4068_/Y sky130_fd_sc_hd__o21ai_1
X_3019_ _5546_/Q _5570_/Q _3077_/S VGND VGND VPWR VPWR _3020_/B sky130_fd_sc_hd__mux2_1
XFILLER_83_387 VGND VGND VPWR VPWR sky130_fd_sc_hd__fill_1
XFILLER_73_29 VGND VGND VPWR VPWR sky130_fd_sc_hd__fill_4
XANTENNA__4170__S0 _4228_/S VGND VGND VPWR VPWR sky130_fd_sc_hd__diode_2
XFILLER_43_229 VGND VGND VPWR VPWR sky130_fd_sc_hd__fill_2
XFILLER_24_421 VPWR VGND VPWR VGND sky130_ef_sc_hd__decap_40_12
XANTENNA_fanout160_X _4251_/A VGND VGND VPWR VPWR sky130_fd_sc_hd__diode_2
XTAP_TAPCELL_ROW_65_1277 VGND VPWR sky130_fd_sc_hd__tapvpwrvgnd_1
XANTENNA__4378__A1 _5051_/A1 VGND VGND VPWR VPWR sky130_fd_sc_hd__diode_2
XANTENNA__3100__A _4881_/A VGND VGND VPWR VPWR sky130_fd_sc_hd__diode_2
XTAP_TAPCELL_ROW_22_633 VGND VPWR sky130_fd_sc_hd__tapvpwrvgnd_1
XFILLER_138_813 VPWR VGND VPWR VGND sky130_ef_sc_hd__decap_40_12
XFILLER_20_693 VGND VGND VPWR VPWR sky130_fd_sc_hd__fill_4
XFILLER_138_55 VGND VGND VPWR VPWR sky130_fd_sc_hd__fill_1
XFILLER_137_367 VGND VGND VPWR VPWR sky130_fd_sc_hd__fill_1
XFILLER_125_529 VPWR VGND VPWR VGND sky130_ef_sc_hd__decap_40_12
XFILLER_98_15 VPWR VGND VPWR VGND sky130_ef_sc_hd__decap_40_12
XFILLER_118_581 VGND VGND VPWR VPWR sky130_fd_sc_hd__fill_4
XFILLER_4_837 VGND VGND VPWR VPWR sky130_fd_sc_hd__fill_4
XANTENNA__4550__A1 _4882_/A1 VGND VGND VPWR VPWR sky130_fd_sc_hd__diode_2
XFILLER_133_573 VPWR VGND VPWR VGND sky130_ef_sc_hd__decap_40_12
XANTENNA__4302__A1 _5045_/A1 VGND VGND VPWR VPWR sky130_fd_sc_hd__diode_2
Xfanout183 _3044_/A VGND VGND VPWR VPWR _2985_/A sky130_fd_sc_hd__buf_4
XFILLER_59_351 VGND VGND VPWR VPWR sky130_fd_sc_hd__fill_2
XANTENNA_fanout73_X _4791_/A1 VGND VGND VPWR VPWR sky130_fd_sc_hd__diode_2
Xfanout150 _4713_/S VGND VGND VPWR VPWR _4773_/S sky130_fd_sc_hd__clkbuf_8
Xfanout172 _4221_/S VGND VGND VPWR VPWR _4270_/S sky130_fd_sc_hd__clkbuf_4
Xfanout161 _4178_/A VGND VGND VPWR VPWR _4241_/A sky130_fd_sc_hd__buf_4
Xfanout194 _5266_/Q VGND VGND VPWR VPWR _3016_/S sky130_fd_sc_hd__buf_4
XFILLER_75_833 VGND VGND VPWR VPWR sky130_fd_sc_hd__fill_4
XFILLER_90_825 VPWR VGND VPWR VGND sky130_ef_sc_hd__decap_40_12
XFILLER_74_365 VPWR VGND VPWR VGND sky130_ef_sc_hd__decap_40_12
XFILLER_74_343 VGND VGND VPWR VPWR sky130_fd_sc_hd__fill_1
XFILLER_35_719 VGND VGND VPWR VPWR sky130_fd_sc_hd__fill_1
XFILLER_28_793 VPWR VGND VPWR VGND sky130_ef_sc_hd__decap_40_12
XFILLER_70_560 VGND VGND VPWR VPWR sky130_fd_sc_hd__fill_1
XFILLER_43_785 VPWR VGND VPWR VGND sky130_ef_sc_hd__decap_40_12
XTAP_TAPCELL_ROW_120_2094 VGND VPWR sky130_fd_sc_hd__tapvpwrvgnd_1
XANTENNA__4106__A _4251_/A VGND VGND VPWR VPWR sky130_fd_sc_hd__diode_2
XTAP_TAPCELL_ROW_41_920 VGND VPWR sky130_fd_sc_hd__tapvpwrvgnd_1
XFILLER_30_457 VGND VGND VPWR VPWR sky130_fd_sc_hd__fill_1
XANTENNA__4540__S _4547_/S VGND VGND VPWR VPWR sky130_fd_sc_hd__diode_2
XFILLER_11_671 VGND VGND VPWR VPWR sky130_fd_sc_hd__fill_1
XFILLER_116_529 VGND VGND VPWR VPWR sky130_fd_sc_hd__fill_2
XTAP_TAPCELL_ROW_96_1738 VGND VPWR sky130_fd_sc_hd__tapvpwrvgnd_1
XFILLER_7_653 VPWR VGND VPWR VGND sky130_ef_sc_hd__decap_40_12
Xhold609 _3639_/X VGND VGND VPWR VPWR _5666_/D sky130_fd_sc_hd__dlygate4sd3_1
XFILLER_7_697 VPWR VGND VPWR VGND sky130_ef_sc_hd__decap_40_12
XANTENNA__4541__A1 _5075_/A0 VGND VGND VPWR VPWR sky130_fd_sc_hd__diode_2
XANTENNA__2778__S1 _3005_/A VGND VGND VPWR VPWR sky130_fd_sc_hd__diode_2
X_3370_ _5840_/Q _3366_/X _4994_/B _6381_/Q _3801_/B VGND VGND VPWR VPWR _3370_/X
+ sky130_fd_sc_hd__a221o_2
XFILLER_112_713 VPWR VGND VPWR VGND sky130_ef_sc_hd__decap_40_12
XTAP_TAPCELL_ROW_127_2204 VGND VPWR sky130_fd_sc_hd__tapvpwrvgnd_1
XFILLER_112_757 VPWR VGND VPWR VGND sky130_ef_sc_hd__decap_40_12
XFILLER_69_159 VGND VGND VPWR VPWR sky130_fd_sc_hd__fill_1
X_5040_ hold355/X _5040_/A1 _5047_/S VGND VGND VPWR VPWR _5040_/X sky130_fd_sc_hd__mux2_1
Xhold1309 _5690_/Q VGND VGND VPWR VPWR _3665_/A1 sky130_fd_sc_hd__dlygate4sd3_1
XFILLER_84_118 VGND VGND VPWR VPWR sky130_fd_sc_hd__fill_2
XFILLER_66_811 VGND VGND VPWR VPWR sky130_fd_sc_hd__fill_1
XFILLER_26_3 VPWR VGND VPWR VGND sky130_ef_sc_hd__decap_40_12
XPHY_EDGE_ROW_108_Left_247 VGND VGND VPWR VPWR sky130_fd_sc_hd__decap_3
XFILLER_93_641 VPWR VGND VPWR VGND sky130_ef_sc_hd__decap_40_12
XANTENNA__2950__S1 _3005_/A VGND VGND VPWR VPWR sky130_fd_sc_hd__diode_2
XTAP_TAPCELL_ROW_0_306 VGND VPWR sky130_fd_sc_hd__tapvpwrvgnd_1
XANTENNA__4057__B1 _3172_/B VGND VGND VPWR VPWR sky130_fd_sc_hd__diode_2
XFILLER_93_685 VPWR VGND VPWR VGND sky130_ef_sc_hd__decap_40_12
X_5942_ _6313_/CLK _5942_/D VGND VGND VPWR VPWR _5942_/Q sky130_fd_sc_hd__dfxtp_1
XFILLER_80_346 VGND VGND VPWR VPWR sky130_fd_sc_hd__fill_1
XTAP_TAPCELL_ROW_105_1878 VGND VPWR sky130_fd_sc_hd__tapvpwrvgnd_1
X_5873_ _6098_/CLK _5873_/D VGND VGND VPWR VPWR _5873_/Q sky130_fd_sc_hd__dfxtp_1
XANTENNA__3280__A1 _3278_/A VGND VGND VPWR VPWR sky130_fd_sc_hd__diode_2
X_4824_ _4889_/A1 _4824_/A1 _4828_/S VGND VGND VPWR VPWR _4824_/X sky130_fd_sc_hd__mux2_1
XFILLER_61_582 VGND VGND VPWR VPWR sky130_fd_sc_hd__fill_1
XTAP_TAPCELL_ROW_138_2366 VGND VPWR sky130_fd_sc_hd__tapvpwrvgnd_1
XPHY_EDGE_ROW_117_Left_256 VGND VGND VPWR VPWR sky130_fd_sc_hd__decap_3
X_4755_ _4663_/A _4750_/X _4754_/X VGND VGND VPWR VPWR _4755_/Y sky130_fd_sc_hd__a21oi_1
XTAP_TAPCELL_ROW_138_2388 VGND VPWR sky130_fd_sc_hd__tapvpwrvgnd_1
XTAP_TAPCELL_ROW_138_2377 VGND VPWR sky130_fd_sc_hd__tapvpwrvgnd_1
XANTENNA__4450__S _4457_/S VGND VGND VPWR VPWR sky130_fd_sc_hd__diode_2
XANTENNA_fanout120_A _4899_/A0 VGND VGND VPWR VPWR sky130_fd_sc_hd__diode_2
X_3706_ _5215_/A1 _3706_/A1 _3707_/S VGND VGND VPWR VPWR _3706_/X sky130_fd_sc_hd__mux2_1
X_4686_ _5847_/Q _5625_/Q _4778_/S VGND VGND VPWR VPWR _4686_/X sky130_fd_sc_hd__mux2_1
XTAP_TAPCELL_ROW_60_1196 VGND VPWR sky130_fd_sc_hd__tapvpwrvgnd_1
X_6425_ _6432_/CLK _6425_/D VGND VGND VPWR VPWR _6425_/Q sky130_fd_sc_hd__dfxtp_1
XANTENNA__5129__A1_N _3958_/A VGND VGND VPWR VPWR sky130_fd_sc_hd__diode_2
X_3637_ hold113/X _5202_/A1 _3637_/S VGND VGND VPWR VPWR _3637_/X sky130_fd_sc_hd__mux2_1
XANTENNA__4532__A1 _5234_/A0 VGND VGND VPWR VPWR sky130_fd_sc_hd__diode_2
X_6356_ _6380_/CLK _6356_/D VGND VGND VPWR VPWR _6356_/Q sky130_fd_sc_hd__dfxtp_1
X_3568_ _3568_/A0 _4958_/A0 _3574_/S VGND VGND VPWR VPWR _3568_/X sky130_fd_sc_hd__mux2_1
XTAP_TAPCELL_ROW_8_417 VGND VPWR sky130_fd_sc_hd__tapvpwrvgnd_1
XFILLER_115_573 VPWR VGND VPWR VGND sky130_ef_sc_hd__decap_40_12
X_5307_ _6369_/CLK hold92/X VGND VGND VPWR VPWR hold91/A sky130_fd_sc_hd__dfxtp_1
XFILLER_102_201 VGND VGND VPWR VPWR sky130_fd_sc_hd__fill_2
XFILLER_68_29 VGND VGND VPWR VPWR sky130_fd_sc_hd__fill_8
X_3499_ _4889_/A1 hold616/X _3503_/S VGND VGND VPWR VPWR _3499_/X sky130_fd_sc_hd__mux2_1
X_6287_ _6312_/CLK _6287_/D VGND VGND VPWR VPWR _6287_/Q sky130_fd_sc_hd__dfxtp_1
XFILLER_130_587 VGND VGND VPWR VPWR sky130_fd_sc_hd__fill_1
XPHY_EDGE_ROW_126_Left_265 VGND VGND VPWR VPWR sky130_fd_sc_hd__decap_3
X_5238_ _5238_/A0 _5238_/A1 _5241_/S VGND VGND VPWR VPWR _5238_/X sky130_fd_sc_hd__mux2_1
XFILLER_75_118 VGND VGND VPWR VPWR sky130_fd_sc_hd__fill_1
Xhold1810 _3752_/X VGND VGND VPWR VPWR _5765_/D sky130_fd_sc_hd__dlygate4sd3_1
XANTENNA__2846__A1 _3094_/C1 VGND VGND VPWR VPWR sky130_fd_sc_hd__diode_2
X_5169_ _3958_/A _5168_/X _5167_/Y _5173_/B VGND VGND VPWR VPWR _5170_/B sky130_fd_sc_hd__a2bb2o_1
Xhold1843 _3152_/X VGND VGND VPWR VPWR _5333_/D sky130_fd_sc_hd__dlygate4sd3_1
Xhold1821 _3875_/X VGND VGND VPWR VPWR _5856_/D sky130_fd_sc_hd__dlygate4sd3_1
XFILLER_57_833 VGND VGND VPWR VPWR sky130_fd_sc_hd__fill_4
Xclkbuf_leaf_95_clk clkbuf_leaf_9_clk/A VGND VGND VPWR VPWR _6408_/CLK sky130_fd_sc_hd__clkbuf_8
Xhold1832 _5761_/Q VGND VGND VPWR VPWR _4051_/A0 sky130_fd_sc_hd__dlygate4sd3_1
Xhold1854 _5455_/Q VGND VGND VPWR VPWR _3398_/A0 sky130_fd_sc_hd__dlygate4sd3_1
Xi2c_master_axil_210 VGND VGND VPWR VPWR i2c_master_axil_210/HI s_axil_rdata[16] sky130_fd_sc_hd__conb_1
Xhold1876 _3516_/X VGND VGND VPWR VPWR _5560_/D sky130_fd_sc_hd__dlygate4sd3_1
Xhold1865 _6213_/Q VGND VGND VPWR VPWR _4862_/A1 sky130_fd_sc_hd__dlygate4sd3_1
XTAP_TAPCELL_ROW_67_1306 VGND VPWR sky130_fd_sc_hd__tapvpwrvgnd_1
XFILLER_56_365 VGND VGND VPWR VPWR sky130_fd_sc_hd__fill_4
XFILLER_56_354 VGND VGND VPWR VPWR sky130_fd_sc_hd__fill_8
Xhold1887 _6014_/Q VGND VGND VPWR VPWR _4373_/A1 sky130_fd_sc_hd__dlygate4sd3_1
Xhold1898 _6374_/Q VGND VGND VPWR VPWR _5086_/A0 sky130_fd_sc_hd__dlygate4sd3_1
Xi2c_master_axil_221 VGND VGND VPWR VPWR i2c_master_axil_221/HI s_axil_rdata[27] sky130_fd_sc_hd__conb_1
XFILLER_17_55 VGND VGND VPWR VPWR sky130_fd_sc_hd__fill_1
XTAP_TAPCELL_ROW_27_703 VGND VPWR sky130_fd_sc_hd__tapvpwrvgnd_1
XFILLER_71_335 VGND VGND VPWR VPWR sky130_fd_sc_hd__fill_1
XTAP_TAPCELL_ROW_80_1506 VGND VPWR sky130_fd_sc_hd__tapvpwrvgnd_1
XANTENNA__3271__A1 _4600_/A VGND VGND VPWR VPWR sky130_fd_sc_hd__diode_2
XFILLER_24_251 VGND VGND VPWR VPWR sky130_fd_sc_hd__fill_1
XFILLER_25_785 VPWR VGND VPWR VGND sky130_ef_sc_hd__decap_40_12
XANTENNA__4694__S1 _4663_/A VGND VGND VPWR VPWR sky130_fd_sc_hd__diode_2
XPHY_EDGE_ROW_135_Left_274 VGND VGND VPWR VPWR sky130_fd_sc_hd__decap_3
XFILLER_12_413 VGND VGND VPWR VPWR sky130_fd_sc_hd__fill_4
XFILLER_40_744 VGND VGND VPWR VPWR sky130_fd_sc_hd__fill_2
XFILLER_40_755 VGND VGND VPWR VPWR sky130_fd_sc_hd__fill_1
XFILLER_138_621 VGND VGND VPWR VPWR sky130_fd_sc_hd__fill_2
XFILLER_130_3 VPWR VGND VPWR VGND sky130_ef_sc_hd__decap_40_12
XFILLER_8_417 VGND VGND VPWR VPWR sky130_fd_sc_hd__fill_2
XFILLER_12_457 VPWR VGND VPWR VGND sky130_ef_sc_hd__decap_40_12
XFILLER_40_777 VPWR VGND VPWR VGND sky130_ef_sc_hd__decap_40_12
XFILLER_138_643 VGND VGND VPWR VPWR sky130_fd_sc_hd__fill_1
XFILLER_126_805 VGND VGND VPWR VPWR sky130_fd_sc_hd__fill_4
XFILLER_4_601 VPWR VGND VPWR VGND sky130_ef_sc_hd__decap_40_12
XFILLER_125_337 VGND VGND VPWR VPWR sky130_fd_sc_hd__fill_2
XTAP_TAPCELL_ROW_78_1468 VGND VPWR sky130_fd_sc_hd__tapvpwrvgnd_1
XFILLER_4_645 VPWR VGND VPWR VGND sky130_ef_sc_hd__decap_40_12
XTAP_TAPCELL_ROW_91_1668 VGND VPWR sky130_fd_sc_hd__tapvpwrvgnd_1
XANTENNA__3704__S _3707_/S VGND VGND VPWR VPWR sky130_fd_sc_hd__diode_2
XFILLER_79_479 VGND VGND VPWR VPWR sky130_fd_sc_hd__fill_2
XFILLER_67_619 VGND VGND VPWR VPWR sky130_fd_sc_hd__fill_1
XFILLER_48_811 VGND VGND VPWR VPWR sky130_fd_sc_hd__fill_1
XFILLER_87_490 VGND VGND VPWR VPWR sky130_fd_sc_hd__fill_4
Xhold6 hold6/A VGND VGND VPWR VPWR hold6/X sky130_fd_sc_hd__dlygate4sd3_1
XANTENNA__3005__A _3005_/A VGND VGND VPWR VPWR sky130_fd_sc_hd__diode_2
XFILLER_35_505 VGND VGND VPWR VPWR sky130_fd_sc_hd__fill_1
XTAP_TAPCELL_ROW_122_2134 VGND VPWR sky130_fd_sc_hd__tapvpwrvgnd_1
XTAP_TAPCELL_ROW_122_2123 VGND VPWR sky130_fd_sc_hd__tapvpwrvgnd_1
XANTENNA__4535__S _4535_/S VGND VGND VPWR VPWR sky130_fd_sc_hd__diode_2
XFILLER_74_151 VGND VGND VPWR VPWR sky130_fd_sc_hd__fill_1
XFILLER_35_538 VGND VGND VPWR VPWR sky130_fd_sc_hd__fill_8
XFILLER_90_699 VGND VGND VPWR VPWR sky130_fd_sc_hd__fill_1
X_2870_ _6073_/Q _6365_/Q _3072_/S VGND VGND VPWR VPWR _2871_/B sky130_fd_sc_hd__mux2_1
XFILLER_30_221 VGND VGND VPWR VPWR sky130_fd_sc_hd__fill_1
XFILLER_88_5 VPWR VGND VPWR VGND sky130_ef_sc_hd__decap_40_12
XFILLER_90_93 VGND VGND VPWR VPWR sky130_fd_sc_hd__fill_8
X_4540_ hold127/X _4899_/A0 _4547_/S VGND VGND VPWR VPWR _4540_/X sky130_fd_sc_hd__mux2_1
XFILLER_129_665 VGND VGND VPWR VPWR sky130_fd_sc_hd__fill_4
XTAP_TAPCELL_ROW_100_1797 VGND VPWR sky130_fd_sc_hd__tapvpwrvgnd_1
Xclkbuf_leaf_10_clk clkbuf_leaf_9_clk/A VGND VGND VPWR VPWR _6403_/CLK sky130_fd_sc_hd__clkbuf_8
XTAP_TAPCELL_ROW_13_496 VGND VPWR sky130_fd_sc_hd__tapvpwrvgnd_1
XANTENNA__4762__A1 _2629_/Y VGND VGND VPWR VPWR sky130_fd_sc_hd__diode_2
X_4471_ _5080_/A0 _4471_/A1 _4472_/S VGND VGND VPWR VPWR _4471_/X sky130_fd_sc_hd__mux2_1
Xhold417 _6242_/Q VGND VGND VPWR VPWR hold417/X sky130_fd_sc_hd__dlygate4sd3_1
Xhold406 _3735_/X VGND VGND VPWR VPWR _5749_/D sky130_fd_sc_hd__dlygate4sd3_1
XANTENNA__2773__B1 _2995_/A VGND VGND VPWR VPWR sky130_fd_sc_hd__diode_2
XFILLER_7_461 VPWR VGND VPWR VGND sky130_ef_sc_hd__decap_40_12
XTAP_TAPCELL_ROW_133_2296 VGND VPWR sky130_fd_sc_hd__tapvpwrvgnd_1
X_6210_ _6242_/CLK _6210_/D VGND VGND VPWR VPWR _6210_/Q sky130_fd_sc_hd__dfxtp_1
Xhold428 _3435_/X VGND VGND VPWR VPWR _5486_/D sky130_fd_sc_hd__dlygate4sd3_1
X_3422_ hold618/X _5215_/A1 _3423_/S VGND VGND VPWR VPWR _3422_/X sky130_fd_sc_hd__mux2_1
Xhold439 _5949_/Q VGND VGND VPWR VPWR hold439/X sky130_fd_sc_hd__dlygate4sd3_1
XANTENNA__4514__A1 _5208_/A1 VGND VGND VPWR VPWR sky130_fd_sc_hd__diode_2
X_6141_ _6143_/CLK _6141_/D VGND VGND VPWR VPWR _6141_/Q sky130_fd_sc_hd__dfxtp_1
XFILLER_98_755 VGND VGND VPWR VPWR sky130_fd_sc_hd__fill_1
X_3353_ _5215_/A0 _3352_/X _3365_/S VGND VGND VPWR VPWR _3353_/X sky130_fd_sc_hd__mux2_1
X_6072_ _6365_/CLK _6072_/D VGND VGND VPWR VPWR _6072_/Q sky130_fd_sc_hd__dfxtp_1
X_3284_ _3284_/A0 _5238_/A1 _3295_/S VGND VGND VPWR VPWR _3284_/X sky130_fd_sc_hd__mux2_1
Xhold1106 _5413_/Q VGND VGND VPWR VPWR _3294_/A0 sky130_fd_sc_hd__dlygate4sd3_1
XFILLER_112_587 VGND VGND VPWR VPWR sky130_fd_sc_hd__fill_1
Xhold1139 _3213_/X VGND VGND VPWR VPWR _5373_/D sky130_fd_sc_hd__dlygate4sd3_1
XFILLER_100_749 VGND VGND VPWR VPWR sky130_fd_sc_hd__fill_4
X_5023_ _6353_/Q _6354_/Q _6357_/Q _6358_/Q _6327_/Q _6329_/Q VGND VGND VPWR VPWR
+ _5023_/X sky130_fd_sc_hd__mux4_1
Xclkbuf_leaf_77_clk clkload2/A VGND VGND VPWR VPWR _6097_/CLK sky130_fd_sc_hd__clkbuf_8
Xhold1117 _4941_/X VGND VGND VPWR VPWR _6277_/D sky130_fd_sc_hd__dlygate4sd3_1
Xhold1128 _6110_/Q VGND VGND VPWR VPWR _4636_/A1 sky130_fd_sc_hd__dlygate4sd3_1
XFILLER_39_833 VGND VGND VPWR VPWR sky130_fd_sc_hd__fill_4
XTAP_TAPCELL_ROW_107_1907 VGND VPWR sky130_fd_sc_hd__tapvpwrvgnd_1
XFILLER_54_825 VPWR VGND VPWR VGND sky130_ef_sc_hd__decap_40_12
XFILLER_53_346 VGND VGND VPWR VPWR sky130_fd_sc_hd__fill_8
XTAP_TAPCELL_ROW_49_1036 VGND VPWR sky130_fd_sc_hd__tapvpwrvgnd_1
XFILLER_26_549 VGND VGND VPWR VPWR sky130_fd_sc_hd__fill_2
XANTENNA_fanout168_A _4221_/S VGND VGND VPWR VPWR sky130_fd_sc_hd__diode_2
XFILLER_110_15 VPWR VGND VPWR VGND sky130_ef_sc_hd__decap_40_12
XFILLER_81_699 VGND VGND VPWR VPWR sky130_fd_sc_hd__fill_1
XFILLER_34_560 VGND VGND VPWR VPWR sky130_fd_sc_hd__fill_2
X_5925_ _6421_/CLK _5925_/D VGND VGND VPWR VPWR _5925_/Q sky130_fd_sc_hd__dfxtp_1
X_5856_ _6060_/CLK _5856_/D VGND VGND VPWR VPWR _5856_/Q sky130_fd_sc_hd__dfxtp_1
XTAP_TAPCELL_ROW_62_1236 VGND VPWR sky130_fd_sc_hd__tapvpwrvgnd_1
XTAP_TAPCELL_ROW_62_1225 VGND VPWR sky130_fd_sc_hd__tapvpwrvgnd_1
X_4807_ _5683_/Q _5665_/Q _5656_/Q _5674_/Q _4810_/S _4809_/A VGND VGND VPWR VPWR
+ _4807_/X sky130_fd_sc_hd__mux4_1
XPHY_EDGE_ROW_3_Right_3 VGND VGND VPWR VPWR sky130_fd_sc_hd__decap_3
XFILLER_22_755 VGND VGND VPWR VPWR sky130_fd_sc_hd__fill_1
X_2999_ hold22/X _5557_/Q _3030_/S VGND VGND VPWR VPWR _3000_/B sky130_fd_sc_hd__mux2_1
XFILLER_21_276 VGND VGND VPWR VPWR sky130_fd_sc_hd__fill_1
XTAP_TAPCELL_ROW_32_783 VGND VPWR sky130_fd_sc_hd__tapvpwrvgnd_1
X_5787_ _6125_/CLK _5787_/D VGND VGND VPWR VPWR _5787_/Q sky130_fd_sc_hd__dfxtp_1
XFILLER_135_613 VGND VGND VPWR VPWR sky130_fd_sc_hd__fill_2
XFILLER_108_805 VGND VGND VPWR VPWR sky130_fd_sc_hd__fill_4
X_4738_ _5849_/Q _5627_/Q _4795_/S VGND VGND VPWR VPWR _4738_/X sky130_fd_sc_hd__mux2_1
XANTENNA_fanout123_X _4906_/A0 VGND VGND VPWR VPWR sky130_fd_sc_hd__diode_2
XFILLER_134_123 VGND VGND VPWR VPWR sky130_fd_sc_hd__fill_1
XFILLER_119_57 VGND VGND VPWR VPWR sky130_fd_sc_hd__fill_1
XFILLER_107_337 VGND VGND VPWR VPWR sky130_fd_sc_hd__fill_1
X_4669_ _5678_/Q _5660_/Q _4810_/S VGND VGND VPWR VPWR _4670_/B sky130_fd_sc_hd__mux2_1
Xhold940 _5302_/Q VGND VGND VPWR VPWR hold940/X sky130_fd_sc_hd__dlygate4sd3_1
X_6408_ _6408_/CLK _6408_/D VGND VGND VPWR VPWR _6408_/Q sky130_fd_sc_hd__dfxtp_2
XFILLER_122_307 VGND VGND VPWR VPWR sky130_fd_sc_hd__fill_1
Xhold962 _5619_/Q VGND VGND VPWR VPWR hold962/X sky130_fd_sc_hd__dlygate4sd3_1
Xhold973 _5628_/Q VGND VGND VPWR VPWR hold973/X sky130_fd_sc_hd__dlygate4sd3_1
XFILLER_1_615 VGND VGND VPWR VPWR sky130_fd_sc_hd__fill_1
Xhold951 _3646_/X VGND VGND VPWR VPWR _5673_/D sky130_fd_sc_hd__dlygate4sd3_1
XFILLER_131_841 VGND VGND VPWR VPWR sky130_fd_sc_hd__fill_1
Xhold995 _3218_/X VGND VGND VPWR VPWR _5378_/D sky130_fd_sc_hd__dlygate4sd3_1
XANTENNA__3524__S _3529_/S VGND VGND VPWR VPWR sky130_fd_sc_hd__diode_2
X_6339_ _6339_/CLK hold36/X VGND VGND VPWR VPWR hold35/A sky130_fd_sc_hd__dfxtp_1
Xhold984 _4495_/X VGND VGND VPWR VPWR _6100_/D sky130_fd_sc_hd__dlygate4sd3_1
XFILLER_95_27 VPWR VGND VPWR VGND sky130_ef_sc_hd__decap_40_12
XFILLER_89_777 VGND VGND VPWR VPWR sky130_fd_sc_hd__fill_4
XTAP_TAPCELL_ROW_73_1398 VGND VPWR sky130_fd_sc_hd__tapvpwrvgnd_1
XFILLER_0_169 VGND VGND VPWR VPWR sky130_fd_sc_hd__fill_4
XFILLER_91_408 VGND VGND VPWR VPWR sky130_fd_sc_hd__fill_1
Xhold1651 _3434_/X VGND VGND VPWR VPWR _5485_/D sky130_fd_sc_hd__dlygate4sd3_1
Xhold1662 _5860_/Q VGND VGND VPWR VPWR _3879_/A1 sky130_fd_sc_hd__dlygate4sd3_1
Xclkbuf_leaf_68_clk clkload5/A VGND VGND VPWR VPWR _6292_/CLK sky130_fd_sc_hd__clkbuf_8
Xhold1640 _5863_/Q VGND VGND VPWR VPWR _3883_/A0 sky130_fd_sc_hd__dlygate4sd3_1
Xhold1684 _4899_/X VGND VGND VPWR VPWR _6247_/D sky130_fd_sc_hd__dlygate4sd3_1
Xhold1695 _6366_/Q VGND VGND VPWR VPWR _5075_/A1 sky130_fd_sc_hd__dlygate4sd3_1
Xhold1673 _5233_/X VGND VGND VPWR VPWR _6430_/D sky130_fd_sc_hd__dlygate4sd3_1
XFILLER_72_600 VGND VGND VPWR VPWR sky130_fd_sc_hd__fill_4
XFILLER_17_505 VPWR VGND VPWR VGND sky130_ef_sc_hd__decap_40_12
XFILLER_28_87 VGND VGND VPWR VPWR sky130_fd_sc_hd__fill_1
XFILLER_29_387 VGND VGND VPWR VPWR sky130_fd_sc_hd__fill_4
XFILLER_44_346 VGND VGND VPWR VPWR sky130_fd_sc_hd__fill_2
XANTENNA__4355__S _4356_/S VGND VGND VPWR VPWR sky130_fd_sc_hd__diode_2
XFILLER_72_699 VGND VGND VPWR VPWR sky130_fd_sc_hd__fill_1
XFILLER_71_198 VPWR VGND VPWR VGND sky130_ef_sc_hd__decap_40_12
XANTENNA__3369__A_N input4/X VGND VGND VPWR VPWR sky130_fd_sc_hd__diode_2
XANTENNA__4992__A1 _5046_/A1 VGND VGND VPWR VPWR sky130_fd_sc_hd__diode_2
XFILLER_13_777 VGND VGND VPWR VPWR sky130_fd_sc_hd__fill_4
XANTENNA__4090__S _4262_/S VGND VGND VPWR VPWR sky130_fd_sc_hd__diode_2
XFILLER_8_269 VGND VGND VPWR VPWR sky130_fd_sc_hd__fill_1
XFILLER_138_473 VGND VGND VPWR VPWR sky130_fd_sc_hd__fill_2
XFILLER_126_613 VPWR VGND VPWR VGND sky130_ef_sc_hd__decap_40_12
XTAP_TAPCELL_ROW_10_455 VGND VPWR sky130_fd_sc_hd__tapvpwrvgnd_1
XTAP_TAPCELL_ROW_10_444 VGND VPWR sky130_fd_sc_hd__tapvpwrvgnd_1
XFILLER_126_657 VPWR VGND VPWR VGND sky130_ef_sc_hd__decap_40_12
XFILLER_125_145 VPWR VGND VPWR VGND sky130_ef_sc_hd__decap_40_12
XFILLER_125_167 VGND VGND VPWR VPWR sky130_fd_sc_hd__fill_1
XFILLER_4_475 VGND VGND VPWR VPWR sky130_fd_sc_hd__fill_1
XFILLER_4_453 VPWR VGND VPWR VGND sky130_ef_sc_hd__decap_40_12
XFILLER_122_841 VGND VGND VPWR VPWR sky130_fd_sc_hd__fill_1
XANTENNA__3434__S _3437_/S VGND VGND VPWR VPWR sky130_fd_sc_hd__diode_2
XFILLER_79_221 VGND VGND VPWR VPWR sky130_fd_sc_hd__fill_2
XFILLER_95_725 VGND VGND VPWR VPWR sky130_fd_sc_hd__fill_2
XFILLER_79_254 VGND VGND VPWR VPWR sky130_fd_sc_hd__fill_8
XFILLER_39_107 VGND VGND VPWR VPWR sky130_fd_sc_hd__fill_4
XFILLER_94_213 VGND VGND VPWR VPWR sky130_fd_sc_hd__fill_1
XFILLER_67_449 VGND VGND VPWR VPWR sky130_fd_sc_hd__fill_1
XFILLER_39_129 VGND VGND VPWR VPWR sky130_fd_sc_hd__fill_2
Xclkbuf_leaf_59_clk clkload6/A VGND VGND VPWR VPWR _5571_/CLK sky130_fd_sc_hd__clkbuf_8
XFILLER_94_257 VGND VGND VPWR VPWR sky130_fd_sc_hd__fill_1
XANTENNA__3483__A1 _4899_/A0 VGND VGND VPWR VPWR sky130_fd_sc_hd__diode_2
XFILLER_36_825 VPWR VGND VPWR VGND sky130_ef_sc_hd__decap_40_12
XANTENNA__4658__S1 _4794_/A VGND VGND VPWR VPWR sky130_fd_sc_hd__diode_2
XFILLER_62_143 VGND VGND VPWR VPWR sky130_fd_sc_hd__fill_4
X_3971_ _5019_/A _5019_/B VGND VGND VPWR VPWR _3972_/C sky130_fd_sc_hd__nor2_1
XFILLER_51_839 VGND VGND VPWR VPWR sky130_fd_sc_hd__fill_1
XTAP_TAPCELL_ROW_18_566 VGND VPWR sky130_fd_sc_hd__tapvpwrvgnd_1
XTAP_TAPCELL_ROW_18_577 VGND VPWR sky130_fd_sc_hd__tapvpwrvgnd_1
X_2922_ _2918_/X _2920_/X _2921_/X _3096_/A1 VGND VGND VPWR VPWR _2922_/X sky130_fd_sc_hd__a22o_1
XTAP_TAPCELL_ROW_102_1837 VGND VPWR sky130_fd_sc_hd__tapvpwrvgnd_1
XTAP_TAPCELL_ROW_102_1826 VGND VPWR sky130_fd_sc_hd__tapvpwrvgnd_1
XANTENNA__4432__B1 _4445_/B VGND VGND VPWR VPWR sky130_fd_sc_hd__diode_2
XANTENNA__4983__A1 _4983_/A1 VGND VGND VPWR VPWR sky130_fd_sc_hd__diode_2
X_5710_ _6125_/CLK _5710_/D VGND VGND VPWR VPWR _5710_/Q sky130_fd_sc_hd__dfxtp_1
XANTENNA__3957__X _4007_/A VGND VGND VPWR VPWR sky130_fd_sc_hd__diode_2
XFILLER_93_3 VPWR VGND VPWR VGND sky130_ef_sc_hd__decap_40_12
X_2853_ _2846_/X _2852_/X _2967_/S VGND VGND VPWR VPWR _2853_/X sky130_fd_sc_hd__mux2_1
X_5641_ _6290_/CLK _5641_/D VGND VGND VPWR VPWR _5641_/Q sky130_fd_sc_hd__dfxtp_1
XTAP_TAPCELL_ROW_135_2325 VGND VPWR sky130_fd_sc_hd__tapvpwrvgnd_1
X_2784_ _6070_/Q _6362_/Q _2984_/S VGND VGND VPWR VPWR _2785_/B sky130_fd_sc_hd__mux2_1
X_5572_ _6242_/CLK _5572_/D VGND VGND VPWR VPWR _5572_/Q sky130_fd_sc_hd__dfxtp_1
XANTENNA__4735__A1 _4792_/A1 VGND VGND VPWR VPWR sky130_fd_sc_hd__diode_2
XFILLER_117_613 VGND VGND VPWR VPWR sky130_fd_sc_hd__fill_2
X_4523_ _4881_/A _4523_/B VGND VGND VPWR VPWR _4535_/S sky130_fd_sc_hd__nor2_4
XFILLER_8_781 VPWR VGND VPWR VGND sky130_ef_sc_hd__decap_40_12
XFILLER_116_123 VGND VGND VPWR VPWR sky130_fd_sc_hd__fill_1
XANTENNA__2841__S0 _3091_/S VGND VGND VPWR VPWR sky130_fd_sc_hd__diode_2
Xhold203 _5752_/Q VGND VGND VPWR VPWR hold203/X sky130_fd_sc_hd__dlygate4sd3_1
Xhold225 _4551_/X VGND VGND VPWR VPWR _6151_/D sky130_fd_sc_hd__dlygate4sd3_1
Xhold214 _6325_/Q VGND VGND VPWR VPWR hold214/X sky130_fd_sc_hd__dlygate4sd3_1
X_4454_ _6260_/Q _3366_/X _4427_/B _5842_/Q _3801_/B VGND VGND VPWR VPWR _4454_/X
+ sky130_fd_sc_hd__a221o_1
Xhold247 _3901_/X VGND VGND VPWR VPWR _5880_/D sky130_fd_sc_hd__dlygate4sd3_1
Xhold269 _3645_/X VGND VGND VPWR VPWR _5672_/D sky130_fd_sc_hd__dlygate4sd3_1
Xhold258 _5802_/Q VGND VGND VPWR VPWR hold258/X sky130_fd_sc_hd__dlygate4sd3_1
Xhold236 _6311_/Q VGND VGND VPWR VPWR hold236/X sky130_fd_sc_hd__dlygate4sd3_1
XFILLER_113_841 VGND VGND VPWR VPWR sky130_fd_sc_hd__fill_1
X_4385_ hold187/X _5046_/A1 _4386_/S VGND VGND VPWR VPWR _4385_/X sky130_fd_sc_hd__mux2_1
X_3405_ _5040_/A1 _4048_/A1 _3412_/S VGND VGND VPWR VPWR _5460_/D sky130_fd_sc_hd__mux2_1
XTAP_TAPCELL_ROW_113_1999 VGND VPWR sky130_fd_sc_hd__tapvpwrvgnd_1
XTAP_TAPCELL_ROW_113_1988 VGND VPWR sky130_fd_sc_hd__tapvpwrvgnd_1
XFILLER_105_15 VPWR VGND VPWR VGND sky130_ef_sc_hd__decap_40_12
X_3336_ _3336_/A _3336_/B _3336_/C _3336_/D VGND VGND VPWR VPWR _3337_/B sky130_fd_sc_hd__or4_1
X_6124_ _6125_/CLK _6124_/D VGND VGND VPWR VPWR _6124_/Q sky130_fd_sc_hd__dfxtp_1
XFILLER_98_585 VGND VGND VPWR VPWR sky130_fd_sc_hd__fill_2
XFILLER_85_202 VGND VGND VPWR VPWR sky130_fd_sc_hd__fill_1
X_6055_ _6421_/CLK _6055_/D VGND VGND VPWR VPWR _6055_/Q sky130_fd_sc_hd__dfxtp_1
XFILLER_100_557 VPWR VGND VPWR VGND sky130_ef_sc_hd__decap_40_12
XFILLER_86_769 VPWR VGND VPWR VGND sky130_ef_sc_hd__decap_40_12
X_3267_ _4773_/S _3267_/B _4786_/S VGND VGND VPWR VPWR _3272_/C sky130_fd_sc_hd__and3_1
X_5006_ _5006_/A _5006_/B VGND VGND VPWR VPWR _5006_/Y sky130_fd_sc_hd__nand2_1
XFILLER_39_630 VGND VGND VPWR VPWR sky130_fd_sc_hd__fill_1
X_3198_ hold551/X _5241_/A1 _3206_/S VGND VGND VPWR VPWR _5360_/D sky130_fd_sc_hd__mux2_1
XFILLER_39_696 VGND VGND VPWR VPWR sky130_fd_sc_hd__fill_1
XTAP_TAPCELL_ROW_37_853 VGND VPWR sky130_fd_sc_hd__tapvpwrvgnd_1
XANTENNA__4903__S _4906_/S VGND VGND VPWR VPWR sky130_fd_sc_hd__diode_2
XFILLER_54_699 VGND VGND VPWR VPWR sky130_fd_sc_hd__fill_1
XFILLER_41_316 VGND VGND VPWR VPWR sky130_fd_sc_hd__fill_4
XANTENNA__3586__Y _3595_/S VGND VGND VPWR VPWR sky130_fd_sc_hd__diode_2
X_5908_ _5908_/CLK _5908_/D VGND VGND VPWR VPWR _5908_/Q sky130_fd_sc_hd__dfxtp_1
XANTENNA__3519__S _3529_/S VGND VGND VPWR VPWR sky130_fd_sc_hd__diode_2
X_5839_ _5841_/CLK _5839_/D VGND VGND VPWR VPWR _5839_/Q sky130_fd_sc_hd__dfxtp_1
XFILLER_10_725 VPWR VGND VPWR VGND sky130_ef_sc_hd__decap_40_12
XFILLER_22_585 VGND VGND VPWR VPWR sky130_fd_sc_hd__fill_2
XFILLER_10_769 VPWR VGND VPWR VGND sky130_ef_sc_hd__decap_40_12
XFILLER_108_613 VGND VGND VPWR VPWR sky130_fd_sc_hd__fill_4
XFILLER_108_657 VPWR VGND VPWR VGND sky130_ef_sc_hd__decap_40_12
XTAP_TAPCELL_ROW_75_1427 VGND VPWR sky130_fd_sc_hd__tapvpwrvgnd_1
XFILLER_30_55 VGND VGND VPWR VPWR sky130_fd_sc_hd__fill_1
XFILLER_135_487 VPWR VGND VPWR VGND sky130_ef_sc_hd__decap_40_12
XFILLER_104_841 VGND VGND VPWR VPWR sky130_fd_sc_hd__fill_1
Xhold770 _4826_/X VGND VGND VPWR VPWR _6180_/D sky130_fd_sc_hd__dlygate4sd3_1
Xhold781 _6038_/Q VGND VGND VPWR VPWR hold781/X sky130_fd_sc_hd__dlygate4sd3_1
Xhold792 _5047_/X VGND VGND VPWR VPWR _6342_/D sky130_fd_sc_hd__dlygate4sd3_1
XFILLER_131_671 VGND VGND VPWR VPWR sky130_fd_sc_hd__fill_1
XFILLER_49_427 VGND VGND VPWR VPWR sky130_fd_sc_hd__fill_1
XFILLER_76_268 VGND VGND VPWR VPWR sky130_fd_sc_hd__fill_2
Xhold2160 _6403_/Q VGND VGND VPWR VPWR _5191_/A sky130_fd_sc_hd__dlygate4sd3_1
Xhold2171 _6405_/Q VGND VGND VPWR VPWR _5198_/B1 sky130_fd_sc_hd__dlygate4sd3_1
Xhold2182 _6387_/Q VGND VGND VPWR VPWR _3975_/C sky130_fd_sc_hd__dlygate4sd3_1
XANTENNA__2665__Y _2665_/Y VGND VGND VPWR VPWR sky130_fd_sc_hd__diode_2
XFILLER_91_227 VGND VGND VPWR VPWR sky130_fd_sc_hd__fill_2
Xhold2193 _5111_/X VGND VGND VPWR VPWR _6387_/D sky130_fd_sc_hd__dlygate4sd3_1
XFILLER_57_471 VGND VGND VPWR VPWR sky130_fd_sc_hd__fill_1
XFILLER_18_825 VPWR VGND VPWR VGND sky130_ef_sc_hd__decap_40_12
Xhold1470 _3915_/X VGND VGND VPWR VPWR _5893_/D sky130_fd_sc_hd__dlygate4sd3_1
Xhold1492 _5380_/Q VGND VGND VPWR VPWR _3220_/A1 sky130_fd_sc_hd__dlygate4sd3_1
Xhold1481 _5758_/Q VGND VGND VPWR VPWR _3744_/A0 sky130_fd_sc_hd__dlygate4sd3_1
XANTENNA_input13_A s_axil_wdata[10] VGND VGND VPWR VPWR sky130_fd_sc_hd__diode_2
XTAP_TAPCELL_ROW_86_1589 VGND VPWR sky130_fd_sc_hd__tapvpwrvgnd_1
XFILLER_72_452 VGND VGND VPWR VPWR sky130_fd_sc_hd__fill_4
XANTENNA__4414__A0 _5045_/A1 VGND VGND VPWR VPWR sky130_fd_sc_hd__diode_2
XTAP_TAPCELL_ROW_15_525 VGND VPWR sky130_fd_sc_hd__tapvpwrvgnd_1
XFILLER_33_839 VGND VGND VPWR VPWR sky130_fd_sc_hd__fill_1
XFILLER_9_501 VGND VGND VPWR VPWR sky130_fd_sc_hd__fill_2
XFILLER_13_541 VPWR VGND VPWR VGND sky130_ef_sc_hd__decap_40_12
XANTENNA__3429__S _3437_/S VGND VGND VPWR VPWR sky130_fd_sc_hd__diode_2
XFILLER_13_585 VPWR VGND VPWR VGND sky130_ef_sc_hd__decap_40_12
XFILLER_40_360 VGND VGND VPWR VPWR sky130_fd_sc_hd__fill_4
XTAP_TAPCELL_ROW_117_2055 VGND VPWR sky130_fd_sc_hd__tapvpwrvgnd_1
XFILLER_138_281 VGND VGND VPWR VPWR sky130_fd_sc_hd__fill_1
XFILLER_126_443 VGND VGND VPWR VPWR sky130_fd_sc_hd__fill_1
XTAP_TAPCELL_ROW_130_2244 VGND VPWR sky130_fd_sc_hd__tapvpwrvgnd_1
XTAP_TAPCELL_ROW_130_2255 VGND VPWR sky130_fd_sc_hd__tapvpwrvgnd_1
X_4170_ _5951_/Q hold35/A _5933_/Q _6322_/Q _4228_/S _4263_/A VGND VGND VPWR VPWR
+ _4170_/X sky130_fd_sc_hd__mux4_1
XFILLER_122_693 VGND VGND VPWR VPWR sky130_fd_sc_hd__fill_4
X_3121_ hold315/X _5232_/A0 _3126_/S VGND VGND VPWR VPWR _3121_/X sky130_fd_sc_hd__mux2_1
XFILLER_110_811 VGND VGND VPWR VPWR sky130_fd_sc_hd__fill_1
XFILLER_95_533 VPWR VGND VPWR VGND sky130_ef_sc_hd__decap_40_12
XFILLER_67_213 VGND VGND VPWR VPWR sky130_fd_sc_hd__fill_2
XANTENNA__3456__A1 _4899_/A0 VGND VGND VPWR VPWR sky130_fd_sc_hd__diode_2
X_3052_ _3052_/A1 _3051_/X _3089_/C1 VGND VGND VPWR VPWR _3052_/X sky130_fd_sc_hd__o21a_1
XFILLER_82_249 VGND VGND VPWR VPWR sky130_fd_sc_hd__fill_1
XFILLER_76_791 VPWR VGND VPWR VGND sky130_ef_sc_hd__decap_40_12
XFILLER_91_783 VGND VGND VPWR VPWR sky130_fd_sc_hd__fill_1
XFILLER_36_677 VGND VGND VPWR VPWR sky130_fd_sc_hd__fill_1
XFILLER_90_293 VGND VGND VPWR VPWR sky130_fd_sc_hd__fill_1
XANTENNA__4405__A0 _5046_/A1 VGND VGND VPWR VPWR sky130_fd_sc_hd__diode_2
XFILLER_51_625 VGND VGND VPWR VPWR sky130_fd_sc_hd__fill_1
XTAP_TAPCELL_ROW_34_812 VGND VPWR sky130_fd_sc_hd__tapvpwrvgnd_1
XFILLER_36_699 VGND VGND VPWR VPWR sky130_fd_sc_hd__fill_1
X_3954_ _3955_/B _5191_/A _5191_/B VGND VGND VPWR VPWR _3954_/X sky130_fd_sc_hd__or3_1
X_2905_ _2962_/A _2905_/B VGND VGND VPWR VPWR _2905_/X sky130_fd_sc_hd__or2_1
X_3885_ hold423/X _6414_/Q _3889_/S VGND VGND VPWR VPWR _3885_/X sky130_fd_sc_hd__mux2_1
X_2836_ _6173_/Q _6197_/Q _6185_/Q _5479_/Q _3033_/S _3034_/A VGND VGND VPWR VPWR
+ _2836_/X sky130_fd_sc_hd__mux4_1
X_5624_ _5870_/CLK _5624_/D VGND VGND VPWR VPWR _5624_/Q sky130_fd_sc_hd__dfxtp_1
XFILLER_31_393 VGND VGND VPWR VPWR sky130_fd_sc_hd__fill_2
XANTENNA__2719__B1 _2682_/A VGND VGND VPWR VPWR sky130_fd_sc_hd__diode_2
XFILLER_129_281 VGND VGND VPWR VPWR sky130_fd_sc_hd__fill_1
XFILLER_117_432 VGND VGND VPWR VPWR sky130_fd_sc_hd__fill_1
XFILLER_117_421 VGND VGND VPWR VPWR sky130_fd_sc_hd__fill_1
X_2767_ _5415_/Q _5489_/Q _5345_/Q _5573_/Q _2963_/S _2962_/A VGND VGND VPWR VPWR
+ _2768_/B sky130_fd_sc_hd__mux4_1
X_5555_ _6402_/CLK _5555_/D VGND VGND VPWR VPWR _5555_/Q sky130_fd_sc_hd__dfxtp_1
X_5486_ _6241_/CLK _5486_/D VGND VGND VPWR VPWR _5486_/Q sky130_fd_sc_hd__dfxtp_1
X_4506_ _4636_/A1 _5210_/A1 _4512_/S VGND VGND VPWR VPWR _4506_/X sky130_fd_sc_hd__mux2_1
X_2698_ _4262_/S _3128_/A VGND VGND VPWR VPWR _2698_/X sky130_fd_sc_hd__or2_1
X_4437_ _4437_/A1 _4457_/S _4434_/X _4436_/X VGND VGND VPWR VPWR _4437_/X sky130_fd_sc_hd__o22a_1
XTAP_TAPCELL_ROW_57_1157 VGND VPWR sky130_fd_sc_hd__tapvpwrvgnd_1
XFILLER_113_671 VGND VGND VPWR VPWR sky130_fd_sc_hd__fill_1
XFILLER_101_833 VGND VGND VPWR VPWR sky130_fd_sc_hd__fill_4
XFILLER_76_29 VPWR VGND VPWR VGND sky130_ef_sc_hd__decap_40_12
XTAP_TAPCELL_ROW_70_1357 VGND VPWR sky130_fd_sc_hd__tapvpwrvgnd_1
XTAP_TAPCELL_ROW_70_1346 VGND VPWR sky130_fd_sc_hd__tapvpwrvgnd_1
XANTENNA_input5_A s_axil_araddr[3] VGND VGND VPWR VPWR sky130_fd_sc_hd__diode_2
X_4368_ _5051_/A1 _4368_/A1 _4376_/S VGND VGND VPWR VPWR _4368_/X sky130_fd_sc_hd__mux2_1
XANTENNA__3695__A1 _5213_/A1 VGND VGND VPWR VPWR sky130_fd_sc_hd__diode_2
X_6107_ _6114_/CLK _6107_/D VGND VGND VPWR VPWR _6107_/Q sky130_fd_sc_hd__dfxtp_1
XANTENNA_fanout190_X _3030_/S VGND VGND VPWR VPWR sky130_fd_sc_hd__diode_2
X_3319_ _5337_/Q _6359_/Q VGND VGND VPWR VPWR _3319_/X sky130_fd_sc_hd__xor2_1
XFILLER_58_235 VGND VGND VPWR VPWR sky130_fd_sc_hd__fill_4
X_4299_ hold439/X _5042_/A1 _4304_/S VGND VGND VPWR VPWR _4299_/X sky130_fd_sc_hd__mux2_1
XFILLER_132_35 VGND VGND VPWR VPWR sky130_fd_sc_hd__fill_1
XANTENNA__3447__A1 _5234_/A0 VGND VGND VPWR VPWR sky130_fd_sc_hd__diode_2
X_6038_ _6347_/CLK _6038_/D VGND VGND VPWR VPWR _6038_/Q sky130_fd_sc_hd__dfxtp_1
XFILLER_46_419 VGND VGND VPWR VPWR sky130_fd_sc_hd__fill_1
XFILLER_92_39 VGND VGND VPWR VPWR sky130_fd_sc_hd__fill_1
XFILLER_82_772 VPWR VGND VPWR VGND sky130_ef_sc_hd__decap_40_12
XFILLER_82_761 VGND VGND VPWR VPWR sky130_fd_sc_hd__fill_2
XFILLER_42_647 VGND VGND VPWR VPWR sky130_fd_sc_hd__fill_1
XFILLER_15_839 VGND VGND VPWR VPWR sky130_fd_sc_hd__fill_1
XFILLER_30_809 VGND VGND VPWR VPWR sky130_fd_sc_hd__fill_2
XANTENNA__3080__C1 _3094_/C1 VGND VGND VPWR VPWR sky130_fd_sc_hd__diode_2
XFILLER_10_533 VPWR VGND VPWR VGND sky130_ef_sc_hd__decap_40_12
XTAP_TAPCELL_ROW_20_594 VGND VPWR sky130_fd_sc_hd__tapvpwrvgnd_1
XFILLER_135_295 VGND VGND VPWR VPWR sky130_fd_sc_hd__fill_1
XFILLER_97_809 VPWR VGND VPWR VGND sky130_ef_sc_hd__decap_40_12
XFILLER_104_693 VGND VGND VPWR VPWR sky130_fd_sc_hd__fill_4
XFILLER_2_15 VPWR VGND VPWR VGND sky130_ef_sc_hd__decap_40_12
XTAP_TAPCELL_ROW_88_1618 VGND VPWR sky130_fd_sc_hd__tapvpwrvgnd_1
XFILLER_65_739 VGND VGND VPWR VPWR sky130_fd_sc_hd__fill_1
XFILLER_58_780 VPWR VGND VPWR VGND sky130_ef_sc_hd__decap_40_12
XFILLER_49_279 VGND VGND VPWR VPWR sky130_fd_sc_hd__fill_1
XFILLER_37_419 VGND VGND VPWR VPWR sky130_fd_sc_hd__fill_1
XFILLER_66_73 VGND VGND VPWR VPWR sky130_fd_sc_hd__fill_1
XFILLER_57_290 VGND VGND VPWR VPWR sky130_fd_sc_hd__fill_4
XFILLER_92_569 VPWR VGND VPWR VGND sky130_ef_sc_hd__decap_40_12
XANTENNA__4730__S0 _4773_/S VGND VGND VPWR VPWR sky130_fd_sc_hd__diode_2
XFILLER_73_783 VGND VGND VPWR VPWR sky130_fd_sc_hd__fill_1
XFILLER_18_699 VGND VGND VPWR VPWR sky130_fd_sc_hd__fill_1
XANTENNA__4543__S _4547_/S VGND VGND VPWR VPWR sky130_fd_sc_hd__diode_2
XFILLER_21_809 VPWR VGND VPWR VGND sky130_ef_sc_hd__decap_40_12
XANTENNA__2949__B1 _3094_/C1 VGND VGND VPWR VPWR sky130_fd_sc_hd__diode_2
XFILLER_82_94 VGND VGND VPWR VPWR sky130_fd_sc_hd__fill_1
XANTENNA__3610__A1 _5210_/A1 VGND VGND VPWR VPWR sky130_fd_sc_hd__diode_2
XFILLER_60_466 VGND VGND VPWR VPWR sky130_fd_sc_hd__fill_1
XFILLER_32_179 VGND VGND VPWR VPWR sky130_fd_sc_hd__fill_1
XFILLER_13_393 VPWR VGND VPWR VGND sky130_ef_sc_hd__decap_40_12
XFILLER_9_375 VPWR VGND VPWR VGND sky130_ef_sc_hd__decap_40_12
X_3670_ _4484_/A0 _3670_/A1 _3678_/S VGND VGND VPWR VPWR _3670_/X sky130_fd_sc_hd__mux2_1
XFILLER_127_741 VPWR VGND VPWR VGND sky130_ef_sc_hd__decap_40_12
X_2621_ _3952_/A VGND VGND VPWR VPWR _2621_/Y sky130_fd_sc_hd__inv_2
XANTENNA__4779__A _4794_/A VGND VGND VPWR VPWR sky130_fd_sc_hd__diode_2
XFILLER_127_785 VPWR VGND VPWR VGND sky130_ef_sc_hd__decap_40_12
XANTENNA__3374__B1 _4445_/B VGND VGND VPWR VPWR sky130_fd_sc_hd__diode_2
XFILLER_56_3 VGND VGND VPWR VPWR sky130_fd_sc_hd__fill_1
X_5340_ clkload9/A _5340_/D VGND VGND VPWR VPWR _5340_/Q sky130_fd_sc_hd__dfxtp_1
XFILLER_126_273 VGND VGND VPWR VPWR sky130_fd_sc_hd__fill_4
X_5271_ _6199_/CLK _5271_/D VGND VGND VPWR VPWR _5271_/Q sky130_fd_sc_hd__dfxtp_1
XFILLER_88_809 VGND VGND VPWR VPWR sky130_fd_sc_hd__fill_2
X_4222_ _4263_/A _4222_/B VGND VGND VPWR VPWR _4222_/X sky130_fd_sc_hd__or2_1
XTAP_TAPCELL_ROW_110_1947 VGND VPWR sky130_fd_sc_hd__tapvpwrvgnd_1
XFILLER_110_641 VGND VGND VPWR VPWR sky130_fd_sc_hd__fill_2
XTAP_TAPCELL_ROW_52_1076 VGND VPWR sky130_fd_sc_hd__tapvpwrvgnd_1
X_4153_ _4264_/A1 _4152_/X _4151_/X _4271_/S1 VGND VGND VPWR VPWR _4153_/X sky130_fd_sc_hd__o211a_1
X_3104_ hold501/X _5241_/A1 _3112_/S VGND VGND VPWR VPWR _3104_/X sky130_fd_sc_hd__mux2_1
XANTENNA__3429__A1 _4846_/A0 VGND VGND VPWR VPWR sky130_fd_sc_hd__diode_2
XTAP_TAPCELL_ROW_52_1087 VGND VPWR sky130_fd_sc_hd__tapvpwrvgnd_1
X_4084_ _5939_/Q _6310_/Q _4258_/S VGND VGND VPWR VPWR _4084_/X sky130_fd_sc_hd__mux2_1
XFILLER_28_419 VGND VGND VPWR VPWR sky130_fd_sc_hd__fill_1
X_3035_ _6159_/Q _6228_/Q _3062_/S VGND VGND VPWR VPWR _3035_/X sky130_fd_sc_hd__mux2_1
XFILLER_102_27 VGND VGND VPWR VPWR sky130_fd_sc_hd__fill_1
XFILLER_64_750 VGND VGND VPWR VPWR sky130_fd_sc_hd__fill_4
XFILLER_24_614 VGND VGND VPWR VPWR sky130_fd_sc_hd__fill_1
X_4986_ hold966/X _5040_/A1 _4993_/S VGND VGND VPWR VPWR _4986_/X sky130_fd_sc_hd__mux2_1
XANTENNA_fanout150_A _4713_/S VGND VGND VPWR VPWR sky130_fd_sc_hd__diode_2
XANTENNA__4929__A1 _4929_/A1 VGND VGND VPWR VPWR sky130_fd_sc_hd__diode_2
XFILLER_12_809 VGND VGND VPWR VPWR sky130_fd_sc_hd__fill_2
XFILLER_24_658 VGND VGND VPWR VPWR sky130_fd_sc_hd__fill_1
X_3937_ _4983_/A1 _3937_/A1 _3938_/S VGND VGND VPWR VPWR _3937_/X sky130_fd_sc_hd__mux2_1
XFILLER_137_505 VPWR VGND VPWR VGND sky130_ef_sc_hd__decap_40_12
XANTENNA__3601__A1 _5212_/A1 VGND VGND VPWR VPWR sky130_fd_sc_hd__diode_2
XFILLER_109_207 VGND VGND VPWR VPWR sky130_fd_sc_hd__fill_1
X_3868_ _6417_/Q _3868_/A1 _3869_/S VGND VGND VPWR VPWR _3868_/X sky130_fd_sc_hd__mux2_1
X_2819_ _3050_/A _2819_/B VGND VGND VPWR VPWR _2819_/X sky130_fd_sc_hd__or2_1
X_3799_ _5176_/A _3811_/B VGND VGND VPWR VPWR _5806_/D sky130_fd_sc_hd__and2_1
X_5607_ _6097_/CLK _5607_/D VGND VGND VPWR VPWR _5607_/Q sky130_fd_sc_hd__dfxtp_1
X_5538_ _5565_/CLK _5538_/D VGND VGND VPWR VPWR _5538_/Q sky130_fd_sc_hd__dfxtp_1
XANTENNA_fanout203_X _5176_/A VGND VGND VPWR VPWR sky130_fd_sc_hd__diode_2
XFILLER_127_57 VGND VGND VPWR VPWR sky130_fd_sc_hd__fill_4
XANTENNA__5106__A1 _5035_/C VGND VGND VPWR VPWR sky130_fd_sc_hd__diode_2
XFILLER_3_529 VPWR VGND VPWR VGND sky130_ef_sc_hd__decap_40_12
XFILLER_133_777 VGND VGND VPWR VPWR sky130_fd_sc_hd__fill_4
XFILLER_79_809 VPWR VGND VPWR VGND sky130_ef_sc_hd__decap_40_12
X_5469_ _6294_/CLK _5469_/D VGND VGND VPWR VPWR _5469_/Q sky130_fd_sc_hd__dfxtp_1
XFILLER_120_416 VGND VGND VPWR VPWR sky130_fd_sc_hd__fill_4
XANTENNA__4865__A0 _4904_/A0 VGND VGND VPWR VPWR sky130_fd_sc_hd__diode_2
XFILLER_120_449 VGND VGND VPWR VPWR sky130_fd_sc_hd__fill_2
XANTENNA__3532__S _3541_/S VGND VGND VPWR VPWR sky130_fd_sc_hd__diode_2
XFILLER_101_641 VPWR VGND VPWR VGND sky130_ef_sc_hd__decap_40_12
XFILLER_101_685 VPWR VGND VPWR VGND sky130_ef_sc_hd__decap_40_12
XTAP_TAPCELL_ROW_6_389 VGND VPWR sky130_fd_sc_hd__tapvpwrvgnd_1
XANTENNA_fanout63_A _2642_/Y VGND VGND VPWR VPWR sky130_fd_sc_hd__diode_2
XFILLER_100_195 VGND VGND VPWR VPWR sky130_fd_sc_hd__fill_1
XFILLER_62_709 VGND VGND VPWR VPWR sky130_fd_sc_hd__fill_1
XFILLER_27_441 VGND VGND VPWR VPWR sky130_fd_sc_hd__fill_4
XANTENNA__4629__A1_N _4791_/B1 VGND VGND VPWR VPWR sky130_fd_sc_hd__diode_2
XFILLER_36_65 VGND VGND VPWR VPWR sky130_fd_sc_hd__fill_2
XFILLER_36_87 VGND VGND VPWR VPWR sky130_fd_sc_hd__fill_1
XTAP_TAPCELL_ROW_83_1548 VGND VPWR sky130_fd_sc_hd__tapvpwrvgnd_1
XFILLER_15_669 VGND VGND VPWR VPWR sky130_fd_sc_hd__fill_2
XFILLER_70_797 VPWR VGND VPWR VGND sky130_ef_sc_hd__decap_40_12
XFILLER_42_477 VGND VGND VPWR VPWR sky130_fd_sc_hd__fill_4
XTAP_TAPCELL_ROW_25_675 VGND VPWR sky130_fd_sc_hd__tapvpwrvgnd_1
XFILLER_128_527 VGND VGND VPWR VPWR sky130_fd_sc_hd__fill_4
Xinput18 s_axil_wdata[15] VGND VGND VPWR VPWR _4922_/A sky130_fd_sc_hd__clkbuf_1
XTAP_TAPCELL_ROW_114_2014 VGND VPWR sky130_fd_sc_hd__tapvpwrvgnd_1
XTAP_TAPCELL_ROW_114_2003 VGND VPWR sky130_fd_sc_hd__tapvpwrvgnd_1
XFILLER_109_741 VPWR VGND VPWR VGND sky130_ef_sc_hd__decap_40_12
Xinput29 s_axil_wstrb[1] VGND VGND VPWR VPWR _3834_/B sky130_fd_sc_hd__clkbuf_1
XFILLER_109_785 VPWR VGND VPWR VGND sky130_ef_sc_hd__decap_40_12
XANTENNA__3707__S _3707_/S VGND VGND VPWR VPWR sky130_fd_sc_hd__diode_2
XANTENNA__3356__B1 _5201_/B VGND VGND VPWR VPWR sky130_fd_sc_hd__diode_2
XFILLER_6_389 VPWR VGND VPWR VGND sky130_ef_sc_hd__decap_40_12
XFILLER_124_755 VGND VGND VPWR VPWR sky130_fd_sc_hd__fill_1
XFILLER_97_617 VPWR VGND VPWR VGND sky130_ef_sc_hd__decap_40_12
XFILLER_42_9 VGND VGND VPWR VPWR sky130_fd_sc_hd__fill_1
XFILLER_96_116 VGND VGND VPWR VPWR sky130_fd_sc_hd__fill_1
XANTENNA__4856__A0 _4882_/A1 VGND VGND VPWR VPWR sky130_fd_sc_hd__diode_2
XANTENNA__4538__S _4547_/S VGND VGND VPWR VPWR sky130_fd_sc_hd__diode_2
XANTENNA__3442__S _3450_/S VGND VGND VPWR VPWR sky130_fd_sc_hd__diode_2
XFILLER_77_341 VGND VGND VPWR VPWR sky130_fd_sc_hd__fill_2
XFILLER_92_311 VGND VGND VPWR VPWR sky130_fd_sc_hd__fill_2
XANTENNA__4608__B1 _4791_/B1 VGND VGND VPWR VPWR sky130_fd_sc_hd__diode_2
XTAP_TAPCELL_ROW_125_2176 VGND VPWR sky130_fd_sc_hd__tapvpwrvgnd_1
XANTENNA__3831__A1 _5046_/A1 VGND VGND VPWR VPWR sky130_fd_sc_hd__diode_2
X_4840_ _4905_/A0 _4840_/A1 _4841_/S VGND VGND VPWR VPWR _4840_/X sky130_fd_sc_hd__mux2_1
XFILLER_61_764 VPWR VGND VPWR VGND sky130_ef_sc_hd__decap_40_12
XFILLER_45_293 VGND VGND VPWR VPWR sky130_fd_sc_hd__fill_2
XANTENNA__4273__S _5343_/Q VGND VGND VPWR VPWR sky130_fd_sc_hd__diode_2
XFILLER_61_797 VPWR VGND VPWR VGND sky130_ef_sc_hd__decap_40_12
XTAP_TAPCELL_ROW_44_962 VGND VPWR sky130_fd_sc_hd__tapvpwrvgnd_1
X_4771_ _4764_/X _4770_/X _4813_/S VGND VGND VPWR VPWR _4771_/X sky130_fd_sc_hd__mux2_1
X_3722_ hold981/X _4978_/A1 _3728_/S VGND VGND VPWR VPWR _3722_/X sky130_fd_sc_hd__mux2_1
XFILLER_119_549 VGND VGND VPWR VPWR sky130_fd_sc_hd__fill_8
X_3653_ hold435/X _4488_/A0 _3657_/S VGND VGND VPWR VPWR _3653_/X sky130_fd_sc_hd__mux2_1
X_6372_ _6434_/CLK _6372_/D VGND VGND VPWR VPWR _6372_/Q sky130_fd_sc_hd__dfxtp_1
X_3584_ hold813/X _4964_/A0 _3584_/S VGND VGND VPWR VPWR _3584_/X sky130_fd_sc_hd__mux2_1
XANTENNA__3898__A1 _5215_/A1 VGND VGND VPWR VPWR sky130_fd_sc_hd__diode_2
X_5323_ clkload8/A _5323_/D VGND VGND VPWR VPWR _5323_/Q sky130_fd_sc_hd__dfxtp_2
XFILLER_115_777 VGND VGND VPWR VPWR sky130_fd_sc_hd__fill_4
XTAP_TAPCELL_ROW_54_1116 VGND VPWR sky130_fd_sc_hd__tapvpwrvgnd_1
XTAP_TAPCELL_ROW_54_1105 VGND VPWR sky130_fd_sc_hd__tapvpwrvgnd_1
XFILLER_130_725 VPWR VGND VPWR VGND sky130_ef_sc_hd__decap_40_12
X_5254_ _6434_/CLK _5254_/D VGND VGND VPWR VPWR _5254_/Q sky130_fd_sc_hd__dfxtp_1
XANTENNA__4847__A0 _4899_/A0 VGND VGND VPWR VPWR sky130_fd_sc_hd__diode_2
XFILLER_69_820 VGND VGND VPWR VPWR sky130_fd_sc_hd__fill_1
XFILLER_130_769 VPWR VGND VPWR VGND sky130_ef_sc_hd__decap_40_12
X_5185_ _5190_/A1 _5185_/A1 _5194_/S VGND VGND VPWR VPWR _5185_/X sky130_fd_sc_hd__mux2_1
X_4205_ _4205_/A _4205_/B VGND VGND VPWR VPWR _4205_/X sky130_fd_sc_hd__and2_1
XANTENNA_fanout198_A _3033_/S VGND VGND VPWR VPWR sky130_fd_sc_hd__diode_2
X_4136_ _4251_/A _4136_/B VGND VGND VPWR VPWR _4136_/X sky130_fd_sc_hd__or2_1
XFILLER_113_15 VPWR VGND VPWR VGND sky130_ef_sc_hd__decap_40_12
XTAP_TAPCELL_ROW_3_348 VGND VPWR sky130_fd_sc_hd__tapvpwrvgnd_1
XFILLER_28_238 VGND VGND VPWR VPWR sky130_fd_sc_hd__fill_1
XFILLER_73_19 VGND VGND VPWR VPWR sky130_fd_sc_hd__fill_1
XANTENNA__4075__A1 _4272_/S VGND VGND VPWR VPWR sky130_fd_sc_hd__diode_2
X_4067_ _4264_/A1 _4066_/X _4065_/X _4271_/S1 VGND VGND VPWR VPWR _4067_/X sky130_fd_sc_hd__o211a_1
X_3018_ _3076_/A1 _3013_/X _3015_/X _3017_/X VGND VGND VPWR VPWR _3018_/X sky130_fd_sc_hd__a22o_1
XANTENNA__4170__S1 _4263_/A VGND VGND VPWR VPWR sky130_fd_sc_hd__diode_2
XFILLER_43_219 VGND VGND VPWR VPWR sky130_fd_sc_hd__fill_1
XFILLER_37_783 VGND VGND VPWR VPWR sky130_fd_sc_hd__fill_1
XANTENNA_fanout153_X _4778_/S VGND VGND VPWR VPWR sky130_fd_sc_hd__diode_2
XFILLER_24_433 VPWR VGND VPWR VGND sky130_ef_sc_hd__decap_40_12
XTAP_TAPCELL_ROW_65_1278 VGND VPWR sky130_fd_sc_hd__tapvpwrvgnd_1
X_4969_ _5042_/A1 _4969_/A1 _4974_/S VGND VGND VPWR VPWR _4969_/X sky130_fd_sc_hd__mux2_1
XTAP_TAPCELL_ROW_22_623 VGND VPWR sky130_fd_sc_hd__tapvpwrvgnd_1
XTAP_TAPCELL_ROW_22_634 VGND VPWR sky130_fd_sc_hd__tapvpwrvgnd_1
XFILLER_138_825 VPWR VGND VPWR VGND sky130_ef_sc_hd__decap_40_12
XANTENNA__3527__S _3529_/S VGND VGND VPWR VPWR sky130_fd_sc_hd__diode_2
XANTENNA__4212__A _4212_/A VGND VGND VPWR VPWR sky130_fd_sc_hd__diode_2
XFILLER_4_805 VGND VGND VPWR VPWR sky130_fd_sc_hd__fill_4
XFILLER_98_27 VGND VGND VPWR VPWR sky130_fd_sc_hd__fill_1
XANTENNA__3889__A1 _4964_/A0 VGND VGND VPWR VPWR sky130_fd_sc_hd__diode_2
XFILLER_133_541 VPWR VGND VPWR VGND sky130_ef_sc_hd__decap_40_12
XFILLER_106_755 VGND VGND VPWR VPWR sky130_fd_sc_hd__fill_1
XFILLER_3_337 VPWR VGND VPWR VGND sky130_ef_sc_hd__decap_40_12
XFILLER_133_585 VPWR VGND VPWR VGND sky130_ef_sc_hd__decap_40_12
XFILLER_121_725 VGND VGND VPWR VPWR sky130_fd_sc_hd__fill_2
XANTENNA__4838__A0 _5813_/Q VGND VGND VPWR VPWR sky130_fd_sc_hd__diode_2
XPHY_EDGE_ROW_110_Right_110 VGND VGND VPWR VPWR sky130_fd_sc_hd__decap_3
Xfanout140 hold2212/X VGND VGND VPWR VPWR _2628_/A sky130_fd_sc_hd__buf_4
XANTENNA__3510__A0 _5075_/A0 VGND VGND VPWR VPWR sky130_fd_sc_hd__diode_2
Xfanout151 _4713_/S VGND VGND VPWR VPWR _4790_/S sky130_fd_sc_hd__clkbuf_4
XFILLER_47_31 VGND VGND VPWR VPWR sky130_fd_sc_hd__fill_2
Xfanout162 _4212_/A VGND VGND VPWR VPWR _4263_/A sky130_fd_sc_hd__buf_4
Xfanout173 hold2229/X VGND VGND VPWR VPWR _4221_/S sky130_fd_sc_hd__clkbuf_4
XANTENNA_fanout66_X _3075_/C1 VGND VGND VPWR VPWR sky130_fd_sc_hd__diode_2
Xfanout184 _5267_/Q VGND VGND VPWR VPWR _3044_/A sky130_fd_sc_hd__buf_4
Xfanout195 _3091_/S VGND VGND VPWR VPWR _3062_/S sky130_fd_sc_hd__clkbuf_8
XFILLER_90_837 VGND VGND VPWR VPWR sky130_fd_sc_hd__fill_4
XFILLER_74_377 VGND VGND VPWR VPWR sky130_fd_sc_hd__fill_4
XANTENNA_clkbuf_leaf_70_clk_A clkload2/A VGND VGND VPWR VPWR sky130_fd_sc_hd__diode_2
XFILLER_63_41 VGND VGND VPWR VPWR sky130_fd_sc_hd__fill_2
XANTENNA__4093__S _4228_/S VGND VGND VPWR VPWR sky130_fd_sc_hd__diode_2
XTAP_TAPCELL_ROW_120_2095 VGND VPWR sky130_fd_sc_hd__tapvpwrvgnd_1
XFILLER_43_797 VPWR VGND VPWR VGND sky130_ef_sc_hd__decap_40_12
XTAP_TAPCELL_ROW_41_910 VGND VPWR sky130_fd_sc_hd__tapvpwrvgnd_1
XTAP_TAPCELL_ROW_41_921 VGND VPWR sky130_fd_sc_hd__tapvpwrvgnd_1
XANTENNA__4821__S _4828_/S VGND VGND VPWR VPWR sky130_fd_sc_hd__diode_2
XANTENNA_clkbuf_leaf_85_clk_A clkload1/A VGND VGND VPWR VPWR sky130_fd_sc_hd__diode_2
XFILLER_10_160 VGND VGND VPWR VPWR sky130_fd_sc_hd__fill_1
XANTENNA__3437__S _3437_/S VGND VGND VPWR VPWR sky130_fd_sc_hd__diode_2
XTAP_TAPCELL_ROW_96_1739 VGND VPWR sky130_fd_sc_hd__tapvpwrvgnd_1
XFILLER_10_182 VGND VGND VPWR VPWR sky130_fd_sc_hd__fill_4
XFILLER_7_665 VGND VGND VPWR VPWR sky130_fd_sc_hd__fill_4
XFILLER_6_197 VGND VGND VPWR VPWR sky130_fd_sc_hd__fill_4
XFILLER_124_585 VGND VGND VPWR VPWR sky130_fd_sc_hd__fill_2
XFILLER_112_725 VPWR VGND VPWR VGND sky130_ef_sc_hd__decap_40_12
XFILLER_112_769 VPWR VGND VPWR VGND sky130_ef_sc_hd__decap_40_12
XFILLER_2_381 VGND VGND VPWR VPWR sky130_fd_sc_hd__fill_2
XTAP_TAPCELL_ROW_127_2205 VGND VPWR sky130_fd_sc_hd__tapvpwrvgnd_1
XANTENNA__3501__A0 _4904_/A0 VGND VGND VPWR VPWR sky130_fd_sc_hd__diode_2
XANTENNA_clkbuf_leaf_23_clk_A clkload3/A VGND VGND VPWR VPWR sky130_fd_sc_hd__diode_2
XFILLER_19_3 VPWR VGND VPWR VGND sky130_ef_sc_hd__decap_40_12
XFILLER_38_514 VGND VGND VPWR VPWR sky130_fd_sc_hd__fill_1
XFILLER_93_653 VPWR VGND VPWR VGND sky130_ef_sc_hd__decap_40_12
XFILLER_92_141 VPWR VGND VPWR VGND sky130_ef_sc_hd__decap_40_12
XTAP_TAPCELL_ROW_0_307 VGND VPWR sky130_fd_sc_hd__tapvpwrvgnd_1
XANTENNA__4057__A1 _4252_/A1 VGND VGND VPWR VPWR sky130_fd_sc_hd__diode_2
XANTENNA_clkbuf_leaf_38_clk_A clkload4/A VGND VGND VPWR VPWR sky130_fd_sc_hd__diode_2
XFILLER_93_697 VPWR VGND VPWR VGND sky130_ef_sc_hd__decap_40_12
XFILLER_81_837 VGND VGND VPWR VPWR sky130_fd_sc_hd__fill_2
XFILLER_19_783 VGND VGND VPWR VPWR sky130_fd_sc_hd__fill_1
X_5941_ _6314_/CLK _5941_/D VGND VGND VPWR VPWR _5941_/Q sky130_fd_sc_hd__dfxtp_1
XANTENNA__3804__A1 _5075_/A0 VGND VGND VPWR VPWR sky130_fd_sc_hd__diode_2
XTAP_TAPCELL_ROW_105_1879 VGND VPWR sky130_fd_sc_hd__tapvpwrvgnd_1
XTAP_TAPCELL_ROW_105_1868 VGND VPWR sky130_fd_sc_hd__tapvpwrvgnd_1
X_5872_ _6094_/CLK _5872_/D VGND VGND VPWR VPWR _5872_/Q sky130_fd_sc_hd__dfxtp_1
X_4823_ _4901_/A0 _4823_/A1 _4828_/S VGND VGND VPWR VPWR _4823_/X sky130_fd_sc_hd__mux2_1
XANTENNA__5396__Q _5396_/Q VGND VGND VPWR VPWR sky130_fd_sc_hd__diode_2
XFILLER_33_296 VGND VGND VPWR VPWR sky130_fd_sc_hd__fill_1
X_4754_ _2629_/Y _4753_/X _4752_/X _4811_/C1 VGND VGND VPWR VPWR _4754_/X sky130_fd_sc_hd__o211a_1
XFILLER_21_447 VGND VGND VPWR VPWR sky130_fd_sc_hd__fill_1
XTAP_TAPCELL_ROW_138_2389 VGND VPWR sky130_fd_sc_hd__tapvpwrvgnd_1
XTAP_TAPCELL_ROW_138_2378 VGND VPWR sky130_fd_sc_hd__tapvpwrvgnd_1
XTAP_TAPCELL_ROW_138_2367 VGND VPWR sky130_fd_sc_hd__tapvpwrvgnd_1
X_3705_ _5214_/A1 _4730_/A3 _3707_/S VGND VGND VPWR VPWR _3705_/X sky130_fd_sc_hd__mux2_1
XFILLER_119_368 VGND VGND VPWR VPWR sky130_fd_sc_hd__fill_2
X_4685_ _5607_/Q _5688_/Q _4778_/S VGND VGND VPWR VPWR _4685_/X sky130_fd_sc_hd__mux2_1
XTAP_TAPCELL_ROW_60_1197 VGND VPWR sky130_fd_sc_hd__tapvpwrvgnd_1
XFILLER_135_839 VGND VGND VPWR VPWR sky130_fd_sc_hd__fill_1
X_6424_ _6428_/CLK _6424_/D VGND VGND VPWR VPWR _6424_/Q sky130_fd_sc_hd__dfxtp_1
XFILLER_108_15 VPWR VGND VPWR VGND sky130_ef_sc_hd__decap_40_12
XANTENNA_fanout113_A _5821_/Q VGND VGND VPWR VPWR sky130_fd_sc_hd__diode_2
X_3636_ hold956/X _4521_/A1 _3637_/S VGND VGND VPWR VPWR _3636_/X sky130_fd_sc_hd__mux2_1
XFILLER_115_541 VPWR VGND VPWR VGND sky130_ef_sc_hd__decap_40_12
X_6355_ _6386_/CLK _6355_/D VGND VGND VPWR VPWR _6355_/Q sky130_fd_sc_hd__dfxtp_1
X_3567_ hold763/X _4515_/A1 _3574_/S VGND VGND VPWR VPWR _3567_/X sky130_fd_sc_hd__mux2_1
XTAP_TAPCELL_ROW_8_418 VGND VPWR sky130_fd_sc_hd__tapvpwrvgnd_1
X_5306_ _6429_/CLK _5306_/D VGND VGND VPWR VPWR _5306_/Q sky130_fd_sc_hd__dfxtp_1
XFILLER_115_585 VPWR VGND VPWR VGND sky130_ef_sc_hd__decap_40_12
XFILLER_103_725 VGND VGND VPWR VPWR sky130_fd_sc_hd__fill_2
XFILLER_88_425 VGND VGND VPWR VPWR sky130_fd_sc_hd__fill_2
XFILLER_0_307 VGND VGND VPWR VPWR sky130_fd_sc_hd__fill_1
X_6286_ _6314_/CLK _6286_/D VGND VGND VPWR VPWR _6286_/Q sky130_fd_sc_hd__dfxtp_1
XFILLER_130_533 VPWR VGND VPWR VGND sky130_ef_sc_hd__decap_40_12
X_3498_ _5811_/Q _3498_/A1 _3503_/S VGND VGND VPWR VPWR _3498_/X sky130_fd_sc_hd__mux2_1
X_5237_ _5237_/A0 _5237_/A1 _5237_/S VGND VGND VPWR VPWR _5237_/X sky130_fd_sc_hd__mux2_1
XFILLER_0_329 VGND VGND VPWR VPWR sky130_fd_sc_hd__fill_2
Xhold1811 _6207_/Q VGND VGND VPWR VPWR _4856_/A1 sky130_fd_sc_hd__dlygate4sd3_1
Xhold1800 _5878_/Q VGND VGND VPWR VPWR _3899_/A0 sky130_fd_sc_hd__dlygate4sd3_1
XANTENNA__4296__A1 _5051_/A1 VGND VGND VPWR VPWR sky130_fd_sc_hd__diode_2
XFILLER_29_503 VGND VGND VPWR VPWR sky130_fd_sc_hd__fill_1
Xhold1822 _5282_/Q VGND VGND VPWR VPWR _2752_/A0 sky130_fd_sc_hd__dlygate4sd3_1
XFILLER_84_29 VPWR VGND VPWR VGND sky130_ef_sc_hd__decap_40_12
X_5168_ _6256_/Q _6255_/Q _5194_/S VGND VGND VPWR VPWR _5168_/X sky130_fd_sc_hd__mux2_1
XFILLER_68_182 VGND VGND VPWR VPWR sky130_fd_sc_hd__fill_1
Xhold1833 _3748_/X VGND VGND VPWR VPWR _5761_/D sky130_fd_sc_hd__dlygate4sd3_1
Xhold1844 _5974_/Q VGND VGND VPWR VPWR _4328_/A1 sky130_fd_sc_hd__dlygate4sd3_1
XANTENNA__4906__S _4906_/S VGND VGND VPWR VPWR sky130_fd_sc_hd__diode_2
Xhold1866 _4862_/X VGND VGND VPWR VPWR _6213_/D sky130_fd_sc_hd__dlygate4sd3_1
XTAP_TAPCELL_ROW_67_1307 VGND VPWR sky130_fd_sc_hd__tapvpwrvgnd_1
X_5099_ _4009_/Y _5099_/B _5099_/C _5099_/D VGND VGND VPWR VPWR _5100_/B sky130_fd_sc_hd__and4b_1
X_4119_ _4149_/A _4119_/B VGND VGND VPWR VPWR _4119_/X sky130_fd_sc_hd__and2_1
XFILLER_17_709 VPWR VGND VPWR VGND sky130_ef_sc_hd__decap_40_12
Xhold1877 _6286_/Q VGND VGND VPWR VPWR _4951_/A1 sky130_fd_sc_hd__dlygate4sd3_1
Xhold1855 _3398_/X VGND VGND VPWR VPWR _5455_/D sky130_fd_sc_hd__dlygate4sd3_1
Xi2c_master_axil_222 VGND VGND VPWR VPWR i2c_master_axil_222/HI s_axil_rdata[28] sky130_fd_sc_hd__conb_1
XFILLER_72_826 VGND VGND VPWR VPWR sky130_fd_sc_hd__fill_1
Xhold1899 _5086_/X VGND VGND VPWR VPWR _6374_/D sky130_fd_sc_hd__dlygate4sd3_1
XFILLER_56_399 VPWR VGND VPWR VGND sky130_ef_sc_hd__decap_40_12
XFILLER_56_388 VGND VGND VPWR VPWR sky130_fd_sc_hd__fill_2
XFILLER_56_377 VGND VGND VPWR VPWR sky130_fd_sc_hd__fill_1
Xi2c_master_axil_211 VGND VGND VPWR VPWR i2c_master_axil_211/HI s_axil_rdata[17] sky130_fd_sc_hd__conb_1
XTAP_TAPCELL_ROW_27_704 VGND VPWR sky130_fd_sc_hd__tapvpwrvgnd_1
Xhold1888 _4373_/X VGND VGND VPWR VPWR _6014_/D sky130_fd_sc_hd__dlygate4sd3_1
XFILLER_25_731 VGND VGND VPWR VPWR sky130_fd_sc_hd__fill_1
XTAP_TAPCELL_ROW_80_1507 VGND VPWR sky130_fd_sc_hd__tapvpwrvgnd_1
XANTENNA__4207__A _4263_/A VGND VGND VPWR VPWR sky130_fd_sc_hd__diode_2
XFILLER_40_712 VGND VGND VPWR VPWR sky130_fd_sc_hd__fill_1
XFILLER_25_797 VPWR VGND VPWR VGND sky130_ef_sc_hd__decap_40_12
XANTENNA__3559__A0 _4488_/A0 VGND VGND VPWR VPWR sky130_fd_sc_hd__diode_2
XFILLER_12_469 VGND VGND VPWR VPWR sky130_fd_sc_hd__fill_4
XANTENNA__4641__S _4810_/S VGND VGND VPWR VPWR sky130_fd_sc_hd__diode_2
XFILLER_33_55 VGND VGND VPWR VPWR sky130_fd_sc_hd__fill_1
XFILLER_40_789 VPWR VGND VPWR VGND sky130_ef_sc_hd__decap_40_12
XFILLER_137_132 VGND VGND VPWR VPWR sky130_fd_sc_hd__fill_1
XFILLER_123_3 VPWR VGND VPWR VGND sky130_ef_sc_hd__decap_40_12
XFILLER_138_699 VGND VGND VPWR VPWR sky130_fd_sc_hd__fill_1
XFILLER_137_165 VGND VGND VPWR VPWR sky130_fd_sc_hd__fill_2
XTAP_TAPCELL_ROW_78_1469 VGND VPWR sky130_fd_sc_hd__tapvpwrvgnd_1
XFILLER_4_613 VPWR VGND VPWR VGND sky130_ef_sc_hd__decap_40_12
XFILLER_4_657 VPWR VGND VPWR VGND sky130_ef_sc_hd__decap_40_12
XFILLER_106_585 VGND VGND VPWR VPWR sky130_fd_sc_hd__fill_2
XANTENNA__2668__Y _5241_/S VGND VGND VPWR VPWR sky130_fd_sc_hd__diode_2
XTAP_TAPCELL_ROW_91_1669 VGND VPWR sky130_fd_sc_hd__tapvpwrvgnd_1
XTAP_TAPCELL_ROW_91_1658 VGND VPWR sky130_fd_sc_hd__tapvpwrvgnd_1
XFILLER_0_841 VGND VGND VPWR VPWR sky130_fd_sc_hd__fill_1
XANTENNA__4287__A1 _5052_/A1 VGND VGND VPWR VPWR sky130_fd_sc_hd__diode_2
Xhold7 hold7/A VGND VGND VPWR VPWR hold7/X sky130_fd_sc_hd__dlygate4sd3_1
XFILLER_59_182 VGND VGND VPWR VPWR sky130_fd_sc_hd__fill_1
XANTENNA__5236__A0 _5815_/Q VGND VGND VPWR VPWR sky130_fd_sc_hd__diode_2
XTAP_TAPCELL_ROW_122_2124 VGND VPWR sky130_fd_sc_hd__tapvpwrvgnd_1
XFILLER_90_601 VPWR VGND VPWR VGND sky130_ef_sc_hd__decap_40_12
XTAP_TAPCELL_ROW_122_2135 VGND VPWR sky130_fd_sc_hd__tapvpwrvgnd_1
XFILLER_90_645 VPWR VGND VPWR VGND sky130_ef_sc_hd__decap_40_12
XANTENNA__4134__S1 _4178_/A VGND VGND VPWR VPWR sky130_fd_sc_hd__diode_2
XFILLER_16_753 VGND VGND VPWR VPWR sky130_fd_sc_hd__fill_2
XANTENNA__4551__S _4561_/S VGND VGND VPWR VPWR sky130_fd_sc_hd__diode_2
XANTENNA__3956__A _3958_/A VGND VGND VPWR VPWR sky130_fd_sc_hd__diode_2
XANTENNA__4747__C1 _4663_/A VGND VGND VPWR VPWR sky130_fd_sc_hd__diode_2
XFILLER_128_143 VGND VGND VPWR VPWR sky130_fd_sc_hd__fill_2
XTAP_TAPCELL_ROW_100_1798 VGND VPWR sky130_fd_sc_hd__tapvpwrvgnd_1
XTAP_TAPCELL_ROW_13_497 VGND VPWR sky130_fd_sc_hd__tapvpwrvgnd_1
X_4470_ _5235_/A0 hold596/X _4472_/S VGND VGND VPWR VPWR _4470_/X sky130_fd_sc_hd__mux2_1
Xhold407 _5525_/Q VGND VGND VPWR VPWR hold407/X sky130_fd_sc_hd__dlygate4sd3_1
XFILLER_117_839 VGND VGND VPWR VPWR sky130_fd_sc_hd__fill_1
Xhold418 _4893_/X VGND VGND VPWR VPWR _6242_/D sky130_fd_sc_hd__dlygate4sd3_1
XFILLER_7_473 VPWR VGND VPWR VGND sky130_ef_sc_hd__decap_40_12
XFILLER_132_809 VGND VGND VPWR VPWR sky130_fd_sc_hd__fill_2
X_3421_ hold85/X _5214_/A1 _3423_/S VGND VGND VPWR VPWR hold86/A sky130_fd_sc_hd__mux2_1
Xhold429 _5756_/Q VGND VGND VPWR VPWR hold429/X sky130_fd_sc_hd__dlygate4sd3_1
X_6140_ _6366_/CLK _6140_/D VGND VGND VPWR VPWR _6140_/Q sky130_fd_sc_hd__dfxtp_1
XTAP_TAPCELL_ROW_133_2297 VGND VPWR sky130_fd_sc_hd__tapvpwrvgnd_1
XFILLER_131_319 VGND VGND VPWR VPWR sky130_fd_sc_hd__fill_1
XFILLER_98_701 VPWR VGND VPWR VGND sky130_ef_sc_hd__decap_40_12
X_3352_ _3352_/A1 _5035_/C _5201_/B _5214_/A0 VGND VGND VPWR VPWR _3352_/X sky130_fd_sc_hd__a22o_1
XFILLER_112_533 VPWR VGND VPWR VGND sky130_ef_sc_hd__decap_40_12
X_6071_ _6432_/CLK _6071_/D VGND VGND VPWR VPWR _6071_/Q sky130_fd_sc_hd__dfxtp_1
X_3283_ _4894_/A _5225_/B VGND VGND VPWR VPWR _3295_/S sky130_fd_sc_hd__nor2_8
XANTENNA__4278__A1 _5053_/A1 VGND VGND VPWR VPWR sky130_fd_sc_hd__diode_2
Xhold1118 _5515_/Q VGND VGND VPWR VPWR _3468_/A1 sky130_fd_sc_hd__dlygate4sd3_1
Xhold1107 _3294_/X VGND VGND VPWR VPWR _5413_/D sky130_fd_sc_hd__dlygate4sd3_1
X_5022_ _6329_/Q _5020_/X _5021_/X VGND VGND VPWR VPWR _5022_/X sky130_fd_sc_hd__a21o_1
Xhold1129 _4506_/X VGND VGND VPWR VPWR _6110_/D sky130_fd_sc_hd__dlygate4sd3_1
XANTENNA__5227__A0 _5239_/A1 VGND VGND VPWR VPWR sky130_fd_sc_hd__diode_2
XTAP_TAPCELL_ROW_107_1908 VGND VPWR sky130_fd_sc_hd__tapvpwrvgnd_1
XFILLER_38_355 VGND VGND VPWR VPWR sky130_fd_sc_hd__fill_1
XFILLER_65_152 VGND VGND VPWR VPWR sky130_fd_sc_hd__fill_1
XFILLER_54_837 VGND VGND VPWR VPWR sky130_fd_sc_hd__fill_4
XFILLER_38_388 VGND VGND VPWR VPWR sky130_fd_sc_hd__fill_4
XFILLER_81_645 VGND VGND VPWR VPWR sky130_fd_sc_hd__fill_2
XFILLER_80_111 VGND VGND VPWR VPWR sky130_fd_sc_hd__fill_2
XTAP_TAPCELL_ROW_49_1037 VGND VPWR sky130_fd_sc_hd__tapvpwrvgnd_1
XANTENNA__4450__A1 _4449_/X VGND VGND VPWR VPWR sky130_fd_sc_hd__diode_2
XFILLER_0_81 VGND VGND VPWR VPWR sky130_fd_sc_hd__fill_2
XFILLER_22_701 VPWR VGND VPWR VGND sky130_ef_sc_hd__decap_40_12
X_5924_ _6420_/CLK _5924_/D VGND VGND VPWR VPWR _5924_/Q sky130_fd_sc_hd__dfxtp_1
XFILLER_110_27 VGND VGND VPWR VPWR sky130_fd_sc_hd__fill_1
X_5855_ _5870_/CLK _5855_/D VGND VGND VPWR VPWR _5855_/Q sky130_fd_sc_hd__dfxtp_1
XTAP_TAPCELL_ROW_62_1237 VGND VPWR sky130_fd_sc_hd__tapvpwrvgnd_1
XTAP_TAPCELL_ROW_62_1226 VGND VPWR sky130_fd_sc_hd__tapvpwrvgnd_1
XFILLER_34_583 VGND VGND VPWR VPWR sky130_fd_sc_hd__fill_4
XANTENNA__4461__S _4472_/S VGND VGND VPWR VPWR sky130_fd_sc_hd__diode_2
X_4806_ _4811_/C1 _4805_/X _4804_/X VGND VGND VPWR VPWR _4806_/Y sky130_fd_sc_hd__a21oi_1
X_2998_ _3085_/A _2998_/B VGND VGND VPWR VPWR _2998_/X sky130_fd_sc_hd__and2_1
X_5786_ _6307_/CLK _5786_/D VGND VGND VPWR VPWR _5786_/Q sky130_fd_sc_hd__dfxtp_1
XTAP_TAPCELL_ROW_32_773 VGND VPWR sky130_fd_sc_hd__tapvpwrvgnd_1
XTAP_TAPCELL_ROW_32_784 VGND VPWR sky130_fd_sc_hd__tapvpwrvgnd_1
XANTENNA__3077__S _3077_/S VGND VGND VPWR VPWR sky130_fd_sc_hd__diode_2
X_4737_ _4794_/A _4737_/B VGND VGND VPWR VPWR _4737_/Y sky130_fd_sc_hd__nor2_1
XANTENNA_fanout116_X _5228_/A0 VGND VGND VPWR VPWR sky130_fd_sc_hd__diode_2
X_4668_ _4663_/X _4667_/X _4813_/S VGND VGND VPWR VPWR _4668_/Y sky130_fd_sc_hd__o21ai_1
XFILLER_135_669 VGND VGND VPWR VPWR sky130_fd_sc_hd__fill_2
XFILLER_123_809 VPWR VGND VPWR VGND sky130_ef_sc_hd__decap_40_12
X_6407_ _6409_/CLK _6407_/D VGND VGND VPWR VPWR _6407_/Q sky130_fd_sc_hd__dfxtp_1
Xhold930 _5894_/Q VGND VGND VPWR VPWR hold930/X sky130_fd_sc_hd__dlygate4sd3_1
XANTENNA__4697__A _4809_/A VGND VGND VPWR VPWR sky130_fd_sc_hd__diode_2
X_3619_ hold29/X _4484_/A0 _3627_/S VGND VGND VPWR VPWR hold30/A sky130_fd_sc_hd__mux2_1
XFILLER_134_157 VGND VGND VPWR VPWR sky130_fd_sc_hd__fill_8
Xhold941 _3107_/X VGND VGND VPWR VPWR _5302_/D sky130_fd_sc_hd__dlygate4sd3_1
Xhold963 _3583_/X VGND VGND VPWR VPWR _5619_/D sky130_fd_sc_hd__dlygate4sd3_1
X_4599_ hold975/X _4599_/A1 _4803_/S VGND VGND VPWR VPWR _4600_/B sky130_fd_sc_hd__mux2_1
Xhold952 _5773_/Q VGND VGND VPWR VPWR hold952/X sky130_fd_sc_hd__dlygate4sd3_1
Xhold996 _5367_/Q VGND VGND VPWR VPWR hold996/X sky130_fd_sc_hd__dlygate4sd3_1
XFILLER_115_371 VGND VGND VPWR VPWR sky130_fd_sc_hd__fill_1
X_6338_ _6338_/CLK hold40/X VGND VGND VPWR VPWR hold39/A sky130_fd_sc_hd__dfxtp_1
Xhold974 _3594_/X VGND VGND VPWR VPWR _5628_/D sky130_fd_sc_hd__dlygate4sd3_1
XFILLER_0_115 VGND VGND VPWR VPWR sky130_fd_sc_hd__fill_4
Xhold985 _5702_/Q VGND VGND VPWR VPWR hold985/X sky130_fd_sc_hd__dlygate4sd3_1
XFILLER_135_68 VGND VGND VPWR VPWR sky130_fd_sc_hd__fill_2
XFILLER_135_57 VGND VGND VPWR VPWR sky130_fd_sc_hd__fill_8
XFILLER_130_363 VGND VGND VPWR VPWR sky130_fd_sc_hd__fill_1
XFILLER_95_39 VGND VGND VPWR VPWR sky130_fd_sc_hd__fill_1
XTAP_TAPCELL_ROW_73_1399 VGND VPWR sky130_fd_sc_hd__tapvpwrvgnd_1
XTAP_TAPCELL_ROW_73_1388 VGND VPWR sky130_fd_sc_hd__tapvpwrvgnd_1
X_6269_ _6300_/CLK _6269_/D VGND VGND VPWR VPWR _6269_/Q sky130_fd_sc_hd__dfxtp_1
Xhold1641 _3883_/X VGND VGND VPWR VPWR _5863_/D sky130_fd_sc_hd__dlygate4sd3_1
Xhold1652 _6304_/Q VGND VGND VPWR VPWR _4971_/A1 sky130_fd_sc_hd__dlygate4sd3_1
XFILLER_28_33 VGND VGND VPWR VPWR sky130_fd_sc_hd__fill_1
XFILLER_29_333 VGND VGND VPWR VPWR sky130_fd_sc_hd__fill_2
Xhold1630 _4413_/X VGND VGND VPWR VPWR _6050_/D sky130_fd_sc_hd__dlygate4sd3_1
Xhold1685 _5563_/Q VGND VGND VPWR VPWR _3520_/A1 sky130_fd_sc_hd__dlygate4sd3_1
Xhold1696 _5075_/X VGND VGND VPWR VPWR _6366_/D sky130_fd_sc_hd__dlygate4sd3_1
XANTENNA__3540__S _3541_/S VGND VGND VPWR VPWR sky130_fd_sc_hd__diode_2
Xhold1663 _3879_/X VGND VGND VPWR VPWR _5860_/D sky130_fd_sc_hd__dlygate4sd3_1
XFILLER_72_623 VGND VGND VPWR VPWR sky130_fd_sc_hd__fill_2
Xhold1674 _5439_/Q VGND VGND VPWR VPWR _3378_/A1 sky130_fd_sc_hd__dlygate4sd3_1
XFILLER_45_837 VGND VGND VPWR VPWR sky130_fd_sc_hd__fill_2
XFILLER_17_517 VPWR VGND VPWR VGND sky130_ef_sc_hd__decap_40_12
XFILLER_25_561 VGND VGND VPWR VPWR sky130_fd_sc_hd__fill_4
XANTENNA__4441__B2 _4440_/X VGND VGND VPWR VPWR sky130_fd_sc_hd__diode_2
XFILLER_9_727 VGND VGND VPWR VPWR sky130_fd_sc_hd__fill_1
XFILLER_126_625 VPWR VGND VPWR VGND sky130_ef_sc_hd__decap_40_12
XTAP_TAPCELL_ROW_10_456 VGND VPWR sky130_fd_sc_hd__tapvpwrvgnd_1
XTAP_TAPCELL_ROW_10_445 VGND VPWR sky130_fd_sc_hd__tapvpwrvgnd_1
XFILLER_126_669 VPWR VGND VPWR VGND sky130_ef_sc_hd__decap_40_12
XFILLER_114_809 VGND VGND VPWR VPWR sky130_fd_sc_hd__fill_2
XFILLER_5_15 VPWR VGND VPWR VGND sky130_ef_sc_hd__decap_40_12
XFILLER_4_421 VGND VGND VPWR VPWR sky130_fd_sc_hd__fill_2
XANTENNA__3704__A0 _4961_/A0 VGND VGND VPWR VPWR sky130_fd_sc_hd__diode_2
XFILLER_4_465 VGND VGND VPWR VPWR sky130_fd_sc_hd__fill_8
XANTENNA__4894__X _4906_/S VGND VGND VPWR VPWR sky130_fd_sc_hd__diode_2
XFILLER_0_671 VGND VGND VPWR VPWR sky130_fd_sc_hd__fill_1
XANTENNA__4546__S _4547_/S VGND VGND VPWR VPWR sky130_fd_sc_hd__diode_2
XFILLER_85_61 VGND VGND VPWR VPWR sky130_fd_sc_hd__fill_2
XPHY_EDGE_ROW_13_Right_13 VGND VGND VPWR VPWR sky130_fd_sc_hd__decap_3
XANTENNA__3450__S _3450_/S VGND VGND VPWR VPWR sky130_fd_sc_hd__diode_2
XFILLER_48_697 VGND VGND VPWR VPWR sky130_fd_sc_hd__fill_1
XFILLER_47_152 VGND VGND VPWR VPWR sky130_fd_sc_hd__fill_1
XFILLER_47_141 VGND VGND VPWR VPWR sky130_fd_sc_hd__fill_1
XFILLER_36_837 VGND VGND VPWR VPWR sky130_fd_sc_hd__fill_4
X_3970_ _6387_/Q _6386_/Q _6385_/Q _6388_/Q VGND VGND VPWR VPWR _5019_/B sky130_fd_sc_hd__or4b_2
XTAP_TAPCELL_ROW_18_567 VGND VPWR sky130_fd_sc_hd__tapvpwrvgnd_1
X_2921_ _5243_/Q _6248_/Q _5408_/Q _5506_/Q _3033_/S _3050_/A VGND VGND VPWR VPWR
+ _2921_/X sky130_fd_sc_hd__mux4_1
XTAP_TAPCELL_ROW_102_1827 VGND VPWR sky130_fd_sc_hd__tapvpwrvgnd_1
XANTENNA__4432__B2 _4889_/A1 VGND VGND VPWR VPWR sky130_fd_sc_hd__diode_2
XFILLER_43_391 VGND VGND VPWR VPWR sky130_fd_sc_hd__fill_1
X_2852_ _2848_/X _2850_/X _2851_/X _3089_/C1 VGND VGND VPWR VPWR _2852_/X sky130_fd_sc_hd__a22o_1
X_5640_ _6294_/CLK _5640_/D VGND VGND VPWR VPWR _5640_/Q sky130_fd_sc_hd__dfxtp_1
XTAP_TAPCELL_ROW_135_2326 VGND VPWR sky130_fd_sc_hd__tapvpwrvgnd_1
X_2783_ _5297_/Q _5370_/Q _5358_/Q _6139_/Q _2984_/S _2985_/A VGND VGND VPWR VPWR
+ _2783_/X sky130_fd_sc_hd__mux4_1
X_5571_ _5571_/CLK _5571_/D VGND VGND VPWR VPWR _5571_/Q sky130_fd_sc_hd__dfxtp_1
XPHY_EDGE_ROW_22_Right_22 VGND VGND VPWR VPWR sky130_fd_sc_hd__decap_3
XANTENNA__2746__A1 _4886_/A1 VGND VGND VPWR VPWR sky130_fd_sc_hd__diode_2
X_4522_ hold230/X _5202_/A1 _4522_/S VGND VGND VPWR VPWR _4522_/X sky130_fd_sc_hd__mux2_1
XFILLER_117_669 VGND VGND VPWR VPWR sky130_fd_sc_hd__fill_2
XANTENNA__2841__S1 _3005_/A VGND VGND VPWR VPWR sky130_fd_sc_hd__diode_2
XFILLER_105_809 VPWR VGND VPWR VGND sky130_ef_sc_hd__decap_40_12
Xhold204 _3738_/X VGND VGND VPWR VPWR _5752_/D sky130_fd_sc_hd__dlygate4sd3_1
X_4453_ _4453_/A1 _4457_/S _4451_/Y _4452_/X VGND VGND VPWR VPWR _4453_/X sky130_fd_sc_hd__o22a_1
Xhold226 _5614_/Q VGND VGND VPWR VPWR hold226/X sky130_fd_sc_hd__dlygate4sd3_1
Xhold215 _4993_/X VGND VGND VPWR VPWR _6325_/D sky130_fd_sc_hd__dlygate4sd3_1
XFILLER_8_793 VPWR VGND VPWR VGND sky130_ef_sc_hd__decap_40_12
Xhold248 _5584_/Q VGND VGND VPWR VPWR hold248/X sky130_fd_sc_hd__dlygate4sd3_1
Xhold259 _3795_/X VGND VGND VPWR VPWR _5802_/D sky130_fd_sc_hd__dlygate4sd3_1
X_3404_ _4976_/A1 _3404_/A1 _3412_/S VGND VGND VPWR VPWR _3404_/X sky130_fd_sc_hd__mux2_1
Xhold237 _4979_/X VGND VGND VPWR VPWR _6311_/D sky130_fd_sc_hd__dlygate4sd3_1
XANTENNA__4499__A1 _5213_/A1 VGND VGND VPWR VPWR sky130_fd_sc_hd__diode_2
XFILLER_98_520 VPWR VGND VPWR VGND sky130_ef_sc_hd__decap_40_12
X_4384_ hold149/X _5829_/Q _4386_/S VGND VGND VPWR VPWR _4384_/X sky130_fd_sc_hd__mux2_1
XTAP_TAPCELL_ROW_113_1989 VGND VPWR sky130_fd_sc_hd__tapvpwrvgnd_1
X_3335_ _5329_/Q _3974_/B VGND VGND VPWR VPWR _3336_/D sky130_fd_sc_hd__or2_1
XFILLER_58_406 VGND VGND VPWR VPWR sky130_fd_sc_hd__fill_1
X_6123_ _6123_/CLK _6123_/D VGND VGND VPWR VPWR _6123_/Q sky130_fd_sc_hd__dfxtp_1
XFILLER_105_27 VPWR VGND VPWR VGND sky130_ef_sc_hd__decap_40_12
X_6054_ _6394_/CLK _6054_/D VGND VGND VPWR VPWR _6054_/Q sky130_fd_sc_hd__dfxtp_1
X_3266_ _3267_/B _4786_/S _4773_/S VGND VGND VPWR VPWR _3266_/Y sky130_fd_sc_hd__a21oi_1
XPHY_EDGE_ROW_31_Right_31 VGND VGND VPWR VPWR sky130_fd_sc_hd__decap_3
XFILLER_100_569 VPWR VGND VPWR VGND sky130_ef_sc_hd__decap_40_12
X_5005_ _5003_/A _4997_/X _4998_/Y _5018_/S VGND VGND VPWR VPWR _5005_/X sky130_fd_sc_hd__a22o_1
X_3197_ hold669/X _5228_/A0 _3206_/S VGND VGND VPWR VPWR _3197_/X sky130_fd_sc_hd__mux2_1
XFILLER_94_781 VPWR VGND VPWR VGND sky130_ef_sc_hd__decap_40_12
XFILLER_27_837 VGND VGND VPWR VPWR sky130_fd_sc_hd__fill_2
XFILLER_121_15 VPWR VGND VPWR VGND sky130_ef_sc_hd__decap_40_12
XFILLER_38_185 VGND VGND VPWR VPWR sky130_fd_sc_hd__fill_1
XFILLER_121_59 VGND VGND VPWR VPWR sky130_fd_sc_hd__fill_1
XTAP_TAPCELL_ROW_37_854 VGND VPWR sky130_fd_sc_hd__tapvpwrvgnd_1
X_5907_ _5908_/CLK _5907_/D VGND VGND VPWR VPWR _5907_/Q sky130_fd_sc_hd__dfxtp_1
X_5838_ _6065_/CLK _5838_/D VGND VGND VPWR VPWR _5838_/Q sky130_fd_sc_hd__dfxtp_1
XPHY_EDGE_ROW_40_Right_40 VGND VGND VPWR VPWR sky130_fd_sc_hd__decap_3
XFILLER_10_737 VPWR VGND VPWR VGND sky130_ef_sc_hd__decap_40_12
X_5769_ _6302_/CLK _5769_/D VGND VGND VPWR VPWR _5769_/Q sky130_fd_sc_hd__dfxtp_1
XFILLER_5_218 VGND VGND VPWR VPWR sky130_fd_sc_hd__fill_2
XANTENNA__3934__A0 _5043_/A1 VGND VGND VPWR VPWR sky130_fd_sc_hd__diode_2
XFILLER_108_669 VPWR VGND VPWR VGND sky130_ef_sc_hd__decap_40_12
XANTENNA__5136__C1 _5034_/B VGND VGND VPWR VPWR sky130_fd_sc_hd__diode_2
XFILLER_123_617 VPWR VGND VPWR VGND sky130_ef_sc_hd__decap_40_12
XANTENNA__3535__S _3541_/S VGND VGND VPWR VPWR sky130_fd_sc_hd__diode_2
XTAP_TAPCELL_ROW_75_1428 VGND VPWR sky130_fd_sc_hd__tapvpwrvgnd_1
XFILLER_135_499 VGND VGND VPWR VPWR sky130_fd_sc_hd__fill_4
Xhold760 _4897_/X VGND VGND VPWR VPWR _6245_/D sky130_fd_sc_hd__dlygate4sd3_1
XANTENNA_fanout93_A _6406_/Q VGND VGND VPWR VPWR sky130_fd_sc_hd__diode_2
Xhold782 _4400_/X VGND VGND VPWR VPWR _6038_/D sky130_fd_sc_hd__dlygate4sd3_1
Xhold771 _6000_/Q VGND VGND VPWR VPWR hold771/X sky130_fd_sc_hd__dlygate4sd3_1
Xhold793 _5371_/Q VGND VGND VPWR VPWR hold793/X sky130_fd_sc_hd__dlygate4sd3_1
XFILLER_1_446 VGND VGND VPWR VPWR sky130_fd_sc_hd__fill_2
XFILLER_39_21 VGND VGND VPWR VPWR sky130_fd_sc_hd__fill_1
XFILLER_77_726 VGND VGND VPWR VPWR sky130_fd_sc_hd__fill_2
XFILLER_76_225 VGND VGND VPWR VPWR sky130_fd_sc_hd__fill_2
XFILLER_76_214 VGND VGND VPWR VPWR sky130_fd_sc_hd__fill_4
XFILLER_39_65 VGND VGND VPWR VPWR sky130_fd_sc_hd__fill_1
Xhold2172 _5250_/Q VGND VGND VPWR VPWR _2647_/A sky130_fd_sc_hd__dlygate4sd3_1
Xhold2161 _5193_/X VGND VGND VPWR VPWR _6403_/D sky130_fd_sc_hd__dlygate4sd3_1
Xhold2150 _5842_/Q VGND VGND VPWR VPWR hold2150/X sky130_fd_sc_hd__dlygate4sd3_1
Xhold1460 _5636_/Q VGND VGND VPWR VPWR _4730_/A2 sky130_fd_sc_hd__dlygate4sd3_1
Xhold2183 _3969_/X VGND VGND VPWR VPWR _4998_/A2 sky130_fd_sc_hd__dlygate4sd3_1
Xhold2194 _5343_/Q VGND VGND VPWR VPWR _3175_/A sky130_fd_sc_hd__dlygate4sd3_1
Xhold1493 _3220_/X VGND VGND VPWR VPWR _5380_/D sky130_fd_sc_hd__dlygate4sd3_1
Xhold1482 _3744_/X VGND VGND VPWR VPWR _5758_/D sky130_fd_sc_hd__dlygate4sd3_1
XFILLER_18_837 VGND VGND VPWR VPWR sky130_fd_sc_hd__fill_4
Xhold1471 _6032_/Q VGND VGND VPWR VPWR _4393_/A1 sky130_fd_sc_hd__dlygate4sd3_1
XFILLER_44_166 VGND VGND VPWR VPWR sky130_fd_sc_hd__fill_1
XTAP_TAPCELL_ROW_15_526 VGND VPWR sky130_fd_sc_hd__tapvpwrvgnd_1
XFILLER_32_306 VGND VGND VPWR VPWR sky130_fd_sc_hd__fill_2
XFILLER_13_553 VGND VGND VPWR VPWR sky130_fd_sc_hd__fill_4
XFILLER_25_391 VGND VGND VPWR VPWR sky130_fd_sc_hd__fill_1
XFILLER_9_557 VGND VGND VPWR VPWR sky130_fd_sc_hd__fill_2
XFILLER_13_597 VPWR VGND VPWR VGND sky130_ef_sc_hd__decap_40_12
XFILLER_126_411 VGND VGND VPWR VPWR sky130_fd_sc_hd__fill_1
XTAP_TAPCELL_ROW_117_2056 VGND VPWR sky130_fd_sc_hd__tapvpwrvgnd_1
XFILLER_5_741 VPWR VGND VPWR VGND sky130_ef_sc_hd__decap_40_12
XFILLER_126_477 VPWR VGND VPWR VGND sky130_ef_sc_hd__decap_40_12
XANTENNA__3445__S _3450_/S VGND VGND VPWR VPWR sky130_fd_sc_hd__diode_2
XTAP_TAPCELL_ROW_130_2256 VGND VPWR sky130_fd_sc_hd__tapvpwrvgnd_1
XTAP_TAPCELL_ROW_130_2245 VGND VPWR sky130_fd_sc_hd__tapvpwrvgnd_1
XFILLER_5_785 VPWR VGND VPWR VGND sky130_ef_sc_hd__decap_40_12
XANTENNA__4576__S1 _4802_/A VGND VGND VPWR VPWR sky130_fd_sc_hd__diode_2
X_3120_ hold954/X _5075_/A0 _3126_/S VGND VGND VPWR VPWR _3120_/X sky130_fd_sc_hd__mux2_1
XFILLER_121_193 VGND VGND VPWR VPWR sky130_fd_sc_hd__fill_8
XFILLER_95_545 VPWR VGND VPWR VGND sky130_ef_sc_hd__decap_40_12
X_3051_ _5413_/Q _5511_/Q _3051_/S VGND VGND VPWR VPWR _3051_/X sky130_fd_sc_hd__mux2_1
XANTENNA__4653__A1 _4792_/A1 VGND VGND VPWR VPWR sky130_fd_sc_hd__diode_2
XPHY_EDGE_ROW_11_Left_150 VGND VGND VPWR VPWR sky130_fd_sc_hd__decap_3
XFILLER_51_615 VGND VGND VPWR VPWR sky130_fd_sc_hd__fill_1
XTAP_TAPCELL_ROW_34_813 VGND VPWR sky130_fd_sc_hd__tapvpwrvgnd_1
X_3953_ _5191_/B VGND VGND VPWR VPWR _3953_/Y sky130_fd_sc_hd__inv_2
X_2904_ _5420_/Q _5494_/Q _2963_/S VGND VGND VPWR VPWR _2905_/B sky130_fd_sc_hd__mux2_1
X_3884_ hold526/X _5211_/A1 _3889_/S VGND VGND VPWR VPWR _3884_/X sky130_fd_sc_hd__mux2_1
XANTENNA_clkbuf_0_clk_X clkbuf_0_clk/X VGND VGND VPWR VPWR sky130_fd_sc_hd__diode_2
XFILLER_137_709 VPWR VGND VPWR VGND sky130_ef_sc_hd__decap_40_12
X_2835_ _3036_/A1 _2834_/X _3094_/C1 VGND VGND VPWR VPWR _2835_/Y sky130_fd_sc_hd__o21ai_1
X_5623_ _6095_/CLK _5623_/D VGND VGND VPWR VPWR _5623_/Q sky130_fd_sc_hd__dfxtp_1
X_2766_ _2759_/X _2765_/X _3083_/S VGND VGND VPWR VPWR _2766_/X sky130_fd_sc_hd__mux2_1
X_5554_ _6399_/CLK _5554_/D VGND VGND VPWR VPWR _5554_/Q sky130_fd_sc_hd__dfxtp_1
XANTENNA__3208__X _3220_/S VGND VGND VPWR VPWR sky130_fd_sc_hd__diode_2
XFILLER_105_617 VPWR VGND VPWR VGND sky130_ef_sc_hd__decap_40_12
X_5485_ _6239_/CLK _5485_/D VGND VGND VPWR VPWR _5485_/Q sky130_fd_sc_hd__dfxtp_1
X_4505_ _4505_/A0 _4515_/A1 _4512_/S VGND VGND VPWR VPWR _4505_/X sky130_fd_sc_hd__mux2_1
X_2697_ _4262_/S _3128_/A VGND VGND VPWR VPWR _2697_/Y sky130_fd_sc_hd__nand2_1
XFILLER_116_15 VPWR VGND VPWR VGND sky130_ef_sc_hd__decap_40_12
X_4436_ _5234_/A0 _4445_/B _4427_/B _5747_/Q _4435_/X VGND VGND VPWR VPWR _4436_/X
+ sky130_fd_sc_hd__a221o_4
XTAP_TAPCELL_ROW_57_1158 VGND VPWR sky130_fd_sc_hd__tapvpwrvgnd_1
XANTENNA__4040__A _4241_/A VGND VGND VPWR VPWR sky130_fd_sc_hd__diode_2
X_4367_ _5038_/B _4377_/B VGND VGND VPWR VPWR _4376_/S sky130_fd_sc_hd__or2_4
XANTENNA__4892__A1 _4905_/A0 VGND VGND VPWR VPWR sky130_fd_sc_hd__diode_2
X_3318_ _5332_/Q _3318_/B VGND VGND VPWR VPWR _3318_/X sky130_fd_sc_hd__and2b_1
XTAP_TAPCELL_ROW_70_1347 VGND VPWR sky130_fd_sc_hd__tapvpwrvgnd_1
X_6106_ _6414_/CLK _6106_/D VGND VGND VPWR VPWR _6106_/Q sky130_fd_sc_hd__dfxtp_1
XFILLER_100_322 VGND VGND VPWR VPWR sky130_fd_sc_hd__fill_1
XFILLER_86_567 VGND VGND VPWR VPWR sky130_fd_sc_hd__fill_2
X_4298_ hold201/X _5053_/A1 _4304_/S VGND VGND VPWR VPWR _4298_/X sky130_fd_sc_hd__mux2_1
X_6037_ _6345_/CLK _6037_/D VGND VGND VPWR VPWR _6037_/Q sky130_fd_sc_hd__dfxtp_1
X_3249_ _3228_/B _3908_/S _3801_/A VGND VGND VPWR VPWR _3249_/Y sky130_fd_sc_hd__a21oi_1
XFILLER_39_461 VGND VGND VPWR VPWR sky130_fd_sc_hd__fill_2
XFILLER_92_29 VGND VGND VPWR VPWR sky130_fd_sc_hd__fill_8
XFILLER_82_751 VGND VGND VPWR VPWR sky130_fd_sc_hd__fill_4
XFILLER_82_784 VPWR VGND VPWR VGND sky130_ef_sc_hd__decap_40_12
XFILLER_50_670 VGND VGND VPWR VPWR sky130_fd_sc_hd__fill_1
XFILLER_10_501 VPWR VGND VPWR VGND sky130_ef_sc_hd__decap_40_12
XFILLER_50_692 VGND VGND VPWR VPWR sky130_fd_sc_hd__fill_8
XFILLER_10_545 VPWR VGND VPWR VGND sky130_ef_sc_hd__decap_40_12
XFILLER_136_753 VGND VGND VPWR VPWR sky130_fd_sc_hd__fill_2
XFILLER_10_589 VPWR VGND VPWR VGND sky130_ef_sc_hd__decap_40_12
XANTENNA__3383__A1 _5040_/A1 VGND VGND VPWR VPWR sky130_fd_sc_hd__diode_2
XFILLER_108_466 VGND VGND VPWR VPWR sky130_fd_sc_hd__fill_1
XANTENNA__5109__C1 _5034_/B VGND VGND VPWR VPWR sky130_fd_sc_hd__diode_2
XTAP_TAPCELL_ROW_20_595 VGND VPWR sky130_fd_sc_hd__tapvpwrvgnd_1
XFILLER_111_609 VGND VGND VPWR VPWR sky130_fd_sc_hd__fill_4
Xhold590 _5607_/Q VGND VGND VPWR VPWR hold590/X sky130_fd_sc_hd__dlygate4sd3_1
XANTENNA_fanout96_X _5046_/A1 VGND VGND VPWR VPWR sky130_fd_sc_hd__diode_2
XFILLER_2_755 VGND VGND VPWR VPWR sky130_fd_sc_hd__fill_1
XANTENNA__4332__A0 _5044_/A1 VGND VGND VPWR VPWR sky130_fd_sc_hd__diode_2
XANTENNA__4883__A1 _4883_/A1 VGND VGND VPWR VPWR sky130_fd_sc_hd__diode_2
XFILLER_2_27 VGND VGND VPWR VPWR sky130_fd_sc_hd__fill_1
XTAP_TAPCELL_ROW_88_1619 VGND VPWR sky130_fd_sc_hd__tapvpwrvgnd_1
XFILLER_65_729 VGND VGND VPWR VPWR sky130_fd_sc_hd__fill_8
XANTENNA__4096__S _4221_/S VGND VGND VPWR VPWR sky130_fd_sc_hd__diode_2
XFILLER_18_601 VPWR VGND VPWR VGND sky130_ef_sc_hd__decap_40_12
XFILLER_66_85 VGND VGND VPWR VPWR sky130_fd_sc_hd__fill_2
XFILLER_58_792 VPWR VGND VPWR VGND sky130_ef_sc_hd__decap_40_12
XFILLER_18_645 VPWR VGND VPWR VGND sky130_ef_sc_hd__decap_40_12
XANTENNA__4824__S _4828_/S VGND VGND VPWR VPWR sky130_fd_sc_hd__diode_2
XANTENNA__4730__S1 _4794_/A VGND VGND VPWR VPWR sky130_fd_sc_hd__diode_2
XANTENNA__3843__C1 _5200_/A VGND VGND VPWR VPWR sky130_fd_sc_hd__diode_2
Xhold1290 _3604_/X VGND VGND VPWR VPWR _5637_/D sky130_fd_sc_hd__dlygate4sd3_1
XFILLER_45_453 VGND VGND VPWR VPWR sky130_fd_sc_hd__fill_1
XFILLER_60_423 VGND VGND VPWR VPWR sky130_fd_sc_hd__fill_2
XANTENNA__4399__A0 _5052_/A1 VGND VGND VPWR VPWR sky130_fd_sc_hd__diode_2
XFILLER_33_615 VGND VGND VPWR VPWR sky130_fd_sc_hd__fill_1
XANTENNA__2949__A1 _3036_/A1 VGND VGND VPWR VPWR sky130_fd_sc_hd__diode_2
XFILLER_119_709 VPWR VGND VPWR VGND sky130_ef_sc_hd__decap_40_12
XFILLER_41_681 VGND VGND VPWR VPWR sky130_fd_sc_hd__fill_8
XFILLER_127_753 VPWR VGND VPWR VGND sky130_ef_sc_hd__decap_40_12
XPHY_EDGE_ROW_124_Right_124 VGND VGND VPWR VPWR sky130_fd_sc_hd__decap_3
XANTENNA__4797__S1 _4794_/A VGND VGND VPWR VPWR sky130_fd_sc_hd__diode_2
XFILLER_9_387 VGND VGND VPWR VPWR sky130_fd_sc_hd__fill_4
XANTENNA__3374__B2 _4906_/A0 VGND VGND VPWR VPWR sky130_fd_sc_hd__diode_2
XANTENNA__4571__B1 _4792_/A1 VGND VGND VPWR VPWR sky130_fd_sc_hd__diode_2
XFILLER_127_797 VPWR VGND VPWR VGND sky130_ef_sc_hd__decap_40_12
X_5270_ _6196_/CLK _5270_/D VGND VGND VPWR VPWR _5270_/Q sky130_fd_sc_hd__dfxtp_2
XANTENNA__3126__A1 _5237_/A0 VGND VGND VPWR VPWR sky130_fd_sc_hd__diode_2
X_4221_ _5263_/Q _6052_/Q _4221_/S VGND VGND VPWR VPWR _4222_/B sky130_fd_sc_hd__mux2_1
XTAP_TAPCELL_ROW_110_1948 VGND VPWR sky130_fd_sc_hd__tapvpwrvgnd_1
XANTENNA__4874__A1 _4887_/A1 VGND VGND VPWR VPWR sky130_fd_sc_hd__diode_2
XFILLER_68_512 VGND VGND VPWR VPWR sky130_fd_sc_hd__fill_1
X_4152_ hold570/X hold483/X _4262_/S VGND VGND VPWR VPWR _4152_/X sky130_fd_sc_hd__mux2_1
X_3103_ hold20/X _5228_/A0 _3112_/S VGND VGND VPWR VPWR hold21/A sky130_fd_sc_hd__mux2_1
XTAP_TAPCELL_ROW_52_1077 VGND VPWR sky130_fd_sc_hd__tapvpwrvgnd_1
X_4083_ _4080_/X _4081_/X _4082_/X _4149_/A VGND VGND VPWR VPWR _4083_/X sky130_fd_sc_hd__a22o_1
XFILLER_28_409 VGND VGND VPWR VPWR sky130_fd_sc_hd__fill_8
XFILLER_110_697 VGND VGND VPWR VPWR sky130_fd_sc_hd__fill_2
X_3034_ _3034_/A _3034_/B VGND VGND VPWR VPWR _3034_/Y sky130_fd_sc_hd__nor2_1
XANTENNA__5051__A1 _5051_/A1 VGND VGND VPWR VPWR sky130_fd_sc_hd__diode_2
X_4985_ hold912/X _5051_/A1 _4993_/S VGND VGND VPWR VPWR _4985_/X sky130_fd_sc_hd__mux2_1
XFILLER_51_423 VPWR VGND VPWR VGND sky130_ef_sc_hd__decap_40_12
XFILLER_23_147 VGND VGND VPWR VPWR sky130_fd_sc_hd__fill_1
XANTENNA_fanout143_A _4794_/A VGND VGND VPWR VPWR sky130_fd_sc_hd__diode_2
XANTENNA__4035__A _4251_/A VGND VGND VPWR VPWR sky130_fd_sc_hd__diode_2
X_3936_ _4982_/A1 _4191_/A1 _3938_/S VGND VGND VPWR VPWR _3936_/X sky130_fd_sc_hd__mux2_1
XFILLER_32_692 VGND VGND VPWR VPWR sky130_fd_sc_hd__fill_8
XFILLER_137_517 VPWR VGND VPWR VGND sky130_ef_sc_hd__decap_40_12
X_3867_ _3926_/A1 _3867_/A1 _3869_/S VGND VGND VPWR VPWR _5849_/D sky130_fd_sc_hd__mux2_1
X_2818_ _5539_/Q _5563_/Q _3077_/S VGND VGND VPWR VPWR _2819_/B sky130_fd_sc_hd__mux2_1
X_5606_ _5849_/CLK hold32/X VGND VGND VPWR VPWR hold31/A sky130_fd_sc_hd__dfxtp_1
X_3798_ _3801_/A _3798_/B VGND VGND VPWR VPWR _5805_/D sky130_fd_sc_hd__nor2_1
X_5537_ _6252_/CLK _5537_/D VGND VGND VPWR VPWR _5537_/Q sky130_fd_sc_hd__dfxtp_1
XFILLER_118_753 VGND VGND VPWR VPWR sky130_fd_sc_hd__fill_2
X_2749_ hold291/X _5233_/A0 _2753_/S VGND VGND VPWR VPWR _2749_/X sky130_fd_sc_hd__mux2_1
XANTENNA__3117__A1 _5228_/A0 VGND VGND VPWR VPWR sky130_fd_sc_hd__diode_2
XFILLER_78_309 VGND VGND VPWR VPWR sky130_fd_sc_hd__fill_1
X_5468_ _6290_/CLK _5468_/D VGND VGND VPWR VPWR _5468_/Q sky130_fd_sc_hd__dfxtp_1
XFILLER_87_821 VPWR VGND VPWR VGND sky130_ef_sc_hd__decap_40_12
X_4419_ _3267_/B _4676_/A _3237_/A VGND VGND VPWR VPWR _6056_/D sky130_fd_sc_hd__o21a_1
X_5399_ _6418_/CLK _5399_/D VGND VGND VPWR VPWR _5399_/Q sky130_fd_sc_hd__dfxtp_1
XFILLER_113_480 VPWR VGND VPWR VGND sky130_ef_sc_hd__decap_40_12
XFILLER_101_653 VPWR VGND VPWR VGND sky130_ef_sc_hd__decap_40_12
XFILLER_101_697 VPWR VGND VPWR VGND sky130_ef_sc_hd__decap_40_12
XFILLER_100_174 VGND VGND VPWR VPWR sky130_fd_sc_hd__fill_2
XFILLER_36_11 VGND VGND VPWR VPWR sky130_fd_sc_hd__fill_1
XFILLER_15_615 VGND VGND VPWR VPWR sky130_fd_sc_hd__fill_1
XFILLER_27_464 VPWR VGND VPWR VGND sky130_ef_sc_hd__decap_40_12
XTAP_TAPCELL_ROW_83_1549 VGND VPWR sky130_fd_sc_hd__tapvpwrvgnd_1
XTAP_TAPCELL_ROW_83_1538 VGND VPWR sky130_fd_sc_hd__tapvpwrvgnd_1
XANTENNA__5042__A1 _5042_/A1 VGND VGND VPWR VPWR sky130_fd_sc_hd__diode_2
XFILLER_42_434 VGND VGND VPWR VPWR sky130_fd_sc_hd__fill_2
XFILLER_70_765 VPWR VGND VPWR VGND sky130_ef_sc_hd__decap_40_12
XTAP_TAPCELL_ROW_25_676 VGND VPWR sky130_fd_sc_hd__tapvpwrvgnd_1
XFILLER_11_821 VPWR VGND VPWR VGND sky130_ef_sc_hd__decap_40_12
Xinput19 s_axil_wdata[1] VGND VGND VPWR VPWR input19/X sky130_fd_sc_hd__buf_1
XTAP_TAPCELL_ROW_114_2004 VGND VPWR sky130_fd_sc_hd__tapvpwrvgnd_1
XFILLER_124_701 VPWR VGND VPWR VGND sky130_ef_sc_hd__decap_40_12
XTAP_TAPCELL_ROW_114_2015 VGND VPWR sky130_fd_sc_hd__tapvpwrvgnd_1
XFILLER_109_753 VPWR VGND VPWR VGND sky130_ef_sc_hd__decap_40_12
XTAP_TAPCELL_ROW_98_1770 VGND VPWR sky130_fd_sc_hd__tapvpwrvgnd_1
XFILLER_6_346 VPWR VGND VPWR VGND sky130_ef_sc_hd__decap_40_12
XFILLER_109_797 VPWR VGND VPWR VGND sky130_ef_sc_hd__decap_40_12
XANTENNA__4798__A1_N _4791_/B1 VGND VGND VPWR VPWR sky130_fd_sc_hd__diode_2
XANTENNA__3108__A1 _5812_/Q VGND VGND VPWR VPWR sky130_fd_sc_hd__diode_2
XANTENNA__4819__S _4828_/S VGND VGND VPWR VPWR sky130_fd_sc_hd__diode_2
XFILLER_97_629 VPWR VGND VPWR VGND sky130_ef_sc_hd__decap_40_12
XFILLER_2_585 VGND VGND VPWR VPWR sky130_fd_sc_hd__fill_2
XANTENNA__4608__A1 _4791_/A1 VGND VGND VPWR VPWR sky130_fd_sc_hd__diode_2
XTAP_TAPCELL_ROW_125_2177 VGND VPWR sky130_fd_sc_hd__tapvpwrvgnd_1
XANTENNA__3959__A _3959_/A VGND VGND VPWR VPWR sky130_fd_sc_hd__diode_2
XANTENNA__4554__S _4561_/S VGND VGND VPWR VPWR sky130_fd_sc_hd__diode_2
XFILLER_93_72 VGND VGND VPWR VPWR sky130_fd_sc_hd__fill_1
XFILLER_80_529 VGND VGND VPWR VPWR sky130_fd_sc_hd__fill_1
XFILLER_18_475 VGND VGND VPWR VPWR sky130_fd_sc_hd__fill_1
XANTENNA__4407__X _4416_/S VGND VGND VPWR VPWR sky130_fd_sc_hd__diode_2
XFILLER_93_94 VGND VGND VPWR VPWR sky130_fd_sc_hd__fill_1
XFILLER_61_776 VGND VGND VPWR VPWR sky130_fd_sc_hd__fill_8
XFILLER_60_253 VGND VGND VPWR VPWR sky130_fd_sc_hd__fill_1
XTAP_TAPCELL_ROW_44_963 VGND VPWR sky130_fd_sc_hd__tapvpwrvgnd_1
XANTENNA__5033__A1 _6460_/A VGND VGND VPWR VPWR sky130_fd_sc_hd__diode_2
XANTENNA__3595__A1 _4964_/A0 VGND VGND VPWR VPWR sky130_fd_sc_hd__diode_2
XFILLER_14_681 VPWR VGND VPWR VGND sky130_ef_sc_hd__decap_40_12
X_4770_ _4663_/A _4765_/X _4767_/X _4769_/X VGND VGND VPWR VPWR _4770_/X sky130_fd_sc_hd__a22o_1
X_3721_ _4051_/A1 _5040_/A1 _3728_/S VGND VGND VPWR VPWR _3721_/X sky130_fd_sc_hd__mux2_1
X_3652_ _3652_/A0 _4517_/A1 _3657_/S VGND VGND VPWR VPWR _3652_/X sky130_fd_sc_hd__mux2_1
XFILLER_127_561 VPWR VGND VPWR VGND sky130_ef_sc_hd__decap_40_12
X_6371_ _6429_/CLK _6371_/D VGND VGND VPWR VPWR _6371_/Q sky130_fd_sc_hd__dfxtp_1
X_3583_ hold962/X _5215_/A1 _3584_/S VGND VGND VPWR VPWR _3583_/X sky130_fd_sc_hd__mux2_1
X_5322_ clkload8/A _5322_/D VGND VGND VPWR VPWR _5322_/Q sky130_fd_sc_hd__dfxtp_2
XTAP_TAPCELL_ROW_54_1117 VGND VPWR sky130_fd_sc_hd__tapvpwrvgnd_1
XTAP_TAPCELL_ROW_54_1106 VGND VPWR sky130_fd_sc_hd__tapvpwrvgnd_1
XFILLER_130_737 VPWR VGND VPWR VGND sky130_ef_sc_hd__decap_40_12
X_5253_ _6434_/CLK _5253_/D VGND VGND VPWR VPWR _5253_/Q sky130_fd_sc_hd__dfxtp_2
XANTENNA__2858__B1 _3075_/C1 VGND VGND VPWR VPWR sky130_fd_sc_hd__diode_2
X_5184_ _5182_/Y _5184_/A2 _5085_/A VGND VGND VPWR VPWR _5184_/Y sky130_fd_sc_hd__a21oi_1
XFILLER_68_331 VGND VGND VPWR VPWR sky130_fd_sc_hd__fill_1
X_4204_ _5952_/Q _6340_/Q _5934_/Q _6323_/Q _4228_/S _4263_/A VGND VGND VPWR VPWR
+ _4205_/B sky130_fd_sc_hd__mux4_1
XFILLER_84_813 VPWR VGND VPWR VGND sky130_ef_sc_hd__decap_40_12
XFILLER_3_81 VGND VGND VPWR VPWR sky130_fd_sc_hd__fill_4
X_4135_ _4135_/A0 _4135_/A1 _4250_/S VGND VGND VPWR VPWR _4136_/B sky130_fd_sc_hd__mux2_1
XFILLER_29_729 VGND VGND VPWR VPWR sky130_fd_sc_hd__fill_2
XFILLER_113_27 VPWR VGND VPWR VGND sky130_ef_sc_hd__decap_40_12
XTAP_TAPCELL_ROW_3_349 VGND VPWR sky130_fd_sc_hd__tapvpwrvgnd_1
XTAP_TAPCELL_ROW_3_338 VGND VPWR sky130_fd_sc_hd__tapvpwrvgnd_1
XFILLER_28_206 VGND VGND VPWR VPWR sky130_fd_sc_hd__fill_1
X_4066_ hold621/X hold651/X _4262_/S VGND VGND VPWR VPWR _4066_/X sky130_fd_sc_hd__mux2_1
XANTENNA__4464__S _4472_/S VGND VGND VPWR VPWR sky130_fd_sc_hd__diode_2
X_3017_ _3052_/A1 _3016_/X _3075_/C1 VGND VGND VPWR VPWR _3017_/X sky130_fd_sc_hd__o21a_1
XFILLER_24_401 VPWR VGND VPWR VGND sky130_ef_sc_hd__decap_40_12
XFILLER_24_445 VPWR VGND VPWR VGND sky130_ef_sc_hd__decap_40_12
XTAP_TAPCELL_ROW_65_1279 VGND VPWR sky130_fd_sc_hd__tapvpwrvgnd_1
XTAP_TAPCELL_ROW_65_1268 VGND VPWR sky130_fd_sc_hd__tapvpwrvgnd_1
X_4968_ _4978_/A1 _4968_/A1 _4974_/S VGND VGND VPWR VPWR _4968_/X sky130_fd_sc_hd__mux2_1
XTAP_TAPCELL_ROW_22_624 VGND VPWR sky130_fd_sc_hd__tapvpwrvgnd_1
XTAP_TAPCELL_ROW_22_635 VGND VPWR sky130_fd_sc_hd__tapvpwrvgnd_1
XFILLER_138_837 VGND VGND VPWR VPWR sky130_fd_sc_hd__fill_2
XFILLER_138_804 VGND VGND VPWR VPWR sky130_fd_sc_hd__fill_8
X_4899_ _4899_/A0 _4899_/A1 _4906_/S VGND VGND VPWR VPWR _4899_/X sky130_fd_sc_hd__mux2_1
X_3919_ _4503_/A _3919_/B VGND VGND VPWR VPWR _3928_/S sky130_fd_sc_hd__nor2_4
XANTENNA__2712__S _2716_/S VGND VGND VPWR VPWR sky130_fd_sc_hd__diode_2
XANTENNA_clkbuf_3_2__f_clk_A clkbuf_0_clk/X VGND VGND VPWR VPWR sky130_fd_sc_hd__diode_2
XFILLER_138_57 VPWR VGND VPWR VGND sky130_ef_sc_hd__decap_40_12
XFILLER_106_701 VPWR VGND VPWR VGND sky130_ef_sc_hd__decap_40_12
XFILLER_133_553 VGND VGND VPWR VPWR sky130_fd_sc_hd__fill_4
XFILLER_3_349 VPWR VGND VPWR VGND sky130_ef_sc_hd__decap_40_12
XFILLER_133_597 VPWR VGND VPWR VGND sky130_ef_sc_hd__decap_40_12
XFILLER_87_640 VGND VGND VPWR VPWR sky130_fd_sc_hd__fill_1
Xfanout130 hold2236/X VGND VGND VPWR VPWR _5233_/A0 sky130_fd_sc_hd__buf_4
Xfanout174 _2661_/A1 VGND VGND VPWR VPWR _2735_/A sky130_fd_sc_hd__buf_4
Xfanout152 _4778_/S VGND VGND VPWR VPWR _4795_/S sky130_fd_sc_hd__clkbuf_8
XFILLER_59_342 VGND VGND VPWR VPWR sky130_fd_sc_hd__fill_4
Xfanout141 _4600_/A VGND VGND VPWR VPWR _4802_/A sky130_fd_sc_hd__buf_4
Xfanout163 _4178_/A VGND VGND VPWR VPWR _4212_/A sky130_fd_sc_hd__buf_4
Xfanout196 _3033_/S VGND VGND VPWR VPWR _3091_/S sky130_fd_sc_hd__clkbuf_8
Xfanout185 _3020_/A VGND VGND VPWR VPWR _3005_/A sky130_fd_sc_hd__buf_4
XFILLER_19_217 VGND VGND VPWR VPWR sky130_fd_sc_hd__fill_1
XFILLER_90_805 VGND VGND VPWR VPWR sky130_fd_sc_hd__fill_4
XFILLER_47_559 VGND VGND VPWR VPWR sky130_fd_sc_hd__fill_1
XFILLER_15_445 VGND VGND VPWR VPWR sky130_fd_sc_hd__fill_2
XFILLER_27_294 VGND VGND VPWR VPWR sky130_fd_sc_hd__fill_1
XPHY_EDGE_ROW_69_Right_69 VGND VGND VPWR VPWR sky130_fd_sc_hd__decap_3
XFILLER_42_253 VGND VGND VPWR VPWR sky130_fd_sc_hd__fill_4
XTAP_TAPCELL_ROW_120_2096 VGND VPWR sky130_fd_sc_hd__tapvpwrvgnd_1
XFILLER_8_15 VPWR VGND VPWR VGND sky130_ef_sc_hd__decap_40_12
XTAP_TAPCELL_ROW_41_911 VGND VPWR sky130_fd_sc_hd__tapvpwrvgnd_1
XTAP_TAPCELL_ROW_41_922 VGND VPWR sky130_fd_sc_hd__tapvpwrvgnd_1
XANTENNA__3577__A1 _5209_/A1 VGND VGND VPWR VPWR sky130_fd_sc_hd__diode_2
XFILLER_129_837 VGND VGND VPWR VPWR sky130_fd_sc_hd__fill_2
XFILLER_11_673 VPWR VGND VPWR VGND sky130_ef_sc_hd__decap_40_12
XFILLER_109_561 VPWR VGND VPWR VGND sky130_ef_sc_hd__decap_40_12
XFILLER_124_531 VGND VGND VPWR VPWR sky130_fd_sc_hd__fill_1
XPHY_EDGE_ROW_78_Right_78 VGND VGND VPWR VPWR sky130_fd_sc_hd__decap_3
XANTENNA__3453__S _3463_/S VGND VGND VPWR VPWR sky130_fd_sc_hd__diode_2
XFILLER_112_737 VPWR VGND VPWR VGND sky130_ef_sc_hd__decap_40_12
XTAP_TAPCELL_ROW_127_2206 VGND VPWR sky130_fd_sc_hd__tapvpwrvgnd_1
XFILLER_78_673 VGND VGND VPWR VPWR sky130_fd_sc_hd__fill_2
XFILLER_78_640 VGND VGND VPWR VPWR sky130_fd_sc_hd__fill_4
XFILLER_66_813 VGND VGND VPWR VPWR sky130_fd_sc_hd__fill_4
XFILLER_120_781 VPWR VGND VPWR VGND sky130_ef_sc_hd__decap_40_12
XFILLER_77_183 VGND VGND VPWR VPWR sky130_fd_sc_hd__fill_2
XFILLER_93_665 VGND VGND VPWR VPWR sky130_fd_sc_hd__fill_4
XFILLER_77_194 VGND VGND VPWR VPWR sky130_fd_sc_hd__fill_1
XFILLER_92_153 VGND VGND VPWR VPWR sky130_fd_sc_hd__fill_4
XFILLER_80_304 VGND VGND VPWR VPWR sky130_fd_sc_hd__fill_1
XANTENNA__4688__S0 _4791_/A1 VGND VGND VPWR VPWR sky130_fd_sc_hd__diode_2
X_5940_ _6316_/CLK _5940_/D VGND VGND VPWR VPWR _5940_/Q sky130_fd_sc_hd__dfxtp_1
XPHY_EDGE_ROW_87_Right_87 VGND VGND VPWR VPWR sky130_fd_sc_hd__decap_3
XTAP_TAPCELL_ROW_105_1869 VGND VPWR sky130_fd_sc_hd__tapvpwrvgnd_1
X_5871_ _6094_/CLK _5871_/D VGND VGND VPWR VPWR _5871_/Q sky130_fd_sc_hd__dfxtp_1
XANTENNA__3017__B1 _3075_/C1 VGND VGND VPWR VPWR sky130_fd_sc_hd__diode_2
X_4822_ _4887_/A1 _4822_/A1 _4828_/S VGND VGND VPWR VPWR _4822_/X sky130_fd_sc_hd__mux2_1
XANTENNA__3568__A1 _4958_/A0 VGND VGND VPWR VPWR sky130_fd_sc_hd__diode_2
X_4753_ _5699_/Q _5903_/Q _4810_/S VGND VGND VPWR VPWR _4753_/X sky130_fd_sc_hd__mux2_1
XTAP_TAPCELL_ROW_138_2379 VGND VPWR sky130_fd_sc_hd__tapvpwrvgnd_1
XTAP_TAPCELL_ROW_138_2368 VGND VPWR sky130_fd_sc_hd__tapvpwrvgnd_1
X_3704_ _4961_/A0 _3704_/A1 _3707_/S VGND VGND VPWR VPWR _3704_/X sky130_fd_sc_hd__mux2_1
X_6423_ _6428_/CLK _6423_/D VGND VGND VPWR VPWR _6423_/Q sky130_fd_sc_hd__dfxtp_1
X_4684_ _6094_/Q _5874_/Q _4778_/S VGND VGND VPWR VPWR _4684_/X sky130_fd_sc_hd__mux2_1
XTAP_TAPCELL_ROW_60_1198 VGND VPWR sky130_fd_sc_hd__tapvpwrvgnd_1
XPHY_EDGE_ROW_96_Right_96 VGND VGND VPWR VPWR sky130_fd_sc_hd__decap_3
X_3635_ hold14/X _3926_/A1 _3637_/S VGND VGND VPWR VPWR hold15/A sky130_fd_sc_hd__mux2_1
XFILLER_108_27 VGND VGND VPWR VPWR sky130_fd_sc_hd__fill_1
X_6354_ _6380_/CLK _6354_/D VGND VGND VPWR VPWR _6354_/Q sky130_fd_sc_hd__dfxtp_1
X_3566_ hold991/X _4484_/A0 _3574_/S VGND VGND VPWR VPWR _3566_/X sky130_fd_sc_hd__mux2_1
XTAP_TAPCELL_ROW_8_419 VGND VPWR sky130_fd_sc_hd__tapvpwrvgnd_1
XFILLER_1_809 VPWR VGND VPWR VGND sky130_ef_sc_hd__decap_40_12
X_3497_ _4887_/A1 _3497_/A1 _3503_/S VGND VGND VPWR VPWR _3497_/X sky130_fd_sc_hd__mux2_1
X_5305_ _6429_/CLK _5305_/D VGND VGND VPWR VPWR _5305_/Q sky130_fd_sc_hd__dfxtp_1
XFILLER_115_553 VGND VGND VPWR VPWR sky130_fd_sc_hd__fill_4
XANTENNA__2768__A _3085_/A VGND VGND VPWR VPWR sky130_fd_sc_hd__diode_2
XANTENNA__3740__A1 _5232_/A0 VGND VGND VPWR VPWR sky130_fd_sc_hd__diode_2
X_6285_ _6312_/CLK _6285_/D VGND VGND VPWR VPWR _6285_/Q sky130_fd_sc_hd__dfxtp_1
XFILLER_130_545 VPWR VGND VPWR VGND sky130_ef_sc_hd__decap_40_12
X_5236_ _5815_/Q hold831/X _5237_/S VGND VGND VPWR VPWR _5236_/X sky130_fd_sc_hd__mux2_1
XFILLER_115_597 VPWR VGND VPWR VGND sky130_ef_sc_hd__decap_40_12
XFILLER_124_15 VPWR VGND VPWR VGND sky130_ef_sc_hd__decap_40_12
XANTENNA__2926__S0 _2984_/S VGND VGND VPWR VPWR sky130_fd_sc_hd__diode_2
Xhold1801 _3899_/X VGND VGND VPWR VPWR _5878_/D sky130_fd_sc_hd__dlygate4sd3_1
XFILLER_130_589 VPWR VGND VPWR VGND sky130_ef_sc_hd__decap_40_12
XFILLER_111_781 VGND VGND VPWR VPWR sky130_fd_sc_hd__fill_2
Xhold1823 _2752_/X VGND VGND VPWR VPWR _5282_/D sky130_fd_sc_hd__dlygate4sd3_1
Xhold1834 _5602_/Q VGND VGND VPWR VPWR _4790_/A0 sky130_fd_sc_hd__dlygate4sd3_1
X_5167_ _6397_/Q _5162_/B _3948_/B VGND VGND VPWR VPWR _5167_/Y sky130_fd_sc_hd__o21ai_1
Xhold1845 _5859_/Q VGND VGND VPWR VPWR _3878_/A1 sky130_fd_sc_hd__dlygate4sd3_1
Xhold1812 _5390_/Q VGND VGND VPWR VPWR _3358_/A1 sky130_fd_sc_hd__dlygate4sd3_1
Xhold1867 _5725_/Q VGND VGND VPWR VPWR _3704_/A1 sky130_fd_sc_hd__dlygate4sd3_1
X_5098_ _3999_/X _5097_/B _5096_/B _3315_/X _5096_/Y VGND VGND VPWR VPWR _5100_/A
+ sky130_fd_sc_hd__o221a_1
X_4118_ _5949_/Q _6337_/Q _5931_/Q _6320_/Q _4228_/S _4263_/A VGND VGND VPWR VPWR
+ _4119_/B sky130_fd_sc_hd__mux4_1
XPHY_EDGE_ROW_3_Left_142 VGND VGND VPWR VPWR sky130_fd_sc_hd__decap_3
Xhold1878 _4951_/X VGND VGND VPWR VPWR _6286_/D sky130_fd_sc_hd__dlygate4sd3_1
Xhold1856 _6012_/Q VGND VGND VPWR VPWR _4371_/A1 sky130_fd_sc_hd__dlygate4sd3_1
Xi2c_master_axil_212 VGND VGND VPWR VPWR i2c_master_axil_212/HI s_axil_rdata[18] sky130_fd_sc_hd__conb_1
Xhold1889 _5597_/Q VGND VGND VPWR VPWR _4651_/A0 sky130_fd_sc_hd__dlygate4sd3_1
XTAP_TAPCELL_ROW_67_1308 VGND VPWR sky130_fd_sc_hd__tapvpwrvgnd_1
XFILLER_44_529 VGND VGND VPWR VPWR sky130_fd_sc_hd__fill_2
Xi2c_master_axil_223 VGND VGND VPWR VPWR i2c_master_axil_223/HI s_axil_rdata[29] sky130_fd_sc_hd__conb_1
X_4049_ _4049_/A0 _4049_/A1 _4237_/S VGND VGND VPWR VPWR _4050_/B sky130_fd_sc_hd__mux2_1
XTAP_TAPCELL_ROW_27_705 VGND VPWR sky130_fd_sc_hd__tapvpwrvgnd_1
XFILLER_83_197 VGND VGND VPWR VPWR sky130_fd_sc_hd__fill_4
XFILLER_17_57 VGND VGND VPWR VPWR sky130_fd_sc_hd__fill_4
XFILLER_52_551 VPWR VGND VPWR VGND sky130_ef_sc_hd__decap_40_12
XFILLER_52_540 VGND VGND VPWR VPWR sky130_fd_sc_hd__fill_4
XFILLER_52_595 VGND VGND VPWR VPWR sky130_fd_sc_hd__fill_1
XFILLER_138_601 VPWR VGND VPWR VGND sky130_ef_sc_hd__decap_40_12
XFILLER_8_419 VGND VGND VPWR VPWR sky130_fd_sc_hd__fill_1
XFILLER_138_645 VPWR VGND VPWR VGND sky130_ef_sc_hd__decap_40_12
XFILLER_138_623 VGND VGND VPWR VPWR sky130_fd_sc_hd__fill_1
XANTENNA__3538__S _3541_/S VGND VGND VPWR VPWR sky130_fd_sc_hd__diode_2
XPHY_EDGE_ROW_49_Left_188 VGND VGND VPWR VPWR sky130_fd_sc_hd__decap_3
XFILLER_116_3 VPWR VGND VPWR VGND sky130_ef_sc_hd__decap_40_12
XFILLER_4_625 VPWR VGND VPWR VGND sky130_ef_sc_hd__decap_40_12
XFILLER_125_339 VGND VGND VPWR VPWR sky130_fd_sc_hd__fill_1
XFILLER_106_531 VGND VGND VPWR VPWR sky130_fd_sc_hd__fill_1
XFILLER_4_669 VPWR VGND VPWR VGND sky130_ef_sc_hd__decap_40_12
XTAP_TAPCELL_ROW_91_1659 VGND VPWR sky130_fd_sc_hd__tapvpwrvgnd_1
XFILLER_58_64 VGND VGND VPWR VPWR sky130_fd_sc_hd__fill_1
XANTENNA__3495__A0 _4846_/A0 VGND VGND VPWR VPWR sky130_fd_sc_hd__diode_2
XFILLER_102_781 VPWR VGND VPWR VGND sky130_ef_sc_hd__decap_40_12
Xhold8 hold8/A VGND VGND VPWR VPWR hold8/X sky130_fd_sc_hd__dlygate4sd3_1
XFILLER_59_172 VGND VGND VPWR VPWR sky130_fd_sc_hd__fill_1
XPHY_EDGE_ROW_58_Left_197 VGND VGND VPWR VPWR sky130_fd_sc_hd__decap_3
XFILLER_48_813 VPWR VGND VPWR VGND sky130_ef_sc_hd__decap_40_12
XFILLER_74_131 VGND VGND VPWR VPWR sky130_fd_sc_hd__fill_1
XFILLER_74_120 VGND VGND VPWR VPWR sky130_fd_sc_hd__fill_1
XFILLER_47_345 VGND VGND VPWR VPWR sky130_fd_sc_hd__fill_1
XTAP_TAPCELL_ROW_122_2125 VGND VPWR sky130_fd_sc_hd__tapvpwrvgnd_1
XFILLER_90_613 VPWR VGND VPWR VGND sky130_ef_sc_hd__decap_40_12
XFILLER_74_41 VGND VGND VPWR VPWR sky130_fd_sc_hd__fill_2
XTAP_TAPCELL_ROW_122_2136 VGND VPWR sky130_fd_sc_hd__tapvpwrvgnd_1
XFILLER_90_657 VPWR VGND VPWR VGND sky130_ef_sc_hd__decap_40_12
XFILLER_74_186 VGND VGND VPWR VPWR sky130_fd_sc_hd__fill_4
XFILLER_62_326 VGND VGND VPWR VPWR sky130_fd_sc_hd__fill_4
XANTENNA__4832__S _4841_/S VGND VGND VPWR VPWR sky130_fd_sc_hd__diode_2
XFILLER_31_724 VGND VGND VPWR VPWR sky130_fd_sc_hd__fill_4
XFILLER_31_757 VPWR VGND VPWR VGND sky130_ef_sc_hd__decap_40_12
XANTENNA__3448__S _3450_/S VGND VGND VPWR VPWR sky130_fd_sc_hd__diode_2
XTAP_TAPCELL_ROW_100_1799 VGND VPWR sky130_fd_sc_hd__tapvpwrvgnd_1
XFILLER_7_441 VGND VGND VPWR VPWR sky130_fd_sc_hd__fill_4
XTAP_TAPCELL_ROW_13_498 VGND VPWR sky130_fd_sc_hd__tapvpwrvgnd_1
Xhold408 _3479_/X VGND VGND VPWR VPWR _5525_/D sky130_fd_sc_hd__dlygate4sd3_1
XFILLER_7_485 VPWR VGND VPWR VGND sky130_ef_sc_hd__decap_40_12
Xhold419 _5873_/Q VGND VGND VPWR VPWR hold419/X sky130_fd_sc_hd__dlygate4sd3_1
X_3420_ hold606/X _4961_/A0 _3423_/S VGND VGND VPWR VPWR _3420_/X sky130_fd_sc_hd__mux2_1
XANTENNA__4420__X _4420_/X VGND VGND VPWR VPWR sky130_fd_sc_hd__diode_2
XTAP_TAPCELL_ROW_133_2298 VGND VPWR sky130_fd_sc_hd__tapvpwrvgnd_1
XFILLER_98_713 VPWR VGND VPWR VGND sky130_ef_sc_hd__decap_40_12
X_3351_ _3351_/A0 _3350_/X _3365_/S VGND VGND VPWR VPWR _3351_/X sky130_fd_sc_hd__mux2_1
XANTENNA__3722__A1 _4978_/A1 VGND VGND VPWR VPWR sky130_fd_sc_hd__diode_2
XFILLER_98_757 VPWR VGND VPWR VGND sky130_ef_sc_hd__decap_40_12
XANTENNA_hold2238_A _5816_/Q VGND VGND VPWR VPWR sky130_fd_sc_hd__diode_2
X_6070_ _6366_/CLK _6070_/D VGND VGND VPWR VPWR _6070_/Q sky130_fd_sc_hd__dfxtp_1
XFILLER_112_545 VPWR VGND VPWR VGND sky130_ef_sc_hd__decap_40_12
X_3282_ _3228_/A _3279_/B _3281_/Y VGND VGND VPWR VPWR _3282_/X sky130_fd_sc_hd__o21a_1
Xhold1119 _3468_/X VGND VGND VPWR VPWR _5515_/D sky130_fd_sc_hd__dlygate4sd3_1
XFILLER_112_589 VPWR VGND VPWR VGND sky130_ef_sc_hd__decap_40_12
Xhold1108 _5575_/Q VGND VGND VPWR VPWR _3532_/A0 sky130_fd_sc_hd__dlygate4sd3_1
XFILLER_97_278 VGND VGND VPWR VPWR sky130_fd_sc_hd__fill_2
XANTENNA__2908__S0 _2963_/S VGND VGND VPWR VPWR sky130_fd_sc_hd__diode_2
XFILLER_78_481 VGND VGND VPWR VPWR sky130_fd_sc_hd__fill_1
X_5021_ _6329_/Q _6327_/Q _6360_/Q VGND VGND VPWR VPWR _5021_/X sky130_fd_sc_hd__and3b_1
XTAP_TAPCELL_ROW_107_1909 VGND VPWR sky130_fd_sc_hd__tapvpwrvgnd_1
XFILLER_66_698 VGND VGND VPWR VPWR sky130_fd_sc_hd__fill_2
XFILLER_65_164 VGND VGND VPWR VPWR sky130_fd_sc_hd__fill_4
XTAP_TAPCELL_ROW_49_1038 VGND VPWR sky130_fd_sc_hd__tapvpwrvgnd_1
XANTENNA__3789__A1 _5208_/A1 VGND VGND VPWR VPWR sky130_fd_sc_hd__diode_2
XFILLER_53_359 VGND VGND VPWR VPWR sky130_fd_sc_hd__fill_4
X_5923_ clkload9/A _5923_/D VGND VGND VPWR VPWR _5923_/Q sky130_fd_sc_hd__dfxtp_1
X_5854_ _6097_/CLK _5854_/D VGND VGND VPWR VPWR _5854_/Q sky130_fd_sc_hd__dfxtp_1
XTAP_TAPCELL_ROW_62_1227 VGND VPWR sky130_fd_sc_hd__tapvpwrvgnd_1
XFILLER_22_713 VPWR VGND VPWR VGND sky130_ef_sc_hd__decap_40_12
XFILLER_22_757 VPWR VGND VPWR VGND sky130_ef_sc_hd__decap_40_12
X_4805_ _5804_/Q _5795_/Q _6125_/Q _6116_/Q _4803_/S _4802_/A VGND VGND VPWR VPWR
+ _4805_/X sky130_fd_sc_hd__mux4_1
X_2997_ _5423_/Q _5497_/Q _5353_/Q _5581_/Q _2963_/S _2962_/A VGND VGND VPWR VPWR
+ _2998_/B sky130_fd_sc_hd__mux4_1
X_5785_ _6310_/CLK _5785_/D VGND VGND VPWR VPWR _5785_/Q sky130_fd_sc_hd__dfxtp_1
XANTENNA__3410__A0 _4982_/A1 VGND VGND VPWR VPWR sky130_fd_sc_hd__diode_2
XTAP_TAPCELL_ROW_32_774 VGND VPWR sky130_fd_sc_hd__tapvpwrvgnd_1
XTAP_TAPCELL_ROW_32_785 VGND VPWR sky130_fd_sc_hd__tapvpwrvgnd_1
XFILLER_119_15 VPWR VGND VPWR VGND sky130_ef_sc_hd__decap_40_12
X_4736_ _5867_/Q _5858_/Q _4795_/S VGND VGND VPWR VPWR _4737_/B sky130_fd_sc_hd__mux2_1
XFILLER_135_615 VGND VGND VPWR VPWR sky130_fd_sc_hd__fill_1
XFILLER_119_188 VGND VGND VPWR VPWR sky130_fd_sc_hd__fill_4
X_4667_ _4811_/A1 _4666_/X _4665_/X _4811_/C1 VGND VGND VPWR VPWR _4667_/X sky130_fd_sc_hd__o211a_1
XANTENNA_fanout109_X _5052_/A1 VGND VGND VPWR VPWR sky130_fd_sc_hd__diode_2
X_6406_ _6418_/CLK _6406_/D VGND VGND VPWR VPWR _6406_/Q sky130_fd_sc_hd__dfxtp_1
X_3618_ _4513_/A _3648_/B VGND VGND VPWR VPWR _3627_/S sky130_fd_sc_hd__nor2_4
Xhold931 _3916_/X VGND VGND VPWR VPWR _5894_/D sky130_fd_sc_hd__dlygate4sd3_1
Xhold920 _5446_/Q VGND VGND VPWR VPWR hold920/X sky130_fd_sc_hd__dlygate4sd3_1
XFILLER_115_350 VGND VGND VPWR VPWR sky130_fd_sc_hd__fill_1
XFILLER_89_702 VGND VGND VPWR VPWR sky130_fd_sc_hd__fill_1
Xhold942 _5867_/Q VGND VGND VPWR VPWR hold942/X sky130_fd_sc_hd__dlygate4sd3_1
X_6337_ _6338_/CLK _6337_/D VGND VGND VPWR VPWR _6337_/Q sky130_fd_sc_hd__dfxtp_1
X_4598_ _6100_/Q _5889_/Q _6082_/Q _5880_/Q _4803_/S _4600_/A VGND VGND VPWR VPWR
+ _4598_/X sky130_fd_sc_hd__mux4_1
XFILLER_1_617 VPWR VGND VPWR VGND sky130_ef_sc_hd__decap_40_12
Xhold953 _3762_/X VGND VGND VPWR VPWR _5773_/D sky130_fd_sc_hd__dlygate4sd3_1
XANTENNA__3713__A1 _5043_/A1 VGND VGND VPWR VPWR sky130_fd_sc_hd__diode_2
Xhold964 _5904_/Q VGND VGND VPWR VPWR hold964/X sky130_fd_sc_hd__dlygate4sd3_1
XFILLER_131_821 VPWR VGND VPWR VGND sky130_ef_sc_hd__decap_40_12
Xhold997 _3205_/X VGND VGND VPWR VPWR _5367_/D sky130_fd_sc_hd__dlygate4sd3_1
X_3549_ _3549_/A0 _4961_/A0 _3552_/S VGND VGND VPWR VPWR _3549_/X sky130_fd_sc_hd__mux2_1
Xhold975 _5797_/Q VGND VGND VPWR VPWR hold975/X sky130_fd_sc_hd__dlygate4sd3_1
Xhold986 _5465_/Q VGND VGND VPWR VPWR hold986/X sky130_fd_sc_hd__dlygate4sd3_1
XTAP_TAPCELL_ROW_73_1389 VGND VPWR sky130_fd_sc_hd__tapvpwrvgnd_1
XFILLER_0_138 VGND VGND VPWR VPWR sky130_fd_sc_hd__fill_2
X_6268_ clkload9/A _6268_/D VGND VGND VPWR VPWR _6268_/Q sky130_fd_sc_hd__dfxtp_1
XANTENNA__3477__A0 _4906_/A0 VGND VGND VPWR VPWR sky130_fd_sc_hd__diode_2
X_6199_ _6199_/CLK _6199_/D VGND VGND VPWR VPWR _6199_/Q sky130_fd_sc_hd__dfxtp_1
X_5219_ _5219_/A _5219_/B VGND VGND VPWR VPWR _5219_/Y sky130_fd_sc_hd__nand2_1
XFILLER_130_397 VGND VGND VPWR VPWR sky130_fd_sc_hd__fill_1
Xhold1620 _6208_/Q VGND VGND VPWR VPWR _4857_/A1 sky130_fd_sc_hd__dlygate4sd3_1
Xhold1642 _5622_/Q VGND VGND VPWR VPWR _3588_/A0 sky130_fd_sc_hd__dlygate4sd3_1
Xhold1631 _5458_/Q VGND VGND VPWR VPWR _3401_/A0 sky130_fd_sc_hd__dlygate4sd3_1
Xhold1653 _4971_/X VGND VGND VPWR VPWR _6304_/D sky130_fd_sc_hd__dlygate4sd3_1
XANTENNA_clkbuf_leaf_84_clk_A clkload1/A VGND VGND VPWR VPWR sky130_fd_sc_hd__diode_2
XFILLER_29_345 VGND VGND VPWR VPWR sky130_fd_sc_hd__fill_4
Xhold1686 _3520_/X VGND VGND VPWR VPWR _5563_/D sky130_fd_sc_hd__dlygate4sd3_1
Xhold1664 _6198_/Q VGND VGND VPWR VPWR _4846_/A1 sky130_fd_sc_hd__dlygate4sd3_1
Xhold1675 _3378_/X VGND VGND VPWR VPWR _5439_/D sky130_fd_sc_hd__dlygate4sd3_1
XFILLER_17_529 VPWR VGND VPWR VGND sky130_ef_sc_hd__decap_40_12
Xhold1697 _5851_/Q VGND VGND VPWR VPWR _3869_/A1 sky130_fd_sc_hd__dlygate4sd3_1
XFILLER_44_348 VGND VGND VPWR VPWR sky130_fd_sc_hd__fill_1
XANTENNA__4441__A2 _4457_/S VGND VGND VPWR VPWR sky130_fd_sc_hd__diode_2
XANTENNA_clkbuf_leaf_99_clk_A clkload0/A VGND VGND VPWR VPWR sky130_fd_sc_hd__diode_2
XFILLER_40_543 VGND VGND VPWR VPWR sky130_fd_sc_hd__fill_1
XANTENNA_clkbuf_leaf_22_clk_A clkload3/A VGND VGND VPWR VPWR sky130_fd_sc_hd__diode_2
XFILLER_138_475 VGND VGND VPWR VPWR sky130_fd_sc_hd__fill_1
XFILLER_126_637 VGND VGND VPWR VPWR sky130_fd_sc_hd__fill_4
XTAP_TAPCELL_ROW_10_457 VGND VPWR sky130_fd_sc_hd__tapvpwrvgnd_1
XTAP_TAPCELL_ROW_10_446 VGND VPWR sky130_fd_sc_hd__tapvpwrvgnd_1
XFILLER_5_27 VPWR VGND VPWR VGND sky130_ef_sc_hd__decap_40_12
XANTENNA_clkbuf_leaf_37_clk_A clkload4/A VGND VGND VPWR VPWR sky130_fd_sc_hd__diode_2
XANTENNA__4901__A0 _4901_/A0 VGND VGND VPWR VPWR sky130_fd_sc_hd__diode_2
XFILLER_4_477 VPWR VGND VPWR VGND sky130_ef_sc_hd__decap_40_12
XFILLER_134_681 VPWR VGND VPWR VGND sky130_ef_sc_hd__decap_40_12
XFILLER_79_223 VGND VGND VPWR VPWR sky130_fd_sc_hd__fill_1
XFILLER_69_74 VGND VGND VPWR VPWR sky130_fd_sc_hd__fill_1
XFILLER_69_52 VGND VGND VPWR VPWR sky130_fd_sc_hd__fill_1
XPHY_EDGE_ROW_66_Left_205 VGND VGND VPWR VPWR sky130_fd_sc_hd__decap_3
XANTENNA__3468__A0 _4445_/A VGND VGND VPWR VPWR sky130_fd_sc_hd__diode_2
XANTENNA__4827__S _4828_/S VGND VGND VPWR VPWR sky130_fd_sc_hd__diode_2
XFILLER_95_727 VGND VGND VPWR VPWR sky130_fd_sc_hd__fill_1
XFILLER_85_51 VGND VGND VPWR VPWR sky130_fd_sc_hd__fill_4
XANTENNA__5209__A1 _5209_/A1 VGND VGND VPWR VPWR sky130_fd_sc_hd__diode_2
XANTENNA_clkload1_A clkload1/A VGND VGND VPWR VPWR sky130_fd_sc_hd__diode_2
XANTENNA__4968__A0 _4978_/A1 VGND VGND VPWR VPWR sky130_fd_sc_hd__diode_2
XTAP_TAPCELL_ROW_18_568 VGND VPWR sky130_fd_sc_hd__tapvpwrvgnd_1
XANTENNA__2871__A _3044_/A VGND VGND VPWR VPWR sky130_fd_sc_hd__diode_2
X_2920_ _3036_/A1 _2919_/X _3094_/C1 VGND VGND VPWR VPWR _2920_/X sky130_fd_sc_hd__o21a_1
XTAP_TAPCELL_ROW_102_1828 VGND VPWR sky130_fd_sc_hd__tapvpwrvgnd_1
XANTENNA__4432__A2 _4994_/B VGND VGND VPWR VPWR sky130_fd_sc_hd__diode_2
XPHY_EDGE_ROW_75_Left_214 VGND VGND VPWR VPWR sky130_fd_sc_hd__decap_3
X_2851_ _6129_/Q _5552_/Q _5751_/Q _5275_/Q _2963_/S _2962_/A VGND VGND VPWR VPWR
+ _2851_/X sky130_fd_sc_hd__mux4_1
XANTENNA_hold2090_A _6414_/Q VGND VGND VPWR VPWR sky130_fd_sc_hd__diode_2
XTAP_TAPCELL_ROW_135_2327 VGND VPWR sky130_fd_sc_hd__tapvpwrvgnd_1
XFILLER_129_453 VGND VGND VPWR VPWR sky130_fd_sc_hd__fill_1
X_5570_ _5571_/CLK _5570_/D VGND VGND VPWR VPWR _5570_/Q sky130_fd_sc_hd__dfxtp_1
X_2782_ hold2/X _3011_/A _2781_/X VGND VGND VPWR VPWR hold3/A sky130_fd_sc_hd__a21o_1
XANTENNA_hold2188_A _5840_/Q VGND VGND VPWR VPWR sky130_fd_sc_hd__diode_2
XFILLER_117_615 VGND VGND VPWR VPWR sky130_fd_sc_hd__fill_1
X_4521_ _4521_/A0 _4521_/A1 _4522_/S VGND VGND VPWR VPWR _4521_/X sky130_fd_sc_hd__mux2_1
Xhold216 _5418_/Q VGND VGND VPWR VPWR hold216/X sky130_fd_sc_hd__dlygate4sd3_1
Xhold205 _5416_/Q VGND VGND VPWR VPWR hold205/X sky130_fd_sc_hd__dlygate4sd3_1
X_4452_ _6259_/Q _3366_/X _4445_/B _4882_/A1 _3801_/B VGND VGND VPWR VPWR _4452_/X
+ sky130_fd_sc_hd__a221o_1
Xhold249 _3541_/X VGND VGND VPWR VPWR _5584_/D sky130_fd_sc_hd__dlygate4sd3_1
Xhold227 _3578_/X VGND VGND VPWR VPWR _5614_/D sky130_fd_sc_hd__dlygate4sd3_1
XANTENNA__4043__S1 _4241_/A VGND VGND VPWR VPWR sky130_fd_sc_hd__diode_2
X_3403_ _3708_/B _5038_/B VGND VGND VPWR VPWR _3412_/S sky130_fd_sc_hd__or2_4
Xhold238 _5719_/Q VGND VGND VPWR VPWR hold238/X sky130_fd_sc_hd__dlygate4sd3_1
XFILLER_113_821 VPWR VGND VPWR VGND sky130_ef_sc_hd__decap_40_12
XPHY_EDGE_ROW_84_Left_223 VGND VGND VPWR VPWR sky130_fd_sc_hd__decap_3
X_4383_ hold681/X _4981_/A1 _4386_/S VGND VGND VPWR VPWR _4383_/X sky130_fd_sc_hd__mux2_1
X_3334_ _3975_/A _3975_/C _3964_/B _2624_/A VGND VGND VPWR VPWR _3974_/B sky130_fd_sc_hd__or4b_2
X_6122_ _6122_/CLK _6122_/D VGND VGND VPWR VPWR _6122_/Q sky130_fd_sc_hd__dfxtp_1
XFILLER_105_39 VGND VGND VPWR VPWR sky130_fd_sc_hd__fill_1
XFILLER_98_587 VGND VGND VPWR VPWR sky130_fd_sc_hd__fill_1
XFILLER_86_738 VGND VGND VPWR VPWR sky130_fd_sc_hd__fill_1
X_3265_ _3265_/A _3265_/B VGND VGND VPWR VPWR _4786_/S sky130_fd_sc_hd__nand2_2
X_6053_ _6345_/CLK _6053_/D VGND VGND VPWR VPWR _6053_/Q sky130_fd_sc_hd__dfxtp_1
X_5004_ _5006_/B _5004_/B VGND VGND VPWR VPWR _5018_/S sky130_fd_sc_hd__nand2_1
X_3196_ hold892/X _5820_/Q _3206_/S VGND VGND VPWR VPWR _3196_/X sky130_fd_sc_hd__mux2_1
XFILLER_94_793 VPWR VGND VPWR VGND sky130_ef_sc_hd__decap_40_12
XFILLER_93_281 VGND VGND VPWR VPWR sky130_fd_sc_hd__fill_4
XFILLER_121_27 VPWR VGND VPWR VGND sky130_ef_sc_hd__decap_40_12
XANTENNA__4959__A0 _5211_/A1 VGND VGND VPWR VPWR sky130_fd_sc_hd__diode_2
XTAP_TAPCELL_ROW_37_855 VGND VPWR sky130_fd_sc_hd__tapvpwrvgnd_1
XPHY_EDGE_ROW_138_Right_138 VGND VGND VPWR VPWR sky130_fd_sc_hd__decap_3
XANTENNA__4472__S _4472_/S VGND VGND VPWR VPWR sky130_fd_sc_hd__diode_2
XPHY_EDGE_ROW_93_Left_232 VGND VGND VPWR VPWR sky130_fd_sc_hd__decap_3
X_5906_ _6310_/CLK _5906_/D VGND VGND VPWR VPWR _5906_/Q sky130_fd_sc_hd__dfxtp_1
XFILLER_50_841 VGND VGND VPWR VPWR sky130_fd_sc_hd__fill_1
X_5837_ _6065_/CLK _5837_/D VGND VGND VPWR VPWR _5837_/Q sky130_fd_sc_hd__dfxtp_1
XFILLER_22_587 VGND VGND VPWR VPWR sky130_fd_sc_hd__fill_1
XFILLER_10_749 VGND VGND VPWR VPWR sky130_fd_sc_hd__fill_4
X_5768_ _6307_/CLK _5768_/D VGND VGND VPWR VPWR _5768_/Q sky130_fd_sc_hd__dfxtp_1
XANTENNA__4187__B2 _4252_/B1 VGND VGND VPWR VPWR sky130_fd_sc_hd__diode_2
X_4719_ _4811_/A1 _4716_/X _4811_/C1 VGND VGND VPWR VPWR _4719_/X sky130_fd_sc_hd__o21a_1
XTAP_TAPCELL_ROW_75_1418 VGND VPWR sky130_fd_sc_hd__tapvpwrvgnd_1
X_5699_ _6120_/CLK _5699_/D VGND VGND VPWR VPWR _5699_/Q sky130_fd_sc_hd__dfxtp_1
XFILLER_123_629 VPWR VGND VPWR VGND sky130_ef_sc_hd__decap_40_12
XTAP_TAPCELL_ROW_75_1429 VGND VPWR sky130_fd_sc_hd__tapvpwrvgnd_1
XFILLER_122_128 VGND VGND VPWR VPWR sky130_fd_sc_hd__fill_1
XFILLER_116_681 VPWR VGND VPWR VGND sky130_ef_sc_hd__decap_40_12
Xhold750 _4339_/X VGND VGND VPWR VPWR _5984_/D sky130_fd_sc_hd__dlygate4sd3_1
Xhold772 _4358_/X VGND VGND VPWR VPWR _6000_/D sky130_fd_sc_hd__dlygate4sd3_1
Xhold761 _5881_/Q VGND VGND VPWR VPWR hold761/X sky130_fd_sc_hd__dlygate4sd3_1
Xhold794 _3211_/X VGND VGND VPWR VPWR _5371_/D sky130_fd_sc_hd__dlygate4sd3_1
XFILLER_103_320 VGND VGND VPWR VPWR sky130_fd_sc_hd__fill_1
Xhold783 _6223_/Q VGND VGND VPWR VPWR hold783/X sky130_fd_sc_hd__dlygate4sd3_1
XANTENNA__5035__C _5035_/C VGND VGND VPWR VPWR sky130_fd_sc_hd__diode_2
XANTENNA_fanout86_A _5210_/A1 VGND VGND VPWR VPWR sky130_fd_sc_hd__diode_2
XFILLER_131_673 VPWR VGND VPWR VGND sky130_ef_sc_hd__decap_40_12
XFILLER_39_55 VGND VGND VPWR VPWR sky130_fd_sc_hd__fill_1
Xhold2162 _5254_/Q VGND VGND VPWR VPWR _2688_/A sky130_fd_sc_hd__dlygate4sd3_1
Xhold2173 _2678_/X VGND VGND VPWR VPWR _2679_/B sky130_fd_sc_hd__dlygate4sd3_1
Xhold2140 _5180_/X VGND VGND VPWR VPWR _6400_/D sky130_fd_sc_hd__dlygate4sd3_1
Xhold2151 _3858_/X VGND VGND VPWR VPWR _3859_/B sky130_fd_sc_hd__dlygate4sd3_1
Xhold1461 _3603_/X VGND VGND VPWR VPWR _5636_/D sky130_fd_sc_hd__dlygate4sd3_1
Xhold2195 _5834_/Q VGND VGND VPWR VPWR _3840_/A sky130_fd_sc_hd__dlygate4sd3_1
Xhold2184 _4998_/Y VGND VGND VPWR VPWR _4999_/A0 sky130_fd_sc_hd__dlygate4sd3_1
Xhold1450 _4937_/X VGND VGND VPWR VPWR _6273_/D sky130_fd_sc_hd__dlygate4sd3_1
XFILLER_18_805 VGND VGND VPWR VPWR sky130_fd_sc_hd__fill_4
XANTENNA__2673__A1 _4903_/A0 VGND VGND VPWR VPWR sky130_fd_sc_hd__diode_2
Xhold1494 _5578_/Q VGND VGND VPWR VPWR _3535_/A0 sky130_fd_sc_hd__dlygate4sd3_1
XFILLER_72_421 VGND VGND VPWR VPWR sky130_fd_sc_hd__fill_4
Xhold1472 _4393_/X VGND VGND VPWR VPWR _6032_/D sky130_fd_sc_hd__dlygate4sd3_1
Xhold1483 _5652_/Q VGND VGND VPWR VPWR _3623_/A0 sky130_fd_sc_hd__dlygate4sd3_1
XPHY_EDGE_ROW_105_Right_105 VGND VGND VPWR VPWR sky130_fd_sc_hd__decap_3
XFILLER_71_31 VGND VGND VPWR VPWR sky130_fd_sc_hd__fill_1
XTAP_TAPCELL_ROW_15_527 VGND VPWR sky130_fd_sc_hd__tapvpwrvgnd_1
XFILLER_41_841 VGND VGND VPWR VPWR sky130_fd_sc_hd__fill_1
XFILLER_9_503 VGND VGND VPWR VPWR sky130_fd_sc_hd__fill_1
XTAP_TAPCELL_ROW_117_2057 VGND VPWR sky130_fd_sc_hd__tapvpwrvgnd_1
XANTENNA__3925__A1 _5213_/A1 VGND VGND VPWR VPWR sky130_fd_sc_hd__diode_2
XFILLER_138_294 VGND VGND VPWR VPWR sky130_fd_sc_hd__fill_1
XFILLER_126_434 VGND VGND VPWR VPWR sky130_fd_sc_hd__fill_1
XFILLER_126_423 VGND VGND VPWR VPWR sky130_fd_sc_hd__fill_1
XFILLER_5_753 VPWR VGND VPWR VGND sky130_ef_sc_hd__decap_40_12
XTAP_TAPCELL_ROW_130_2257 VGND VPWR sky130_fd_sc_hd__tapvpwrvgnd_1
XTAP_TAPCELL_ROW_130_2246 VGND VPWR sky130_fd_sc_hd__tapvpwrvgnd_1
XFILLER_126_489 VPWR VGND VPWR VGND sky130_ef_sc_hd__decap_40_12
XANTENNA__3027__A _3027_/A VGND VGND VPWR VPWR sky130_fd_sc_hd__diode_2
XFILLER_5_797 VPWR VGND VPWR VGND sky130_ef_sc_hd__decap_40_12
XANTENNA__4350__A1 _5053_/A1 VGND VGND VPWR VPWR sky130_fd_sc_hd__diode_2
XFILLER_110_813 VPWR VGND VPWR VGND sky130_ef_sc_hd__decap_40_12
XANTENNA__4557__S _4561_/S VGND VGND VPWR VPWR sky130_fd_sc_hd__diode_2
XFILLER_67_215 VGND VGND VPWR VPWR sky130_fd_sc_hd__fill_1
XANTENNA__3461__S _3463_/S VGND VGND VPWR VPWR sky130_fd_sc_hd__diode_2
X_3050_ _3050_/A _3050_/B VGND VGND VPWR VPWR _3050_/X sky130_fd_sc_hd__or2_1
XFILLER_95_557 VGND VGND VPWR VPWR sky130_fd_sc_hd__fill_2
XANTENNA__3038__A1_N _3096_/A1 VGND VGND VPWR VPWR sky130_fd_sc_hd__diode_2
XFILLER_75_281 VGND VGND VPWR VPWR sky130_fd_sc_hd__fill_4
XANTENNA__3861__A0 _6410_/Q VGND VGND VPWR VPWR sky130_fd_sc_hd__diode_2
XFILLER_48_473 VGND VGND VPWR VPWR sky130_fd_sc_hd__fill_2
XFILLER_91_741 VPWR VGND VPWR VGND sky130_ef_sc_hd__decap_40_12
XANTENNA__2805__S _3091_/S VGND VGND VPWR VPWR sky130_fd_sc_hd__diode_2
XFILLER_91_785 VPWR VGND VPWR VGND sky130_ef_sc_hd__decap_40_12
Xclkbuf_leaf_109_clk clkload0/A VGND VGND VPWR VPWR _5908_/CLK sky130_fd_sc_hd__clkbuf_8
XANTENNA__4292__S _4294_/S VGND VGND VPWR VPWR sky130_fd_sc_hd__diode_2
XTAP_TAPCELL_ROW_34_803 VGND VPWR sky130_fd_sc_hd__tapvpwrvgnd_1
XTAP_TAPCELL_ROW_34_814 VGND VPWR sky130_fd_sc_hd__tapvpwrvgnd_1
X_3952_ _3952_/A _3952_/B _3952_/C _3952_/D VGND VGND VPWR VPWR _5191_/B sky130_fd_sc_hd__or4_2
XFILLER_50_137 VGND VGND VPWR VPWR sky130_fd_sc_hd__fill_1
XFILLER_32_841 VGND VGND VPWR VPWR sky130_fd_sc_hd__fill_1
X_2903_ _3094_/C1 _2898_/X _2900_/X _2902_/X VGND VGND VPWR VPWR _2903_/X sky130_fd_sc_hd__a22o_1
X_3883_ _3883_/A0 _4958_/A0 _3889_/S VGND VGND VPWR VPWR _3883_/X sky130_fd_sc_hd__mux2_1
X_2834_ _6152_/Q _6221_/Q _3077_/S VGND VGND VPWR VPWR _2834_/X sky130_fd_sc_hd__mux2_1
X_5622_ _5898_/CLK _5622_/D VGND VGND VPWR VPWR _5622_/Q sky130_fd_sc_hd__dfxtp_1
XANTENNA__4169__B2 _4271_/S1 VGND VGND VPWR VPWR sky130_fd_sc_hd__diode_2
X_5553_ _6137_/CLK _5553_/D VGND VGND VPWR VPWR _5553_/Q sky130_fd_sc_hd__dfxtp_1
XANTENNA__3377__C1 _3801_/B VGND VGND VPWR VPWR sky130_fd_sc_hd__diode_2
XANTENNA__3916__A1 _5214_/A1 VGND VGND VPWR VPWR sky130_fd_sc_hd__diode_2
X_2765_ _2761_/X _2763_/X _2764_/X _2641_/Y VGND VGND VPWR VPWR _2765_/X sky130_fd_sc_hd__a22o_1
X_4504_ _4580_/A1 _5208_/A1 _4512_/S VGND VGND VPWR VPWR _4504_/X sky130_fd_sc_hd__mux2_1
X_5484_ _6239_/CLK _5484_/D VGND VGND VPWR VPWR _5484_/Q sky130_fd_sc_hd__dfxtp_1
X_2696_ _4263_/A _5321_/Q VGND VGND VPWR VPWR _2696_/X sky130_fd_sc_hd__xor2_1
XFILLER_105_629 VPWR VGND VPWR VGND sky130_ef_sc_hd__decap_40_12
X_4435_ _5836_/Q input5/X input4/X VGND VGND VPWR VPWR _4435_/X sky130_fd_sc_hd__and3_1
XTAP_TAPCELL_ROW_57_1159 VGND VPWR sky130_fd_sc_hd__tapvpwrvgnd_1
XTAP_TAPCELL_ROW_57_1148 VGND VPWR sky130_fd_sc_hd__tapvpwrvgnd_1
XFILLER_116_27 VGND VGND VPWR VPWR sky130_fd_sc_hd__fill_1
XFILLER_99_841 VGND VGND VPWR VPWR sky130_fd_sc_hd__fill_1
X_4366_ hold497/X _5047_/A1 _4366_/S VGND VGND VPWR VPWR _4366_/X sky130_fd_sc_hd__mux2_1
XANTENNA__3144__A2 _4993_/S VGND VGND VPWR VPWR sky130_fd_sc_hd__diode_2
XANTENNA__4341__A1 _5043_/A1 VGND VGND VPWR VPWR sky130_fd_sc_hd__diode_2
XANTENNA__4467__S _4472_/S VGND VGND VPWR VPWR sky130_fd_sc_hd__diode_2
XFILLER_113_673 VPWR VGND VPWR VGND sky130_ef_sc_hd__decap_40_12
X_3317_ _3317_/A _3317_/B VGND VGND VPWR VPWR _3317_/Y sky130_fd_sc_hd__xnor2_1
XTAP_TAPCELL_ROW_70_1348 VGND VPWR sky130_fd_sc_hd__tapvpwrvgnd_1
X_6105_ _6114_/CLK _6105_/D VGND VGND VPWR VPWR _6105_/Q sky130_fd_sc_hd__dfxtp_1
XFILLER_58_226 VGND VGND VPWR VPWR sky130_fd_sc_hd__fill_1
X_4297_ hold381/X _5040_/A1 _4304_/S VGND VGND VPWR VPWR _4297_/X sky130_fd_sc_hd__mux2_1
XFILLER_132_15 VPWR VGND VPWR VGND sky130_ef_sc_hd__decap_40_12
X_3248_ _4503_/A _4493_/A VGND VGND VPWR VPWR _3908_/S sky130_fd_sc_hd__nor2_4
X_6036_ _6345_/CLK _6036_/D VGND VGND VPWR VPWR _6036_/Q sky130_fd_sc_hd__dfxtp_1
XANTENNA_fanout176_X _2995_/A VGND VGND VPWR VPWR sky130_fd_sc_hd__diode_2
XFILLER_27_613 VGND VGND VPWR VPWR sky130_fd_sc_hd__fill_2
X_3179_ _2703_/A _3177_/A _3178_/Y VGND VGND VPWR VPWR _3179_/X sky130_fd_sc_hd__o21a_1
XFILLER_92_19 VGND VGND VPWR VPWR sky130_fd_sc_hd__fill_8
XFILLER_82_763 VGND VGND VPWR VPWR sky130_fd_sc_hd__fill_1
XFILLER_27_668 VGND VGND VPWR VPWR sky130_fd_sc_hd__fill_4
XFILLER_82_796 VPWR VGND VPWR VGND sky130_ef_sc_hd__decap_40_12
XANTENNA__2715__S _2716_/S VGND VGND VPWR VPWR sky130_fd_sc_hd__diode_2
XFILLER_14_307 VGND VGND VPWR VPWR sky130_fd_sc_hd__fill_1
XFILLER_26_167 VGND VGND VPWR VPWR sky130_fd_sc_hd__fill_2
XTAP_TAPCELL_ROW_85_1580 VGND VPWR sky130_fd_sc_hd__tapvpwrvgnd_1
XFILLER_81_284 VGND VGND VPWR VPWR sky130_fd_sc_hd__fill_2
XFILLER_23_841 VGND VGND VPWR VPWR sky130_fd_sc_hd__fill_1
XFILLER_25_68 VGND VGND VPWR VPWR sky130_fd_sc_hd__fill_1
XFILLER_41_137 VGND VGND VPWR VPWR sky130_fd_sc_hd__fill_2
XANTENNA__3080__A1 _3050_/A VGND VGND VPWR VPWR sky130_fd_sc_hd__diode_2
XFILLER_22_340 VGND VGND VPWR VPWR sky130_fd_sc_hd__fill_1
XFILLER_10_513 VPWR VGND VPWR VGND sky130_ef_sc_hd__decap_40_12
XANTENNA__4930__S _4934_/S VGND VGND VPWR VPWR sky130_fd_sc_hd__diode_2
XFILLER_10_557 VPWR VGND VPWR VGND sky130_ef_sc_hd__decap_40_12
XANTENNA__3907__A1 _5215_/A1 VGND VGND VPWR VPWR sky130_fd_sc_hd__diode_2
XTAP_TAPCELL_ROW_20_596 VGND VPWR sky130_fd_sc_hd__tapvpwrvgnd_1
XFILLER_2_701 VPWR VGND VPWR VGND sky130_ef_sc_hd__decap_40_12
Xhold580 _5885_/Q VGND VGND VPWR VPWR hold580/X sky130_fd_sc_hd__dlygate4sd3_1
XFILLER_9_3 VPWR VGND VPWR VGND sky130_ef_sc_hd__decap_40_12
XFILLER_77_502 VGND VGND VPWR VPWR sky130_fd_sc_hd__fill_2
Xhold591 _3570_/X VGND VGND VPWR VPWR _5607_/D sky130_fd_sc_hd__dlygate4sd3_1
XANTENNA_fanout89_X _5209_/A1 VGND VGND VPWR VPWR sky130_fd_sc_hd__diode_2
XFILLER_106_60 VGND VGND VPWR VPWR sky130_fd_sc_hd__fill_1
XFILLER_77_546 VGND VGND VPWR VPWR sky130_fd_sc_hd__fill_2
XFILLER_49_248 VGND VGND VPWR VPWR sky130_fd_sc_hd__fill_1
XFILLER_66_31 VGND VGND VPWR VPWR sky130_fd_sc_hd__fill_2
XFILLER_45_421 VGND VGND VPWR VPWR sky130_fd_sc_hd__fill_1
XFILLER_18_613 VPWR VGND VPWR VGND sky130_ef_sc_hd__decap_40_12
Xhold1280 _3456_/X VGND VGND VPWR VPWR _5505_/D sky130_fd_sc_hd__dlygate4sd3_1
XANTENNA__2692__Y _3541_/S VGND VGND VPWR VPWR sky130_fd_sc_hd__diode_2
XFILLER_17_123 VGND VGND VPWR VPWR sky130_fd_sc_hd__fill_1
XFILLER_18_657 VPWR VGND VPWR VGND sky130_ef_sc_hd__decap_40_12
Xhold1291 _5960_/Q VGND VGND VPWR VPWR _4312_/A0 sky130_fd_sc_hd__dlygate4sd3_1
XFILLER_82_41 VPWR VGND VPWR VGND sky130_ef_sc_hd__decap_40_12
XFILLER_73_785 VPWR VGND VPWR VGND sky130_ef_sc_hd__decap_40_12
XFILLER_60_402 VGND VGND VPWR VPWR sky130_fd_sc_hd__fill_2
XFILLER_45_487 VPWR VGND VPWR VGND sky130_ef_sc_hd__decap_40_12
XFILLER_14_841 VGND VGND VPWR VPWR sky130_fd_sc_hd__fill_1
XANTENNA__4840__S _4841_/S VGND VGND VPWR VPWR sky130_fd_sc_hd__diode_2
XFILLER_9_311 VGND VGND VPWR VPWR sky130_fd_sc_hd__fill_1
XANTENNA__3456__S _3463_/S VGND VGND VPWR VPWR sky130_fd_sc_hd__diode_2
XFILLER_127_721 VGND VGND VPWR VPWR sky130_fd_sc_hd__fill_4
XFILLER_127_765 VPWR VGND VPWR VGND sky130_ef_sc_hd__decap_40_12
XANTENNA__3374__A2 _4994_/B VGND VGND VPWR VPWR sky130_fd_sc_hd__diode_2
XANTENNA__4571__A1 _4791_/A1 VGND VGND VPWR VPWR sky130_fd_sc_hd__diode_2
XANTENNA__4141__A _4241_/A VGND VGND VPWR VPWR sky130_fd_sc_hd__diode_2
XFILLER_5_561 VPWR VGND VPWR VGND sky130_ef_sc_hd__decap_40_12
X_4220_ _6025_/Q _6016_/Q _6007_/Q _5998_/Q _4213_/S _4212_/A VGND VGND VPWR VPWR
+ _4220_/X sky130_fd_sc_hd__mux4_1
XANTENNA__4323__A1 _5045_/A1 VGND VGND VPWR VPWR sky130_fd_sc_hd__diode_2
XTAP_TAPCELL_ROW_110_1949 VGND VPWR sky130_fd_sc_hd__tapvpwrvgnd_1
XFILLER_101_109 VGND VGND VPWR VPWR sky130_fd_sc_hd__fill_2
XFILLER_96_811 VGND VGND VPWR VPWR sky130_fd_sc_hd__fill_1
XFILLER_110_643 VGND VGND VPWR VPWR sky130_fd_sc_hd__fill_1
XANTENNA_hold2220_A _5267_/Q VGND VGND VPWR VPWR sky130_fd_sc_hd__diode_2
X_4151_ _4263_/A _4151_/B VGND VGND VPWR VPWR _4151_/X sky130_fd_sc_hd__or2_1
XANTENNA__4287__S _4294_/S VGND VGND VPWR VPWR sky130_fd_sc_hd__diode_2
X_3102_ _3102_/A0 _5239_/A1 _3112_/S VGND VGND VPWR VPWR _3102_/X sky130_fd_sc_hd__mux2_1
XFILLER_83_505 VGND VGND VPWR VPWR sky130_fd_sc_hd__fill_4
XTAP_TAPCELL_ROW_52_1078 VGND VPWR sky130_fd_sc_hd__tapvpwrvgnd_1
X_4082_ hold95/A _5461_/Q _5452_/Q _5443_/Q _4237_/S _4251_/A VGND VGND VPWR VPWR
+ _4082_/X sky130_fd_sc_hd__mux4_1
X_3033_ _6240_/Q _6216_/Q _3033_/S VGND VGND VPWR VPWR _3034_/B sky130_fd_sc_hd__mux2_1
XFILLER_102_29 VGND VGND VPWR VPWR sky130_fd_sc_hd__fill_4
XFILLER_51_435 VPWR VGND VPWR VGND sky130_ef_sc_hd__decap_40_12
X_4984_ hold934/X _4984_/A1 _4984_/S VGND VGND VPWR VPWR _4984_/X sky130_fd_sc_hd__mux2_1
X_3935_ _5044_/A1 _3935_/A1 _3938_/S VGND VGND VPWR VPWR _3935_/X sky130_fd_sc_hd__mux2_1
XFILLER_20_811 VGND VGND VPWR VPWR sky130_fd_sc_hd__fill_1
XFILLER_137_529 VPWR VGND VPWR VGND sky130_ef_sc_hd__decap_40_12
X_3866_ _4961_/A0 _3866_/A1 _3869_/S VGND VGND VPWR VPWR _3866_/X sky130_fd_sc_hd__mux2_1
X_5605_ _6094_/CLK _5605_/D VGND VGND VPWR VPWR _5605_/Q sky130_fd_sc_hd__dfxtp_1
X_2817_ _3076_/A1 _2812_/X _2814_/X _2816_/X VGND VGND VPWR VPWR _2817_/X sky130_fd_sc_hd__a22o_1
XFILLER_11_15 VPWR VGND VPWR VGND sky130_ef_sc_hd__decap_40_12
X_3797_ hold125/X _5202_/A1 _3797_/S VGND VGND VPWR VPWR _3797_/X sky130_fd_sc_hd__mux2_1
XFILLER_127_15 VPWR VGND VPWR VGND sky130_ef_sc_hd__decap_40_12
X_5536_ _6242_/CLK _5536_/D VGND VGND VPWR VPWR _5536_/Q sky130_fd_sc_hd__dfxtp_1
X_2748_ hold704/X _5232_/A0 _2753_/S VGND VGND VPWR VPWR _2748_/X sky130_fd_sc_hd__mux2_1
X_5467_ _5784_/CLK _5467_/D VGND VGND VPWR VPWR _5467_/Q sky130_fd_sc_hd__dfxtp_1
XFILLER_105_437 VGND VGND VPWR VPWR sky130_fd_sc_hd__fill_1
X_2679_ _2681_/B _2679_/B VGND VGND VPWR VPWR _2679_/Y sky130_fd_sc_hd__nor2_1
X_4418_ wire60/X _4274_/S _5085_/A VGND VGND VPWR VPWR _6055_/D sky130_fd_sc_hd__a21oi_1
XANTENNA__4314__A1 _5046_/A1 VGND VGND VPWR VPWR sky130_fd_sc_hd__diode_2
XFILLER_99_671 VGND VGND VPWR VPWR sky130_fd_sc_hd__fill_1
X_5398_ _6418_/CLK _5398_/D VGND VGND VPWR VPWR _5398_/Q sky130_fd_sc_hd__dfxtp_1
XFILLER_113_492 VPWR VGND VPWR VGND sky130_ef_sc_hd__decap_40_12
XFILLER_87_833 VGND VGND VPWR VPWR sky130_fd_sc_hd__fill_4
X_4349_ _4349_/A0 _5052_/A1 _4356_/S VGND VGND VPWR VPWR _4349_/X sky130_fd_sc_hd__mux2_1
XFILLER_101_665 VGND VGND VPWR VPWR sky130_fd_sc_hd__fill_4
XFILLER_86_365 VGND VGND VPWR VPWR sky130_fd_sc_hd__fill_2
XFILLER_100_164 VGND VGND VPWR VPWR sky130_fd_sc_hd__fill_4
X_6019_ _6422_/CLK hold44/X VGND VGND VPWR VPWR hold43/A sky130_fd_sc_hd__dfxtp_1
XFILLER_39_292 VGND VGND VPWR VPWR sky130_fd_sc_hd__fill_2
XFILLER_55_785 VPWR VGND VPWR VGND sky130_ef_sc_hd__decap_40_12
XFILLER_27_476 VGND VGND VPWR VPWR sky130_fd_sc_hd__fill_2
XFILLER_36_78 VGND VGND VPWR VPWR sky130_fd_sc_hd__fill_4
XTAP_TAPCELL_ROW_83_1539 VGND VPWR sky130_fd_sc_hd__tapvpwrvgnd_1
XFILLER_70_755 VGND VGND VPWR VPWR sky130_fd_sc_hd__fill_1
XFILLER_27_498 VGND VGND VPWR VPWR sky130_fd_sc_hd__fill_4
XANTENNA__3053__A1 _3076_/A1 VGND VGND VPWR VPWR sky130_fd_sc_hd__diode_2
XFILLER_70_777 VGND VGND VPWR VPWR sky130_fd_sc_hd__fill_4
XFILLER_11_833 VGND VGND VPWR VPWR sky130_fd_sc_hd__fill_4
XFILLER_23_671 VGND VGND VPWR VPWR sky130_fd_sc_hd__fill_1
XFILLER_23_682 VGND VGND VPWR VPWR sky130_fd_sc_hd__fill_2
XTAP_TAPCELL_ROW_25_677 VGND VPWR sky130_fd_sc_hd__tapvpwrvgnd_1
XPHY_EDGE_ROW_30_Left_169 VGND VGND VPWR VPWR sky130_fd_sc_hd__decap_3
XTAP_TAPCELL_ROW_114_2005 VGND VPWR sky130_fd_sc_hd__tapvpwrvgnd_1
XFILLER_109_721 VGND VGND VPWR VPWR sky130_fd_sc_hd__fill_4
XFILLER_10_365 VPWR VGND VPWR VGND sky130_ef_sc_hd__decap_40_12
XTAP_TAPCELL_ROW_114_2016 VGND VPWR sky130_fd_sc_hd__tapvpwrvgnd_1
XFILLER_109_765 VPWR VGND VPWR VGND sky130_ef_sc_hd__decap_40_12
XANTENNA__4553__A1 _5241_/A1 VGND VGND VPWR VPWR sky130_fd_sc_hd__diode_2
XTAP_TAPCELL_ROW_98_1771 VGND VPWR sky130_fd_sc_hd__tapvpwrvgnd_1
XFILLER_6_358 VGND VGND VPWR VPWR sky130_fd_sc_hd__fill_4
XANTENNA__3356__A2 _5035_/C VGND VGND VPWR VPWR sky130_fd_sc_hd__diode_2
XFILLER_124_713 VPWR VGND VPWR VGND sky130_ef_sc_hd__decap_40_12
XFILLER_124_757 VPWR VGND VPWR VGND sky130_ef_sc_hd__decap_40_12
XFILLER_2_531 VGND VGND VPWR VPWR sky130_fd_sc_hd__fill_1
XFILLER_111_418 VGND VGND VPWR VPWR sky130_fd_sc_hd__fill_4
XFILLER_78_811 VGND VGND VPWR VPWR sky130_fd_sc_hd__fill_1
XANTENNA__4835__S _4841_/S VGND VGND VPWR VPWR sky130_fd_sc_hd__diode_2
XFILLER_77_387 VGND VGND VPWR VPWR sky130_fd_sc_hd__fill_4
XTAP_TAPCELL_ROW_5_380 VGND VPWR sky130_fd_sc_hd__tapvpwrvgnd_1
XFILLER_37_229 VGND VGND VPWR VPWR sky130_fd_sc_hd__fill_1
XFILLER_18_421 VPWR VGND VPWR VGND sky130_ef_sc_hd__decap_40_12
XTAP_TAPCELL_ROW_125_2178 VGND VPWR sky130_fd_sc_hd__tapvpwrvgnd_1
XANTENNA__3292__A1 _4903_/A0 VGND VGND VPWR VPWR sky130_fd_sc_hd__diode_2
XANTENNA__3959__B _4007_/A VGND VGND VPWR VPWR sky130_fd_sc_hd__diode_2
XFILLER_46_774 VPWR VGND VPWR VGND sky130_ef_sc_hd__decap_40_12
XFILLER_45_295 VGND VGND VPWR VPWR sky130_fd_sc_hd__fill_1
XANTENNA__4136__A _4251_/A VGND VGND VPWR VPWR sky130_fd_sc_hd__diode_2
XTAP_TAPCELL_ROW_44_964 VGND VPWR sky130_fd_sc_hd__tapvpwrvgnd_1
XTAP_TAPCELL_ROW_44_953 VGND VPWR sky130_fd_sc_hd__tapvpwrvgnd_1
XFILLER_33_468 VGND VGND VPWR VPWR sky130_fd_sc_hd__fill_4
XANTENNA__4570__S _4713_/S VGND VGND VPWR VPWR sky130_fd_sc_hd__diode_2
X_3720_ _3720_/A0 _4976_/A1 _3728_/S VGND VGND VPWR VPWR _3720_/X sky130_fd_sc_hd__mux2_1
XFILLER_14_693 VGND VGND VPWR VPWR sky130_fd_sc_hd__fill_4
Xclkbuf_leaf_40_clk clkload4/A VGND VGND VPWR VPWR _6434_/CLK sky130_fd_sc_hd__clkbuf_8
XANTENNA__4792__A1 _4792_/A1 VGND VGND VPWR VPWR sky130_fd_sc_hd__diode_2
X_3651_ hold61/X _4958_/A0 _3657_/S VGND VGND VPWR VPWR hold62/A sky130_fd_sc_hd__mux2_1
X_6370_ _6428_/CLK _6370_/D VGND VGND VPWR VPWR _6370_/Q sky130_fd_sc_hd__dfxtp_1
XANTENNA__4544__A1 _4903_/A0 VGND VGND VPWR VPWR sky130_fd_sc_hd__diode_2
X_3582_ hold93/X _5214_/A1 _3584_/S VGND VGND VPWR VPWR hold94/A sky130_fd_sc_hd__mux2_1
XFILLER_61_3 VGND VGND VPWR VPWR sky130_fd_sc_hd__fill_1
XFILLER_127_573 VPWR VGND VPWR VGND sky130_ef_sc_hd__decap_40_12
X_5321_ _5988_/CLK _5321_/D VGND VGND VPWR VPWR _5321_/Q sky130_fd_sc_hd__dfxtp_2
XTAP_TAPCELL_ROW_54_1107 VGND VPWR sky130_fd_sc_hd__tapvpwrvgnd_1
XFILLER_5_391 VGND VGND VPWR VPWR sky130_fd_sc_hd__fill_1
X_5252_ _6222_/CLK _5252_/D VGND VGND VPWR VPWR _5252_/Q sky130_fd_sc_hd__dfxtp_1
XFILLER_130_749 VGND VGND VPWR VPWR sky130_fd_sc_hd__fill_4
XANTENNA__2858__A1 _3031_/A1 VGND VGND VPWR VPWR sky130_fd_sc_hd__diode_2
X_5183_ _3951_/Y _5175_/S _2622_/Y VGND VGND VPWR VPWR _5183_/X sky130_fd_sc_hd__a21o_1
X_4203_ _4260_/S _4195_/X _4202_/Y _5343_/Q VGND VGND VPWR VPWR _4203_/X sky130_fd_sc_hd__a211o_1
XFILLER_96_641 VGND VGND VPWR VPWR sky130_fd_sc_hd__fill_2
X_4134_ _4134_/A0 _4134_/A1 hold547/X hold698/X _4250_/S _4178_/A VGND VGND VPWR VPWR
+ _4134_/X sky130_fd_sc_hd__mux4_1
XFILLER_95_173 VGND VGND VPWR VPWR sky130_fd_sc_hd__fill_2
XFILLER_84_825 VPWR VGND VPWR VGND sky130_ef_sc_hd__decap_40_12
XTAP_TAPCELL_ROW_3_339 VGND VPWR sky130_fd_sc_hd__tapvpwrvgnd_1
XFILLER_3_93 VGND VGND VPWR VPWR sky130_fd_sc_hd__fill_4
XFILLER_113_39 VGND VGND VPWR VPWR sky130_fd_sc_hd__fill_8
X_4065_ _4263_/A _4065_/B VGND VGND VPWR VPWR _4065_/X sky130_fd_sc_hd__or2_1
X_3016_ _6432_/Q _5317_/Q _3016_/S VGND VGND VPWR VPWR _3016_/X sky130_fd_sc_hd__mux2_1
XFILLER_36_251 VGND VGND VPWR VPWR sky130_fd_sc_hd__fill_1
XFILLER_37_785 VPWR VGND VPWR VGND sky130_ef_sc_hd__decap_40_12
XFILLER_24_413 VGND VGND VPWR VPWR sky130_fd_sc_hd__fill_4
XTAP_TAPCELL_ROW_65_1269 VGND VPWR sky130_fd_sc_hd__tapvpwrvgnd_1
XFILLER_52_755 VGND VGND VPWR VPWR sky130_fd_sc_hd__fill_1
XFILLER_24_457 VGND VGND VPWR VPWR sky130_fd_sc_hd__fill_4
XFILLER_11_129 VGND VGND VPWR VPWR sky130_fd_sc_hd__fill_2
X_4967_ _5824_/Q _4967_/A1 _4974_/S VGND VGND VPWR VPWR _4967_/X sky130_fd_sc_hd__mux2_1
XTAP_TAPCELL_ROW_22_625 VGND VPWR sky130_fd_sc_hd__tapvpwrvgnd_1
X_4898_ _5241_/A1 hold232/X _4906_/S VGND VGND VPWR VPWR _6246_/D sky130_fd_sc_hd__mux2_1
Xclkbuf_leaf_31_clk clkload3/A VGND VGND VPWR VPWR _6129_/CLK sky130_fd_sc_hd__clkbuf_8
XANTENNA_fanout139_X _4792_/A1 VGND VGND VPWR VPWR sky130_fd_sc_hd__diode_2
XANTENNA__4783__B2 _4791_/B1 VGND VGND VPWR VPWR sky130_fd_sc_hd__diode_2
XFILLER_20_641 VGND VGND VPWR VPWR sky130_fd_sc_hd__fill_2
XTAP_TAPCELL_ROW_22_636 VGND VPWR sky130_fd_sc_hd__tapvpwrvgnd_1
X_3918_ hold765/X _5202_/A1 _3918_/S VGND VGND VPWR VPWR _3918_/X sky130_fd_sc_hd__mux2_1
XFILLER_137_337 VGND VGND VPWR VPWR sky130_fd_sc_hd__fill_1
X_3849_ input23/X _3837_/A _3836_/Y _3848_/X _5176_/A VGND VGND VPWR VPWR _5838_/D
+ sky130_fd_sc_hd__o311a_1
XANTENNA__4535__A1 _5237_/A0 VGND VGND VPWR VPWR sky130_fd_sc_hd__diode_2
XFILLER_138_69 VPWR VGND VPWR VGND sky130_ef_sc_hd__decap_40_12
X_5519_ _5571_/CLK _5519_/D VGND VGND VPWR VPWR _5519_/Q sky130_fd_sc_hd__dfxtp_1
XFILLER_106_713 VPWR VGND VPWR VGND sky130_ef_sc_hd__decap_40_12
XFILLER_98_29 VGND VGND VPWR VPWR sky130_fd_sc_hd__fill_1
XFILLER_106_757 VPWR VGND VPWR VGND sky130_ef_sc_hd__decap_40_12
XFILLER_121_727 VGND VGND VPWR VPWR sky130_fd_sc_hd__fill_1
XTAP_TAPCELL_ROW_93_1690 VGND VPWR sky130_fd_sc_hd__tapvpwrvgnd_1
Xfanout120 _4899_/A0 VGND VGND VPWR VPWR _4886_/A1 sky130_fd_sc_hd__buf_4
Xfanout131 _5812_/Q VGND VGND VPWR VPWR _4889_/A1 sky130_fd_sc_hd__buf_4
Xclkbuf_leaf_98_clk clkload0/A VGND VGND VPWR VPWR _6312_/CLK sky130_fd_sc_hd__clkbuf_8
Xfanout153 _4713_/S VGND VGND VPWR VPWR _4778_/S sky130_fd_sc_hd__clkbuf_8
Xfanout142 _4600_/A VGND VGND VPWR VPWR _4809_/A sky130_fd_sc_hd__buf_4
Xfanout164 hold2223/X VGND VGND VPWR VPWR _4178_/A sky130_fd_sc_hd__clkbuf_4
Xfanout197 _3033_/S VGND VGND VPWR VPWR _3051_/S sky130_fd_sc_hd__clkbuf_8
XFILLER_101_473 VGND VGND VPWR VPWR sky130_fd_sc_hd__fill_2
Xfanout186 _3020_/A VGND VGND VPWR VPWR _3034_/A sky130_fd_sc_hd__buf_2
Xfanout175 _2995_/A VGND VGND VPWR VPWR _2967_/S sky130_fd_sc_hd__buf_4
XFILLER_47_55 VGND VGND VPWR VPWR sky130_fd_sc_hd__fill_1
XFILLER_47_44 VGND VGND VPWR VPWR sky130_fd_sc_hd__fill_1
XFILLER_86_195 VGND VGND VPWR VPWR sky130_fd_sc_hd__fill_1
XANTENNA__4471__A0 _5080_/A0 VGND VGND VPWR VPWR sky130_fd_sc_hd__diode_2
XANTENNA__3274__A1 _4663_/A VGND VGND VPWR VPWR sky130_fd_sc_hd__diode_2
XFILLER_63_10 VGND VGND VPWR VPWR sky130_fd_sc_hd__fill_1
XFILLER_63_76 VGND VGND VPWR VPWR sky130_fd_sc_hd__fill_1
XTAP_TAPCELL_ROW_120_2097 VGND VPWR sky130_fd_sc_hd__tapvpwrvgnd_1
XFILLER_42_276 VGND VGND VPWR VPWR sky130_fd_sc_hd__fill_8
XTAP_TAPCELL_ROW_41_912 VGND VPWR sky130_fd_sc_hd__tapvpwrvgnd_1
Xclkbuf_leaf_22_clk clkload3/A VGND VGND VPWR VPWR _6137_/CLK sky130_fd_sc_hd__clkbuf_8
XFILLER_8_27 VGND VGND VPWR VPWR sky130_fd_sc_hd__fill_1
XFILLER_11_641 VPWR VGND VPWR VGND sky130_ef_sc_hd__decap_40_12
XFILLER_11_685 VPWR VGND VPWR VGND sky130_ef_sc_hd__decap_40_12
XANTENNA__4526__A1 _5228_/A0 VGND VGND VPWR VPWR sky130_fd_sc_hd__diode_2
XFILLER_109_573 VPWR VGND VPWR VGND sky130_ef_sc_hd__decap_40_12
XANTENNA__3734__S _3745_/S VGND VGND VPWR VPWR sky130_fd_sc_hd__diode_2
XFILLER_124_587 VGND VGND VPWR VPWR sky130_fd_sc_hd__fill_1
XFILLER_112_749 VGND VGND VPWR VPWR sky130_fd_sc_hd__fill_4
XFILLER_97_438 VGND VGND VPWR VPWR sky130_fd_sc_hd__fill_1
XFILLER_2_383 VGND VGND VPWR VPWR sky130_fd_sc_hd__fill_1
XFILLER_2_361 VGND VGND VPWR VPWR sky130_fd_sc_hd__fill_2
XFILLER_33_7 VGND VGND VPWR VPWR sky130_fd_sc_hd__fill_2
XTAP_TAPCELL_ROW_127_2207 VGND VPWR sky130_fd_sc_hd__tapvpwrvgnd_1
Xclkbuf_leaf_89_clk clkload1/A VGND VGND VPWR VPWR _6125_/CLK sky130_fd_sc_hd__clkbuf_8
XFILLER_120_793 VPWR VGND VPWR VGND sky130_ef_sc_hd__decap_40_12
XFILLER_65_313 VGND VGND VPWR VPWR sky130_fd_sc_hd__fill_4
XTAP_TAPCELL_ROW_109_1940 VGND VPWR sky130_fd_sc_hd__tapvpwrvgnd_1
XFILLER_19_741 VPWR VGND VPWR VGND sky130_ef_sc_hd__decap_40_12
XANTENNA__4462__A0 _5239_/A1 VGND VGND VPWR VPWR sky130_fd_sc_hd__diode_2
XFILLER_81_839 VGND VGND VPWR VPWR sky130_fd_sc_hd__fill_1
XANTENNA__4688__S1 _4792_/A1 VGND VGND VPWR VPWR sky130_fd_sc_hd__diode_2
XFILLER_46_560 VGND VGND VPWR VPWR sky130_fd_sc_hd__fill_2
XFILLER_18_251 VGND VGND VPWR VPWR sky130_fd_sc_hd__fill_1
XFILLER_19_785 VPWR VGND VPWR VGND sky130_ef_sc_hd__decap_40_12
X_5870_ _5870_/CLK _5870_/D VGND VGND VPWR VPWR _5870_/Q sky130_fd_sc_hd__dfxtp_1
X_4821_ _4886_/A1 _4821_/A1 _4828_/S VGND VGND VPWR VPWR _6175_/D sky130_fd_sc_hd__mux2_1
XFILLER_33_243 VGND VGND VPWR VPWR sky130_fd_sc_hd__fill_1
XFILLER_34_755 VGND VGND VPWR VPWR sky130_fd_sc_hd__fill_1
XANTENNA__4214__B1 _4205_/A VGND VGND VPWR VPWR sky130_fd_sc_hd__diode_2
XFILLER_21_405 VPWR VGND VPWR VGND sky130_ef_sc_hd__decap_40_12
XANTENNA__2813__S _3016_/S VGND VGND VPWR VPWR sky130_fd_sc_hd__diode_2
Xclkbuf_leaf_13_clk clkbuf_leaf_9_clk/A VGND VGND VPWR VPWR _6349_/CLK sky130_fd_sc_hd__clkbuf_8
X_4752_ _4809_/A _4752_/B VGND VGND VPWR VPWR _4752_/X sky130_fd_sc_hd__or2_1
XFILLER_21_449 VPWR VGND VPWR VGND sky130_ef_sc_hd__decap_40_12
XTAP_TAPCELL_ROW_138_2369 VGND VPWR sky130_fd_sc_hd__tapvpwrvgnd_1
X_4683_ _4680_/X _4681_/X _4682_/X _4792_/A1 VGND VGND VPWR VPWR _4683_/X sky130_fd_sc_hd__a22o_1
X_3703_ _5212_/A1 _3703_/A1 _3707_/S VGND VGND VPWR VPWR _3703_/X sky130_fd_sc_hd__mux2_1
XTAP_TAPCELL_ROW_60_1199 VGND VPWR sky130_fd_sc_hd__tapvpwrvgnd_1
X_6422_ _6422_/CLK _6422_/D VGND VGND VPWR VPWR _6422_/Q sky130_fd_sc_hd__dfxtp_1
X_3634_ hold968/X _5213_/A1 _3637_/S VGND VGND VPWR VPWR _3634_/X sky130_fd_sc_hd__mux2_1
XANTENNA__4517__A1 _4517_/A1 VGND VGND VPWR VPWR sky130_fd_sc_hd__diode_2
X_6353_ _6380_/CLK _6353_/D VGND VGND VPWR VPWR _6353_/Q sky130_fd_sc_hd__dfxtp_1
X_3565_ _4493_/B _4483_/B VGND VGND VPWR VPWR _3574_/S sky130_fd_sc_hd__nor2_4
X_3496_ _4899_/A0 _3496_/A1 _3503_/S VGND VGND VPWR VPWR _3496_/X sky130_fd_sc_hd__mux2_1
X_5304_ _6369_/CLK _5304_/D VGND VGND VPWR VPWR _5304_/Q sky130_fd_sc_hd__dfxtp_1
XFILLER_0_309 VPWR VGND VPWR VGND sky130_ef_sc_hd__decap_40_12
X_6284_ _6302_/CLK _6284_/D VGND VGND VPWR VPWR _6284_/Q sky130_fd_sc_hd__dfxtp_1
X_5235_ _5235_/A0 _5235_/A1 _5237_/S VGND VGND VPWR VPWR _5235_/X sky130_fd_sc_hd__mux2_1
XFILLER_103_727 VGND VGND VPWR VPWR sky130_fd_sc_hd__fill_1
XFILLER_130_557 VPWR VGND VPWR VGND sky130_ef_sc_hd__decap_40_12
XFILLER_124_27 VGND VGND VPWR VPWR sky130_fd_sc_hd__fill_1
Xhold1802 _5912_/Q VGND VGND VPWR VPWR _4191_/A1 sky130_fd_sc_hd__dlygate4sd3_1
Xhold1835 _3563_/X VGND VGND VPWR VPWR _5602_/D sky130_fd_sc_hd__dlygate4sd3_1
X_5166_ _5162_/A _5175_/S _5165_/Y _5176_/A VGND VGND VPWR VPWR _5166_/X sky130_fd_sc_hd__o211a_1
XFILLER_68_151 VGND VGND VPWR VPWR sky130_fd_sc_hd__fill_2
Xhold1824 _6294_/Q VGND VGND VPWR VPWR _4960_/A1 sky130_fd_sc_hd__dlygate4sd3_1
Xhold1813 _3254_/X VGND VGND VPWR VPWR _5390_/D sky130_fd_sc_hd__dlygate4sd3_1
Xhold1846 _6175_/Q VGND VGND VPWR VPWR _4821_/A1 sky130_fd_sc_hd__dlygate4sd3_1
Xhold1868 _3704_/X VGND VGND VPWR VPWR _5725_/D sky130_fd_sc_hd__dlygate4sd3_1
XFILLER_68_195 VGND VGND VPWR VPWR sky130_fd_sc_hd__fill_1
X_5097_ _6386_/Q _5097_/B VGND VGND VPWR VPWR _5097_/Y sky130_fd_sc_hd__nor2_1
Xhold1857 _6163_/Q VGND VGND VPWR VPWR _5087_/A1 sky130_fd_sc_hd__dlygate4sd3_1
X_4117_ _4260_/S _4109_/X _4116_/Y _5343_/Q VGND VGND VPWR VPWR _4117_/X sky130_fd_sc_hd__a211o_1
XFILLER_83_165 VGND VGND VPWR VPWR sky130_fd_sc_hd__fill_1
XFILLER_83_143 VGND VGND VPWR VPWR sky130_fd_sc_hd__fill_1
XTAP_TAPCELL_ROW_67_1309 VGND VPWR sky130_fd_sc_hd__tapvpwrvgnd_1
Xhold1879 _6045_/Q VGND VGND VPWR VPWR _4408_/A1 sky130_fd_sc_hd__dlygate4sd3_1
Xi2c_master_axil_224 VGND VGND VPWR VPWR i2c_master_axil_224/HI s_axil_rdata[30] sky130_fd_sc_hd__conb_1
Xi2c_master_axil_213 VGND VGND VPWR VPWR i2c_master_axil_213/HI s_axil_rdata[19] sky130_fd_sc_hd__conb_1
X_4048_ hold635/X _4048_/A1 _4048_/A2 hold285/X _4237_/S _4251_/A VGND VGND VPWR VPWR
+ _4048_/X sky130_fd_sc_hd__mux4_1
XTAP_TAPCELL_ROW_27_706 VGND VPWR sky130_fd_sc_hd__tapvpwrvgnd_1
XFILLER_52_563 VGND VGND VPWR VPWR sky130_fd_sc_hd__fill_4
XFILLER_52_530 VGND VGND VPWR VPWR sky130_fd_sc_hd__fill_2
X_5999_ _6351_/CLK _5999_/D VGND VGND VPWR VPWR _5999_/Q sky130_fd_sc_hd__dfxtp_1
XFILLER_33_57 VGND VGND VPWR VPWR sky130_fd_sc_hd__fill_2
XFILLER_138_613 VGND VGND VPWR VPWR sky130_fd_sc_hd__fill_2
XFILLER_138_657 VPWR VGND VPWR VGND sky130_ef_sc_hd__decap_40_12
XANTENNA__4508__A1 _5212_/A1 VGND VGND VPWR VPWR sky130_fd_sc_hd__diode_2
XFILLER_137_167 VGND VGND VPWR VPWR sky130_fd_sc_hd__fill_1
XPHY_EDGE_ROW_104_Left_243 VGND VGND VPWR VPWR sky130_fd_sc_hd__decap_3
XTAP_TAPCELL_ROW_95_1730 VGND VPWR sky130_fd_sc_hd__tapvpwrvgnd_1
XFILLER_134_841 VGND VGND VPWR VPWR sky130_fd_sc_hd__fill_1
XFILLER_109_3 VPWR VGND VPWR VGND sky130_ef_sc_hd__decap_40_12
XFILLER_106_521 VGND VGND VPWR VPWR sky130_fd_sc_hd__fill_8
XFILLER_4_637 VGND VGND VPWR VPWR sky130_fd_sc_hd__fill_4
XFILLER_3_169 VGND VGND VPWR VPWR sky130_fd_sc_hd__fill_1
XFILLER_121_513 VPWR VGND VPWR VGND sky130_ef_sc_hd__decap_40_12
XFILLER_106_587 VGND VGND VPWR VPWR sky130_fd_sc_hd__fill_1
XFILLER_0_832 VGND VGND VPWR VPWR sky130_fd_sc_hd__fill_8
XFILLER_121_557 VGND VGND VPWR VPWR sky130_fd_sc_hd__fill_2
XFILLER_94_419 VGND VGND VPWR VPWR sky130_fd_sc_hd__fill_1
Xhold9 hold9/A VGND VGND VPWR VPWR hold9/X sky130_fd_sc_hd__dlygate4sd3_1
XFILLER_59_140 VGND VGND VPWR VPWR sky130_fd_sc_hd__fill_4
XFILLER_48_825 VPWR VGND VPWR VGND sky130_ef_sc_hd__decap_40_12
XANTENNA_fanout71_X _4252_/B1 VGND VGND VPWR VPWR sky130_fd_sc_hd__diode_2
XPHY_EDGE_ROW_113_Left_252 VGND VGND VPWR VPWR sky130_fd_sc_hd__decap_3
XFILLER_102_793 VPWR VGND VPWR VGND sky130_ef_sc_hd__decap_40_12
XFILLER_101_292 VGND VGND VPWR VPWR sky130_fd_sc_hd__fill_2
XFILLER_101_281 VGND VGND VPWR VPWR sky130_fd_sc_hd__fill_8
XANTENNA_input29_A s_axil_wstrb[1] VGND VGND VPWR VPWR sky130_fd_sc_hd__diode_2
XFILLER_74_20 VGND VGND VPWR VPWR sky130_fd_sc_hd__fill_8
XTAP_TAPCELL_ROW_122_2137 VGND VPWR sky130_fd_sc_hd__tapvpwrvgnd_1
XTAP_TAPCELL_ROW_122_2126 VGND VPWR sky130_fd_sc_hd__tapvpwrvgnd_1
XANTENNA__3079__B1_N _3050_/A VGND VGND VPWR VPWR sky130_fd_sc_hd__diode_2
XFILLER_90_625 VPWR VGND VPWR VGND sky130_ef_sc_hd__decap_40_12
XFILLER_90_669 VPWR VGND VPWR VGND sky130_ef_sc_hd__decap_40_12
XFILLER_16_755 VGND VGND VPWR VPWR sky130_fd_sc_hd__fill_1
XANTENNA__5069__X _5081_/S VGND VGND VPWR VPWR sky130_fd_sc_hd__diode_2
XANTENNA__4747__A1 _4811_/A1 VGND VGND VPWR VPWR sky130_fd_sc_hd__diode_2
XFILLER_31_769 VPWR VGND VPWR VGND sky130_ef_sc_hd__decap_40_12
XFILLER_129_613 VGND VGND VPWR VPWR sky130_fd_sc_hd__fill_2
XANTENNA__2758__B1 _3075_/C1 VGND VGND VPWR VPWR sky130_fd_sc_hd__diode_2
XPHY_EDGE_ROW_122_Left_261 VGND VGND VPWR VPWR sky130_fd_sc_hd__decap_3
XTAP_TAPCELL_ROW_13_488 VGND VPWR sky130_fd_sc_hd__tapvpwrvgnd_1
XTAP_TAPCELL_ROW_13_499 VGND VPWR sky130_fd_sc_hd__tapvpwrvgnd_1
Xhold409 _6313_/Q VGND VGND VPWR VPWR hold409/X sky130_fd_sc_hd__dlygate4sd3_1
XFILLER_125_841 VGND VGND VPWR VPWR sky130_fd_sc_hd__fill_1
XFILLER_7_497 VGND VGND VPWR VPWR sky130_fd_sc_hd__fill_4
XTAP_TAPCELL_ROW_133_2299 VGND VPWR sky130_fd_sc_hd__tapvpwrvgnd_1
XTAP_TAPCELL_ROW_133_2288 VGND VPWR sky130_fd_sc_hd__tapvpwrvgnd_1
X_3350_ hold946/X _5035_/C _5201_/B _5430_/Q VGND VGND VPWR VPWR _3350_/X sky130_fd_sc_hd__a22o_1
XANTENNA__2930__B1 _3075_/C1 VGND VGND VPWR VPWR sky130_fd_sc_hd__diode_2
XFILLER_98_725 VPWR VGND VPWR VGND sky130_ef_sc_hd__decap_40_12
XFILLER_112_557 VPWR VGND VPWR VGND sky130_ef_sc_hd__decap_40_12
XFILLER_98_769 VPWR VGND VPWR VGND sky130_ef_sc_hd__decap_40_12
X_5020_ _6355_/Q _6356_/Q _6327_/Q VGND VGND VPWR VPWR _5020_/X sky130_fd_sc_hd__mux2_1
X_3281_ _3228_/A _3279_/B _3801_/A VGND VGND VPWR VPWR _3281_/Y sky130_fd_sc_hd__a21oi_1
XPHY_EDGE_ROW_131_Left_270 VGND VGND VPWR VPWR sky130_fd_sc_hd__decap_3
XANTENNA__3486__A1 _4889_/A1 VGND VGND VPWR VPWR sky130_fd_sc_hd__diode_2
Xhold1109 _3532_/X VGND VGND VPWR VPWR _5575_/D sky130_fd_sc_hd__dlygate4sd3_1
XANTENNA__2908__S1 _2962_/A VGND VGND VPWR VPWR sky130_fd_sc_hd__diode_2
XFILLER_24_3 VPWR VGND VPWR VGND sky130_ef_sc_hd__decap_40_12
Xclkbuf_leaf_2_clk clkbuf_leaf_9_clk/A VGND VGND VPWR VPWR _5988_/CLK sky130_fd_sc_hd__clkbuf_8
XPHY_EDGE_ROW_119_Right_119 VGND VGND VPWR VPWR sky130_fd_sc_hd__decap_3
XFILLER_81_625 VGND VGND VPWR VPWR sky130_fd_sc_hd__fill_2
XTAP_TAPCELL_ROW_49_1039 VGND VPWR sky130_fd_sc_hd__tapvpwrvgnd_1
XTAP_TAPCELL_ROW_49_1028 VGND VPWR sky130_fd_sc_hd__tapvpwrvgnd_1
XANTENNA__4986__A1 _5040_/A1 VGND VGND VPWR VPWR sky130_fd_sc_hd__diode_2
XFILLER_0_83 VGND VGND VPWR VPWR sky130_fd_sc_hd__fill_1
X_5922_ _6312_/CLK _5922_/D VGND VGND VPWR VPWR _5922_/Q sky130_fd_sc_hd__dfxtp_1
XFILLER_34_530 VGND VGND VPWR VPWR sky130_fd_sc_hd__fill_2
XFILLER_34_541 VPWR VGND VPWR VGND sky130_ef_sc_hd__decap_40_12
XFILLER_110_29 VPWR VGND VPWR VGND sky130_ef_sc_hd__decap_40_12
XTAP_TAPCELL_ROW_62_1228 VGND VPWR sky130_fd_sc_hd__tapvpwrvgnd_1
X_5853_ _6097_/CLK _5853_/D VGND VGND VPWR VPWR _5853_/Q sky130_fd_sc_hd__dfxtp_1
XFILLER_22_725 VPWR VGND VPWR VGND sky130_ef_sc_hd__decap_40_12
XFILLER_61_393 VGND VGND VPWR VPWR sky130_fd_sc_hd__fill_8
X_5784_ _5784_/CLK _5784_/D VGND VGND VPWR VPWR _5784_/Q sky130_fd_sc_hd__dfxtp_1
XFILLER_22_769 VPWR VGND VPWR VGND sky130_ef_sc_hd__decap_40_12
X_4804_ _4811_/A1 _4803_/X _4802_/X _4663_/A VGND VGND VPWR VPWR _4804_/X sky130_fd_sc_hd__o211a_1
X_2996_ _2995_/A _2988_/X _2995_/Y _5270_/Q VGND VGND VPWR VPWR _2996_/X sky130_fd_sc_hd__a211o_1
X_4735_ _4792_/A1 _4730_/X _4732_/X _4734_/X VGND VGND VPWR VPWR _4735_/X sky130_fd_sc_hd__a22o_1
XFILLER_21_279 VGND VGND VPWR VPWR sky130_fd_sc_hd__fill_1
XTAP_TAPCELL_ROW_32_775 VGND VPWR sky130_fd_sc_hd__tapvpwrvgnd_1
XFILLER_119_27 VPWR VGND VPWR VGND sky130_ef_sc_hd__decap_40_12
XTAP_TAPCELL_ROW_32_786 VGND VPWR sky130_fd_sc_hd__tapvpwrvgnd_1
XFILLER_119_167 VGND VGND VPWR VPWR sky130_fd_sc_hd__fill_1
X_4666_ hold218/X hold683/X _4803_/S VGND VGND VPWR VPWR _4666_/X sky130_fd_sc_hd__mux2_1
Xhold910 _5369_/Q VGND VGND VPWR VPWR hold910/X sky130_fd_sc_hd__dlygate4sd3_1
XFILLER_116_841 VGND VGND VPWR VPWR sky130_fd_sc_hd__fill_1
XANTENNA__5163__A1 _5840_/Q VGND VGND VPWR VPWR sky130_fd_sc_hd__diode_2
X_6405_ _6405_/CLK _6405_/D VGND VGND VPWR VPWR _6405_/Q sky130_fd_sc_hd__dfxtp_1
X_4597_ _4593_/X _4595_/X _4596_/X _4811_/C1 VGND VGND VPWR VPWR _4597_/X sky130_fd_sc_hd__a22o_1
X_3617_ _3777_/A _5384_/Q _3617_/C VGND VGND VPWR VPWR _3648_/B sky130_fd_sc_hd__or3_4
Xhold921 _3387_/X VGND VGND VPWR VPWR _5446_/D sky130_fd_sc_hd__dlygate4sd3_1
Xhold954 _5313_/Q VGND VGND VPWR VPWR hold954/X sky130_fd_sc_hd__dlygate4sd3_1
Xhold943 _3887_/X VGND VGND VPWR VPWR _5867_/D sky130_fd_sc_hd__dlygate4sd3_1
XTAP_TAPCELL_ROW_77_1460 VGND VPWR sky130_fd_sc_hd__tapvpwrvgnd_1
X_3548_ hold803/X _4488_/A0 _3552_/S VGND VGND VPWR VPWR _3548_/X sky130_fd_sc_hd__mux2_1
X_6336_ _6341_/CLK _6336_/D VGND VGND VPWR VPWR _6336_/Q sky130_fd_sc_hd__dfxtp_1
Xhold932 _6099_/Q VGND VGND VPWR VPWR hold932/X sky130_fd_sc_hd__dlygate4sd3_1
XFILLER_135_15 VPWR VGND VPWR VGND sky130_ef_sc_hd__decap_40_12
XFILLER_131_833 VGND VGND VPWR VPWR sky130_fd_sc_hd__fill_4
XFILLER_103_513 VPWR VGND VPWR VGND sky130_ef_sc_hd__decap_40_12
XFILLER_103_502 VGND VGND VPWR VPWR sky130_fd_sc_hd__fill_2
Xhold987 _6167_/Q VGND VGND VPWR VPWR hold987/X sky130_fd_sc_hd__dlygate4sd3_1
Xhold998 _5596_/Q VGND VGND VPWR VPWR hold998/X sky130_fd_sc_hd__dlygate4sd3_1
Xhold976 _3790_/X VGND VGND VPWR VPWR _5797_/D sky130_fd_sc_hd__dlygate4sd3_1
XFILLER_1_629 VPWR VGND VPWR VGND sky130_ef_sc_hd__decap_40_12
Xhold965 _3927_/X VGND VGND VPWR VPWR _5904_/D sky130_fd_sc_hd__dlygate4sd3_1
X_3479_ hold407/X _5238_/A1 _3490_/S VGND VGND VPWR VPWR _3479_/X sky130_fd_sc_hd__mux2_1
XFILLER_103_557 VGND VGND VPWR VPWR sky130_fd_sc_hd__fill_2
X_6267_ _6312_/CLK _6267_/D VGND VGND VPWR VPWR _6267_/Q sky130_fd_sc_hd__dfxtp_1
X_6198_ _6242_/CLK _6198_/D VGND VGND VPWR VPWR _6198_/Q sky130_fd_sc_hd__dfxtp_1
Xhold1610 _5484_/Q VGND VGND VPWR VPWR _3433_/A0 sky130_fd_sc_hd__dlygate4sd3_1
XFILLER_69_471 VGND VGND VPWR VPWR sky130_fd_sc_hd__fill_1
X_5218_ _5218_/A _5218_/B _5218_/C VGND VGND VPWR VPWR _5219_/B sky130_fd_sc_hd__or3_1
XANTENNA__4123__C1 _4271_/S1 VGND VGND VPWR VPWR sky130_fd_sc_hd__diode_2
X_5149_ _3958_/A _5148_/X _5147_/Y _5152_/B VGND VGND VPWR VPWR _5150_/B sky130_fd_sc_hd__a2bb2o_1
Xhold1643 _3588_/X VGND VGND VPWR VPWR _5622_/D sky130_fd_sc_hd__dlygate4sd3_1
Xhold1621 _5451_/Q VGND VGND VPWR VPWR _4048_/A2 sky130_fd_sc_hd__dlygate4sd3_1
Xhold1632 _3401_/X VGND VGND VPWR VPWR _5458_/D sky130_fd_sc_hd__dlygate4sd3_1
XFILLER_29_335 VGND VGND VPWR VPWR sky130_fd_sc_hd__fill_1
Xhold1665 _4846_/X VGND VGND VPWR VPWR _6198_/D sky130_fd_sc_hd__dlygate4sd3_1
Xhold1654 _5558_/Q VGND VGND VPWR VPWR _3514_/A1 sky130_fd_sc_hd__dlygate4sd3_1
XFILLER_84_474 VGND VGND VPWR VPWR sky130_fd_sc_hd__fill_2
Xhold1687 _5843_/Q VGND VGND VPWR VPWR _3861_/A1 sky130_fd_sc_hd__dlygate4sd3_1
XFILLER_56_165 VGND VGND VPWR VPWR sky130_fd_sc_hd__fill_1
Xhold1676 _5710_/Q VGND VGND VPWR VPWR _3688_/A1 sky130_fd_sc_hd__dlygate4sd3_1
Xhold1698 _3869_/X VGND VGND VPWR VPWR _5851_/D sky130_fd_sc_hd__dlygate4sd3_1
XFILLER_72_625 VGND VGND VPWR VPWR sky130_fd_sc_hd__fill_1
XFILLER_56_187 VGND VGND VPWR VPWR sky130_fd_sc_hd__fill_1
XFILLER_45_839 VGND VGND VPWR VPWR sky130_fd_sc_hd__fill_1
XFILLER_44_338 VGND VGND VPWR VPWR sky130_fd_sc_hd__fill_8
XFILLER_71_135 VGND VGND VPWR VPWR sky130_fd_sc_hd__fill_2
XFILLER_60_809 VGND VGND VPWR VPWR sky130_fd_sc_hd__fill_2
XANTENNA__4933__S _4934_/S VGND VGND VPWR VPWR sky130_fd_sc_hd__diode_2
XANTENNA__4977__A1 _5052_/A1 VGND VGND VPWR VPWR sky130_fd_sc_hd__diode_2
XFILLER_80_680 VGND VGND VPWR VPWR sky130_fd_sc_hd__fill_1
XFILLER_13_725 VGND VGND VPWR VPWR sky130_fd_sc_hd__fill_2
XFILLER_25_596 VGND VGND VPWR VPWR sky130_fd_sc_hd__fill_2
XFILLER_9_729 VPWR VGND VPWR VGND sky130_ef_sc_hd__decap_40_12
XANTENNA__4044__A1_N _4252_/B1 VGND VGND VPWR VPWR sky130_fd_sc_hd__diode_2
XANTENNA__3401__A1 _4984_/A1 VGND VGND VPWR VPWR sky130_fd_sc_hd__diode_2
XANTENNA__4674__A1_N _4811_/C1 VGND VGND VPWR VPWR sky130_fd_sc_hd__diode_2
XTAP_TAPCELL_ROW_10_447 VGND VPWR sky130_fd_sc_hd__tapvpwrvgnd_1
XANTENNA__3284__S _3295_/S VGND VGND VPWR VPWR sky130_fd_sc_hd__diode_2
XFILLER_125_115 VGND VGND VPWR VPWR sky130_fd_sc_hd__fill_2
XFILLER_107_841 VGND VGND VPWR VPWR sky130_fd_sc_hd__fill_1
XANTENNA__5154__A1 _3959_/A VGND VGND VPWR VPWR sky130_fd_sc_hd__diode_2
XFILLER_4_423 VGND VGND VPWR VPWR sky130_fd_sc_hd__fill_1
XFILLER_4_401 VPWR VGND VPWR VGND sky130_ef_sc_hd__decap_40_12
XFILLER_5_39 VPWR VGND VPWR VGND sky130_ef_sc_hd__decap_40_12
XFILLER_134_693 VGND VGND VPWR VPWR sky130_fd_sc_hd__fill_4
XFILLER_122_811 VGND VGND VPWR VPWR sky130_fd_sc_hd__fill_1
XFILLER_106_362 VGND VGND VPWR VPWR sky130_fd_sc_hd__fill_2
XFILLER_4_489 VPWR VGND VPWR VGND sky130_ef_sc_hd__decap_40_12
XANTENNA__4059__A1_N _4252_/B1 VGND VGND VPWR VPWR sky130_fd_sc_hd__diode_2
XFILLER_125_70 VGND VGND VPWR VPWR sky130_fd_sc_hd__fill_1
XFILLER_0_673 VPWR VGND VPWR VGND sky130_ef_sc_hd__decap_40_12
XFILLER_94_249 VGND VGND VPWR VPWR sky130_fd_sc_hd__fill_2
XFILLER_47_110 VGND VGND VPWR VPWR sky130_fd_sc_hd__fill_2
XFILLER_90_411 VGND VGND VPWR VPWR sky130_fd_sc_hd__fill_1
XFILLER_85_96 VGND VGND VPWR VPWR sky130_fd_sc_hd__fill_1
XANTENNA__4417__B1 _5222_/A VGND VGND VPWR VPWR sky130_fd_sc_hd__diode_2
XFILLER_35_327 VGND VGND VPWR VPWR sky130_fd_sc_hd__fill_1
XANTENNA_clkbuf_3_4__f_clk_X clkload3/A VGND VGND VPWR VPWR sky130_fd_sc_hd__diode_2
XANTENNA__4843__S _4854_/S VGND VGND VPWR VPWR sky130_fd_sc_hd__diode_2
XFILLER_51_809 VPWR VGND VPWR VGND sky130_ef_sc_hd__decap_40_12
XTAP_TAPCELL_ROW_102_1829 VGND VPWR sky130_fd_sc_hd__tapvpwrvgnd_1
XFILLER_90_488 VGND VGND VPWR VPWR sky130_fd_sc_hd__fill_1
XFILLER_90_477 VGND VGND VPWR VPWR sky130_fd_sc_hd__fill_1
XANTENNA__3640__A1 _5209_/A1 VGND VGND VPWR VPWR sky130_fd_sc_hd__diode_2
XFILLER_16_585 VGND VGND VPWR VPWR sky130_fd_sc_hd__fill_2
XTAP_TAPCELL_ROW_18_569 VGND VPWR sky130_fd_sc_hd__tapvpwrvgnd_1
XFILLER_31_511 VGND VGND VPWR VPWR sky130_fd_sc_hd__fill_1
XANTENNA__3459__S _3463_/S VGND VGND VPWR VPWR sky130_fd_sc_hd__diode_2
X_2850_ _3031_/A1 _2849_/X _3085_/A VGND VGND VPWR VPWR _2850_/X sky130_fd_sc_hd__o21a_1
XTAP_TAPCELL_ROW_135_2328 VGND VPWR sky130_fd_sc_hd__tapvpwrvgnd_1
X_2781_ _2735_/A _2766_/X _2780_/Y _2925_/S VGND VGND VPWR VPWR _2781_/X sky130_fd_sc_hd__o211a_1
X_4520_ hold479/X _5214_/A1 _4522_/S VGND VGND VPWR VPWR _4520_/X sky130_fd_sc_hd__mux2_1
Xhold217 _3300_/X VGND VGND VPWR VPWR _5418_/D sky130_fd_sc_hd__dlygate4sd3_1
Xhold206 _6157_/Q VGND VGND VPWR VPWR hold206/X sky130_fd_sc_hd__dlygate4sd3_1
X_4451_ _4451_/A _4451_/B VGND VGND VPWR VPWR _4451_/Y sky130_fd_sc_hd__nor2_1
Xhold228 _5303_/Q VGND VGND VPWR VPWR hold228/X sky130_fd_sc_hd__dlygate4sd3_1
Xhold239 _3698_/X VGND VGND VPWR VPWR _5719_/D sky130_fd_sc_hd__dlygate4sd3_1
X_3402_ hold2209/X _3402_/B VGND VGND VPWR VPWR _5038_/B sky130_fd_sc_hd__nand2b_4
XFILLER_131_129 VGND VGND VPWR VPWR sky130_fd_sc_hd__fill_1
XFILLER_125_671 VGND VGND VPWR VPWR sky130_fd_sc_hd__fill_1
XFILLER_113_833 VGND VGND VPWR VPWR sky130_fd_sc_hd__fill_4
XFILLER_98_533 VPWR VGND VPWR VGND sky130_ef_sc_hd__decap_40_12
XTAP_TAPCELL_ROW_59_1190 VGND VPWR sky130_fd_sc_hd__tapvpwrvgnd_1
X_4382_ hold545/X _4980_/A1 _4386_/S VGND VGND VPWR VPWR _4382_/X sky130_fd_sc_hd__mux2_1
X_6121_ _6121_/CLK _6121_/D VGND VGND VPWR VPWR _6121_/Q sky130_fd_sc_hd__dfxtp_1
XFILLER_124_192 VGND VGND VPWR VPWR sky130_fd_sc_hd__fill_2
X_3333_ _3975_/A _3975_/C _3964_/B VGND VGND VPWR VPWR _3976_/A sky130_fd_sc_hd__or3_1
XANTENNA__3459__A1 _4889_/A1 VGND VGND VPWR VPWR sky130_fd_sc_hd__diode_2
X_3264_ _3265_/A _3265_/B VGND VGND VPWR VPWR _4676_/A sky130_fd_sc_hd__and2_2
X_6052_ _6403_/CLK _6052_/D VGND VGND VPWR VPWR _6052_/Q sky130_fd_sc_hd__dfxtp_1
XPHY_EDGE_ROW_7_Right_7 VGND VGND VPWR VPWR sky130_fd_sc_hd__decap_3
XFILLER_85_227 VGND VGND VPWR VPWR sky130_fd_sc_hd__fill_4
X_5003_ _5003_/A _5003_/B VGND VGND VPWR VPWR _5004_/B sky130_fd_sc_hd__nand2_1
X_3195_ hold351/X _5821_/Q _3206_/S VGND VGND VPWR VPWR _3195_/X sky130_fd_sc_hd__mux2_1
XANTENNA__4408__A0 _5051_/A1 VGND VGND VPWR VPWR sky130_fd_sc_hd__diode_2
XFILLER_27_839 VGND VGND VPWR VPWR sky130_fd_sc_hd__fill_1
XFILLER_121_39 VGND VGND VPWR VPWR sky130_fd_sc_hd__fill_8
XANTENNA__5081__A0 _5237_/A0 VGND VGND VPWR VPWR sky130_fd_sc_hd__diode_2
XANTENNA__4753__S _4810_/S VGND VGND VPWR VPWR sky130_fd_sc_hd__diode_2
XFILLER_42_809 VGND VGND VPWR VPWR sky130_fd_sc_hd__fill_2
XANTENNA_fanout166_A _4221_/S VGND VGND VPWR VPWR sky130_fd_sc_hd__diode_2
XTAP_TAPCELL_ROW_37_856 VGND VPWR sky130_fd_sc_hd__tapvpwrvgnd_1
X_5905_ _6120_/CLK _5905_/D VGND VGND VPWR VPWR _5905_/Q sky130_fd_sc_hd__dfxtp_1
XANTENNA__3631__A1 _4958_/A0 VGND VGND VPWR VPWR sky130_fd_sc_hd__diode_2
XFILLER_14_15 VGND VGND VPWR VPWR sky130_fd_sc_hd__fill_4
X_5836_ _5841_/CLK _5836_/D VGND VGND VPWR VPWR _5836_/Q sky130_fd_sc_hd__dfxtp_1
XFILLER_61_190 VGND VGND VPWR VPWR sky130_fd_sc_hd__fill_4
X_2979_ _2975_/X _2977_/X _2978_/X _3089_/C1 VGND VGND VPWR VPWR _2979_/X sky130_fd_sc_hd__a22o_1
X_5767_ _6310_/CLK _5767_/D VGND VGND VPWR VPWR _5767_/Q sky130_fd_sc_hd__dfxtp_1
XANTENNA_fanout121_X _4899_/A0 VGND VGND VPWR VPWR sky130_fd_sc_hd__diode_2
X_5698_ _6122_/CLK _5698_/D VGND VGND VPWR VPWR _5698_/Q sky130_fd_sc_hd__dfxtp_1
X_4718_ _4802_/A _4718_/B VGND VGND VPWR VPWR _4718_/X sky130_fd_sc_hd__or2_1
X_4649_ hold47/X _4959_/A1 _4790_/S VGND VGND VPWR VPWR _4650_/B sky130_fd_sc_hd__mux2_1
XTAP_TAPCELL_ROW_75_1419 VGND VPWR sky130_fd_sc_hd__tapvpwrvgnd_1
Xhold751 _6074_/Q VGND VGND VPWR VPWR hold751/X sky130_fd_sc_hd__dlygate4sd3_1
XANTENNA__4895__A0 _5238_/A1 VGND VGND VPWR VPWR sky130_fd_sc_hd__diode_2
XFILLER_116_693 VGND VGND VPWR VPWR sky130_fd_sc_hd__fill_4
XFILLER_104_811 VGND VGND VPWR VPWR sky130_fd_sc_hd__fill_1
Xhold740 _4320_/X VGND VGND VPWR VPWR _5967_/D sky130_fd_sc_hd__dlygate4sd3_1
Xhold773 _6101_/Q VGND VGND VPWR VPWR hold773/X sky130_fd_sc_hd__dlygate4sd3_1
Xhold762 _3902_/X VGND VGND VPWR VPWR _5881_/D sky130_fd_sc_hd__dlygate4sd3_1
XANTENNA__3698__A1 _5202_/A1 VGND VGND VPWR VPWR sky130_fd_sc_hd__diode_2
XFILLER_131_641 VPWR VGND VPWR VGND sky130_ef_sc_hd__decap_40_12
Xhold784 _4873_/X VGND VGND VPWR VPWR _6223_/D sky130_fd_sc_hd__dlygate4sd3_1
Xhold795 _6133_/Q VGND VGND VPWR VPWR hold795/X sky130_fd_sc_hd__dlygate4sd3_1
X_6319_ _6341_/CLK _6319_/D VGND VGND VPWR VPWR _6319_/Q sky130_fd_sc_hd__dfxtp_1
XANTENNA__4928__S _4934_/S VGND VGND VPWR VPWR sky130_fd_sc_hd__diode_2
XANTENNA__6059__CLK clkload1/A VGND VGND VPWR VPWR sky130_fd_sc_hd__diode_2
XFILLER_131_685 VPWR VGND VPWR VGND sky130_ef_sc_hd__decap_40_12
XFILLER_89_588 VPWR VGND VPWR VGND sky130_ef_sc_hd__decap_40_12
Xhold2130 _6327_/Q VGND VGND VPWR VPWR _5000_/A sky130_fd_sc_hd__dlygate4sd3_1
Xhold2163 _2690_/X VGND VGND VPWR VPWR _5254_/D sky130_fd_sc_hd__dlygate4sd3_1
Xhold2141 _6255_/Q VGND VGND VPWR VPWR _4909_/A1 sky130_fd_sc_hd__dlygate4sd3_1
XFILLER_76_227 VGND VGND VPWR VPWR sky130_fd_sc_hd__fill_1
Xhold2152 _5323_/Q VGND VGND VPWR VPWR _2701_/B sky130_fd_sc_hd__dlygate4sd3_1
Xhold1451 _5520_/Q VGND VGND VPWR VPWR _3473_/A1 sky130_fd_sc_hd__dlygate4sd3_1
Xhold2174 _2679_/Y VGND VGND VPWR VPWR _5250_/D sky130_fd_sc_hd__dlygate4sd3_1
Xhold2196 _5822_/Q VGND VGND VPWR VPWR _2666_/A sky130_fd_sc_hd__dlygate4sd3_1
XFILLER_57_441 VGND VGND VPWR VPWR sky130_fd_sc_hd__fill_2
Xhold2185 _4999_/X VGND VGND VPWR VPWR _6327_/D sky130_fd_sc_hd__dlygate4sd3_1
Xhold1440 _3775_/X VGND VGND VPWR VPWR _5785_/D sky130_fd_sc_hd__dlygate4sd3_1
Xhold1495 _3535_/X VGND VGND VPWR VPWR _5578_/D sky130_fd_sc_hd__dlygate4sd3_1
Xhold1473 _6379_/Q VGND VGND VPWR VPWR _5091_/A0 sky130_fd_sc_hd__dlygate4sd3_1
Xhold1462 _6094_/Q VGND VGND VPWR VPWR _4488_/A1 sky130_fd_sc_hd__dlygate4sd3_1
Xhold1484 _3623_/X VGND VGND VPWR VPWR _5652_/D sky130_fd_sc_hd__dlygate4sd3_1
XANTENNA__5072__A0 _5228_/A0 VGND VGND VPWR VPWR sky130_fd_sc_hd__diode_2
XFILLER_55_55 VGND VGND VPWR VPWR sky130_fd_sc_hd__fill_1
XFILLER_33_809 VPWR VGND VPWR VGND sky130_ef_sc_hd__decap_40_12
XFILLER_111_61 VGND VGND VPWR VPWR sky130_fd_sc_hd__fill_1
XFILLER_71_21 VGND VGND VPWR VPWR sky130_fd_sc_hd__fill_8
XANTENNA__3622__A1 _4517_/A1 VGND VGND VPWR VPWR sky130_fd_sc_hd__diode_2
XTAP_TAPCELL_ROW_15_528 VGND VPWR sky130_fd_sc_hd__tapvpwrvgnd_1
XFILLER_25_393 VPWR VGND VPWR VGND sky130_ef_sc_hd__decap_40_12
XANTENNA__2830__C1 _3089_/C1 VGND VGND VPWR VPWR sky130_fd_sc_hd__diode_2
XFILLER_9_559 VGND VGND VPWR VPWR sky130_fd_sc_hd__fill_1
XTAP_TAPCELL_ROW_117_2058 VGND VPWR sky130_fd_sc_hd__tapvpwrvgnd_1
XFILLER_5_721 VGND VGND VPWR VPWR sky130_fd_sc_hd__fill_4
XFILLER_5_765 VPWR VGND VPWR VGND sky130_ef_sc_hd__decap_40_12
XTAP_TAPCELL_ROW_130_2247 VGND VPWR sky130_fd_sc_hd__tapvpwrvgnd_1
XFILLER_107_671 VGND VGND VPWR VPWR sky130_fd_sc_hd__fill_1
XFILLER_122_641 VGND VGND VPWR VPWR sky130_fd_sc_hd__fill_2
XANTENNA__3742__S _3745_/S VGND VGND VPWR VPWR sky130_fd_sc_hd__diode_2
XANTENNA__4838__S _4841_/S VGND VGND VPWR VPWR sky130_fd_sc_hd__diode_2
XFILLER_4_297 VGND VGND VPWR VPWR sky130_fd_sc_hd__fill_2
XTAP_TAPCELL_ROW_112_1980 VGND VPWR sky130_fd_sc_hd__tapvpwrvgnd_1
XFILLER_110_825 VPWR VGND VPWR VGND sky130_ef_sc_hd__decap_40_12
XFILLER_121_184 VGND VGND VPWR VPWR sky130_fd_sc_hd__fill_1
XFILLER_67_227 VGND VGND VPWR VPWR sky130_fd_sc_hd__fill_1
XFILLER_48_496 VGND VGND VPWR VPWR sky130_fd_sc_hd__fill_1
XFILLER_91_753 VPWR VGND VPWR VGND sky130_ef_sc_hd__decap_40_12
XFILLER_24_809 VGND VGND VPWR VPWR sky130_fd_sc_hd__fill_2
XFILLER_91_797 VPWR VGND VPWR VGND sky130_ef_sc_hd__decap_40_12
X_3951_ _3951_/A VGND VGND VPWR VPWR _3951_/Y sky130_fd_sc_hd__inv_2
XFILLER_23_308 VGND VGND VPWR VPWR sky130_fd_sc_hd__fill_2
XTAP_TAPCELL_ROW_34_804 VGND VPWR sky130_fd_sc_hd__tapvpwrvgnd_1
XTAP_TAPCELL_ROW_34_815 VGND VPWR sky130_fd_sc_hd__tapvpwrvgnd_1
X_2902_ _3036_/A1 _2901_/X _3096_/A1 VGND VGND VPWR VPWR _2902_/X sky130_fd_sc_hd__o21a_1
XANTENNA__3613__A1 _4961_/A0 VGND VGND VPWR VPWR sky130_fd_sc_hd__diode_2
X_3882_ hold222/X _4515_/A1 _3889_/S VGND VGND VPWR VPWR _3882_/X sky130_fd_sc_hd__mux2_1
X_2833_ _3034_/A _2833_/B VGND VGND VPWR VPWR _2833_/Y sky130_fd_sc_hd__nor2_1
X_5621_ _5870_/CLK _5621_/D VGND VGND VPWR VPWR _5621_/Q sky130_fd_sc_hd__dfxtp_1
X_2764_ _6435_/Q _6243_/Q _5403_/Q _5501_/Q _3051_/S _3050_/A VGND VGND VPWR VPWR
+ _2764_/X sky130_fd_sc_hd__mux4_1
X_5552_ _6129_/CLK _5552_/D VGND VGND VPWR VPWR _5552_/Q sky130_fd_sc_hd__dfxtp_1
XANTENNA__3377__B1 _4445_/B VGND VGND VPWR VPWR sky130_fd_sc_hd__diode_2
X_4503_ _4503_/A _4513_/B VGND VGND VPWR VPWR _4512_/S sky130_fd_sc_hd__nor2_4
XFILLER_8_581 VGND VGND VPWR VPWR sky130_fd_sc_hd__fill_4
XANTENNA_clkbuf_leaf_83_clk_A clkload1/A VGND VGND VPWR VPWR sky130_fd_sc_hd__diode_2
XFILLER_117_446 VGND VGND VPWR VPWR sky130_fd_sc_hd__fill_2
X_5483_ _6380_/CLK _5483_/D VGND VGND VPWR VPWR _5483_/Q sky130_fd_sc_hd__dfxtp_1
X_2695_ _4346_/A _5323_/Q _5322_/Q VGND VGND VPWR VPWR _5050_/A sky130_fd_sc_hd__or3_2
X_4434_ _5089_/A0 _4994_/B _3801_/B VGND VGND VPWR VPWR _4434_/X sky130_fd_sc_hd__a21o_1
XTAP_TAPCELL_ROW_57_1149 VGND VPWR sky130_fd_sc_hd__tapvpwrvgnd_1
XFILLER_113_641 VPWR VGND VPWR VGND sky130_ef_sc_hd__decap_40_12
XFILLER_104_129 VGND VGND VPWR VPWR sky130_fd_sc_hd__fill_1
X_4365_ _4365_/A0 _5046_/A1 _4366_/S VGND VGND VPWR VPWR _4365_/X sky130_fd_sc_hd__mux2_1
XANTENNA_clkbuf_leaf_98_clk_A clkload0/A VGND VGND VPWR VPWR sky130_fd_sc_hd__diode_2
XFILLER_113_685 VPWR VGND VPWR VGND sky130_ef_sc_hd__decap_40_12
X_3316_ _6354_/Q _5332_/Q VGND VGND VPWR VPWR _3316_/X sky130_fd_sc_hd__and2b_1
X_6104_ _6121_/CLK _6104_/D VGND VGND VPWR VPWR _6104_/Q sky130_fd_sc_hd__dfxtp_1
XTAP_TAPCELL_ROW_70_1349 VGND VPWR sky130_fd_sc_hd__tapvpwrvgnd_1
X_4296_ hold157/X _5051_/A1 _4304_/S VGND VGND VPWR VPWR _4296_/X sky130_fd_sc_hd__mux2_1
X_6035_ _6314_/CLK _6035_/D VGND VGND VPWR VPWR _6035_/Q sky130_fd_sc_hd__dfxtp_1
XFILLER_132_27 VGND VGND VPWR VPWR sky130_fd_sc_hd__fill_1
XANTENNA_clkbuf_leaf_21_clk_A clkload3/A VGND VGND VPWR VPWR sky130_fd_sc_hd__diode_2
XFILLER_86_569 VGND VGND VPWR VPWR sky130_fd_sc_hd__fill_1
X_3247_ _5385_/Q _5384_/Q _5383_/Q VGND VGND VPWR VPWR _4493_/A sky130_fd_sc_hd__nand3_4
XFILLER_82_720 VGND VGND VPWR VPWR sky130_fd_sc_hd__fill_4
XFILLER_67_783 VGND VGND VPWR VPWR sky130_fd_sc_hd__fill_1
XFILLER_54_400 VGND VGND VPWR VPWR sky130_fd_sc_hd__fill_4
X_3178_ _2703_/A _3177_/A _5085_/A VGND VGND VPWR VPWR _3178_/Y sky130_fd_sc_hd__a21oi_1
XFILLER_39_463 VGND VGND VPWR VPWR sky130_fd_sc_hd__fill_1
XFILLER_15_809 VPWR VGND VPWR VGND sky130_ef_sc_hd__decap_40_12
XFILLER_27_647 VGND VGND VPWR VPWR sky130_fd_sc_hd__fill_1
XFILLER_25_36 VGND VGND VPWR VPWR sky130_fd_sc_hd__fill_2
XANTENNA_fanout169_X _4262_/S VGND VGND VPWR VPWR sky130_fd_sc_hd__diode_2
XANTENNA_clkbuf_leaf_36_clk_A clkload4/A VGND VGND VPWR VPWR sky130_fd_sc_hd__diode_2
XTAP_TAPCELL_ROW_85_1581 VGND VPWR sky130_fd_sc_hd__tapvpwrvgnd_1
XTAP_TAPCELL_ROW_85_1570 VGND VPWR sky130_fd_sc_hd__tapvpwrvgnd_1
XANTENNA__3604__A1 _5215_/A1 VGND VGND VPWR VPWR sky130_fd_sc_hd__diode_2
XFILLER_25_47 VGND VGND VPWR VPWR sky130_fd_sc_hd__fill_4
X_5819_ _6261_/CLK _5819_/D VGND VGND VPWR VPWR _5819_/Q sky130_fd_sc_hd__dfxtp_2
XFILLER_10_525 VGND VGND VPWR VPWR sky130_fd_sc_hd__fill_4
XFILLER_22_363 VGND VGND VPWR VPWR sky130_fd_sc_hd__fill_1
XFILLER_10_569 VPWR VGND VPWR VGND sky130_ef_sc_hd__decap_40_12
XFILLER_6_529 VGND VGND VPWR VPWR sky130_fd_sc_hd__fill_2
XFILLER_136_755 VGND VGND VPWR VPWR sky130_fd_sc_hd__fill_1
XTAP_TAPCELL_ROW_20_597 VGND VPWR sky130_fd_sc_hd__tapvpwrvgnd_1
XFILLER_2_713 VPWR VGND VPWR VGND sky130_ef_sc_hd__decap_40_12
XFILLER_104_641 VGND VGND VPWR VPWR sky130_fd_sc_hd__fill_2
Xhold581 _3906_/X VGND VGND VPWR VPWR _5885_/D sky130_fd_sc_hd__dlygate4sd3_1
Xhold570 _5968_/Q VGND VGND VPWR VPWR hold570/X sky130_fd_sc_hd__dlygate4sd3_1
XFILLER_2_757 VPWR VGND VPWR VGND sky130_ef_sc_hd__decap_40_12
Xhold592 _5642_/Q VGND VGND VPWR VPWR hold592/X sky130_fd_sc_hd__dlygate4sd3_1
XFILLER_49_205 VGND VGND VPWR VPWR sky130_fd_sc_hd__fill_1
XANTENNA_clkbuf_leaf_109_clk_A clkload0/A VGND VGND VPWR VPWR sky130_fd_sc_hd__diode_2
XFILLER_77_525 VGND VGND VPWR VPWR sky130_fd_sc_hd__fill_4
XFILLER_2_29 VPWR VGND VPWR VGND sky130_ef_sc_hd__decap_40_12
Xhold1270 _3185_/X VGND VGND VPWR VPWR _5348_/D sky130_fd_sc_hd__dlygate4sd3_1
XFILLER_66_87 VGND VGND VPWR VPWR sky130_fd_sc_hd__fill_1
XFILLER_18_625 VPWR VGND VPWR VGND sky130_ef_sc_hd__decap_40_12
XANTENNA__2906__S _3086_/S VGND VGND VPWR VPWR sky130_fd_sc_hd__diode_2
XANTENNA__3798__A _3801_/A VGND VGND VPWR VPWR sky130_fd_sc_hd__diode_2
XANTENNA_input11_A s_axil_rready VGND VGND VPWR VPWR sky130_fd_sc_hd__diode_2
XFILLER_18_669 VPWR VGND VPWR VGND sky130_ef_sc_hd__decap_40_12
Xhold1292 _4312_/X VGND VGND VPWR VPWR _5960_/D sky130_fd_sc_hd__dlygate4sd3_1
Xhold1281 _5994_/Q VGND VGND VPWR VPWR _4351_/A0 sky130_fd_sc_hd__dlygate4sd3_1
XFILLER_73_797 VPWR VGND VPWR VGND sky130_ef_sc_hd__decap_40_12
XFILLER_82_53 VGND VGND VPWR VPWR sky130_fd_sc_hd__fill_4
XFILLER_72_296 VPWR VGND VPWR VGND sky130_ef_sc_hd__decap_40_12
XFILLER_60_425 VGND VGND VPWR VPWR sky130_fd_sc_hd__fill_1
XFILLER_45_499 VGND VGND VPWR VPWR sky130_fd_sc_hd__fill_2
XFILLER_32_149 VGND VGND VPWR VPWR sky130_fd_sc_hd__fill_2
XANTENNA__3737__S _3745_/S VGND VGND VPWR VPWR sky130_fd_sc_hd__diode_2
XFILLER_70_8 VPWR VGND VPWR VGND sky130_ef_sc_hd__decap_40_12
XANTENNA__4422__A input5/X VGND VGND VPWR VPWR sky130_fd_sc_hd__diode_2
XFILLER_127_777 VGND VGND VPWR VPWR sky130_fd_sc_hd__fill_4
XFILLER_126_243 VGND VGND VPWR VPWR sky130_fd_sc_hd__fill_1
XANTENNA__6410__Q _6410_/Q VGND VGND VPWR VPWR sky130_fd_sc_hd__diode_2
XANTENNA__4859__A0 _5241_/A1 VGND VGND VPWR VPWR sky130_fd_sc_hd__diode_2
XFILLER_5_573 VPWR VGND VPWR VGND sky130_ef_sc_hd__decap_40_12
XANTENNA__4568__S _4713_/S VGND VGND VPWR VPWR sky130_fd_sc_hd__diode_2
XFILLER_49_5 VGND VGND VPWR VPWR sky130_fd_sc_hd__fill_1
XANTENNA__3472__S _3477_/S VGND VGND VPWR VPWR sky130_fd_sc_hd__diode_2
X_4150_ _5986_/Q _5977_/Q _4262_/S VGND VGND VPWR VPWR _4151_/B sky130_fd_sc_hd__mux2_1
X_3101_ hold89/X _5238_/A1 _3112_/S VGND VGND VPWR VPWR hold90/A sky130_fd_sc_hd__mux2_1
XTAP_TAPCELL_ROW_52_1079 VGND VPWR sky130_fd_sc_hd__tapvpwrvgnd_1
X_4081_ _4252_/A1 _4078_/X _4252_/B1 VGND VGND VPWR VPWR _4081_/X sky130_fd_sc_hd__o21a_1
XFILLER_110_699 VGND VGND VPWR VPWR sky130_fd_sc_hd__fill_1
X_3032_ _3027_/X _3031_/X _2995_/A VGND VGND VPWR VPWR _3032_/Y sky130_fd_sc_hd__o21ai_1
XFILLER_49_783 VGND VGND VPWR VPWR sky130_fd_sc_hd__fill_1
XFILLER_91_561 VPWR VGND VPWR VGND sky130_ef_sc_hd__decap_40_12
XFILLER_63_263 VGND VGND VPWR VPWR sky130_fd_sc_hd__fill_1
XFILLER_51_447 VGND VGND VPWR VPWR sky130_fd_sc_hd__fill_1
X_4983_ hold671/X _4983_/A1 _4984_/S VGND VGND VPWR VPWR _4983_/X sky130_fd_sc_hd__mux2_1
X_3934_ _5043_/A1 _4135_/A1 _3938_/S VGND VGND VPWR VPWR _5910_/D sky130_fd_sc_hd__mux2_1
X_3865_ _4488_/A0 _3865_/A1 _3869_/S VGND VGND VPWR VPWR _5847_/D sky130_fd_sc_hd__mux2_1
X_2816_ _3031_/A1 _2815_/X _3089_/C1 VGND VGND VPWR VPWR _2816_/X sky130_fd_sc_hd__o21a_1
X_5604_ _6097_/CLK _5604_/D VGND VGND VPWR VPWR _5604_/Q sky130_fd_sc_hd__dfxtp_1
XANTENNA_fanout129_A _5813_/Q VGND VGND VPWR VPWR sky130_fd_sc_hd__diode_2
XANTENNA__4011__A1 _5201_/B VGND VGND VPWR VPWR sky130_fd_sc_hd__diode_2
X_3796_ _3796_/A0 _5215_/A1 _3797_/S VGND VGND VPWR VPWR _3796_/X sky130_fd_sc_hd__mux2_1
XFILLER_118_755 VGND VGND VPWR VPWR sky130_fd_sc_hd__fill_1
X_5535_ _5571_/CLK _5535_/D VGND VGND VPWR VPWR _5535_/Q sky130_fd_sc_hd__dfxtp_1
X_2747_ hold485/X _5075_/A0 _2753_/S VGND VGND VPWR VPWR _2747_/X sky130_fd_sc_hd__mux2_1
XFILLER_11_27 VGND VGND VPWR VPWR sky130_fd_sc_hd__fill_1
XFILLER_133_725 VGND VGND VPWR VPWR sky130_fd_sc_hd__fill_2
XFILLER_127_27 VGND VGND VPWR VPWR sky130_fd_sc_hd__fill_4
XFILLER_117_265 VGND VGND VPWR VPWR sky130_fd_sc_hd__fill_1
XFILLER_105_427 VGND VGND VPWR VPWR sky130_fd_sc_hd__fill_2
X_2678_ _3207_/B _3207_/C _5222_/A VGND VGND VPWR VPWR _2678_/X sky130_fd_sc_hd__a21o_1
X_5466_ _5908_/CLK _5466_/D VGND VGND VPWR VPWR _5466_/Q sky130_fd_sc_hd__dfxtp_1
XANTENNA__3770__A0 _4978_/A1 VGND VGND VPWR VPWR sky130_fd_sc_hd__diode_2
XFILLER_132_213 VGND VGND VPWR VPWR sky130_fd_sc_hd__fill_1
X_4417_ _2982_/S _4417_/A2 _5222_/A VGND VGND VPWR VPWR _6054_/D sky130_fd_sc_hd__a21oi_1
XANTENNA__3522__A0 _4899_/A0 VGND VGND VPWR VPWR sky130_fd_sc_hd__diode_2
X_5397_ _6418_/CLK _5397_/D VGND VGND VPWR VPWR _5397_/Q sky130_fd_sc_hd__dfxtp_1
XANTENNA__3382__S _3390_/S VGND VGND VPWR VPWR sky130_fd_sc_hd__diode_2
XANTENNA_input3_A rst VGND VGND VPWR VPWR sky130_fd_sc_hd__diode_2
X_4348_ hold165/X _5051_/A1 _4356_/S VGND VGND VPWR VPWR _4348_/X sky130_fd_sc_hd__mux2_1
X_4279_ hold109/X _5042_/A1 _4284_/S VGND VGND VPWR VPWR _4279_/X sky130_fd_sc_hd__mux2_1
XTAP_TAPCELL_ROW_87_1610 VGND VPWR sky130_fd_sc_hd__tapvpwrvgnd_1
XFILLER_74_528 VGND VGND VPWR VPWR sky130_fd_sc_hd__fill_2
XFILLER_46_208 VGND VGND VPWR VPWR sky130_fd_sc_hd__fill_4
X_6018_ _6421_/CLK _6018_/D VGND VGND VPWR VPWR _6018_/Q sky130_fd_sc_hd__dfxtp_1
XANTENNA__3825__A1 _5052_/A1 VGND VGND VPWR VPWR sky130_fd_sc_hd__diode_2
XFILLER_55_764 VPWR VGND VPWR VGND sky130_ef_sc_hd__decap_40_12
XFILLER_15_617 VPWR VGND VPWR VGND sky130_ef_sc_hd__decap_40_12
XFILLER_70_745 VGND VGND VPWR VPWR sky130_fd_sc_hd__fill_1
XFILLER_55_797 VPWR VGND VPWR VGND sky130_ef_sc_hd__decap_40_12
XFILLER_42_436 VGND VGND VPWR VPWR sky130_fd_sc_hd__fill_1
XANTENNA__4941__S _4944_/S VGND VGND VPWR VPWR sky130_fd_sc_hd__diode_2
XFILLER_22_160 VGND VGND VPWR VPWR sky130_fd_sc_hd__fill_1
XTAP_TAPCELL_ROW_25_678 VGND VPWR sky130_fd_sc_hd__tapvpwrvgnd_1
XFILLER_50_491 VGND VGND VPWR VPWR sky130_fd_sc_hd__fill_1
XFILLER_10_377 VPWR VGND VPWR VGND sky130_ef_sc_hd__decap_40_12
XTAP_TAPCELL_ROW_114_2017 VGND VPWR sky130_fd_sc_hd__tapvpwrvgnd_1
XTAP_TAPCELL_ROW_114_2006 VGND VPWR sky130_fd_sc_hd__tapvpwrvgnd_1
XTAP_TAPCELL_ROW_98_1772 VGND VPWR sky130_fd_sc_hd__tapvpwrvgnd_1
XFILLER_136_585 VGND VGND VPWR VPWR sky130_fd_sc_hd__fill_2
XFILLER_124_725 VPWR VGND VPWR VGND sky130_ef_sc_hd__decap_40_12
XFILLER_109_777 VGND VGND VPWR VPWR sky130_fd_sc_hd__fill_4
XFILLER_124_769 VPWR VGND VPWR VGND sky130_ef_sc_hd__decap_40_12
XANTENNA__2697__A _4262_/S VGND VGND VPWR VPWR sky130_fd_sc_hd__diode_2
XANTENNA__3292__S _3295_/S VGND VGND VPWR VPWR sky130_fd_sc_hd__diode_2
XFILLER_97_609 VGND VGND VPWR VPWR sky130_fd_sc_hd__fill_4
XANTENNA__3513__A0 _5234_/A0 VGND VGND VPWR VPWR sky130_fd_sc_hd__diode_2
XFILLER_78_801 VGND VGND VPWR VPWR sky130_fd_sc_hd__fill_8
XFILLER_104_493 VGND VGND VPWR VPWR sky130_fd_sc_hd__fill_1
XFILLER_2_587 VGND VGND VPWR VPWR sky130_fd_sc_hd__fill_1
XFILLER_38_709 VGND VGND VPWR VPWR sky130_fd_sc_hd__fill_2
XFILLER_93_837 VGND VGND VPWR VPWR sky130_fd_sc_hd__fill_2
XTAP_TAPCELL_ROW_5_381 VGND VPWR sky130_fd_sc_hd__tapvpwrvgnd_1
XTAP_TAPCELL_ROW_5_370 VGND VPWR sky130_fd_sc_hd__tapvpwrvgnd_1
XTAP_TAPCELL_ROW_125_2168 VGND VPWR sky130_fd_sc_hd__tapvpwrvgnd_1
XANTENNA__3816__A1 _5228_/A0 VGND VGND VPWR VPWR sky130_fd_sc_hd__diode_2
XFILLER_18_433 VPWR VGND VPWR VGND sky130_ef_sc_hd__decap_40_12
XTAP_TAPCELL_ROW_125_2179 VGND VPWR sky130_fd_sc_hd__tapvpwrvgnd_1
XFILLER_92_369 VGND VGND VPWR VPWR sky130_fd_sc_hd__fill_1
XFILLER_46_786 VPWR VGND VPWR VGND sky130_ef_sc_hd__decap_40_12
XFILLER_18_477 VPWR VGND VPWR VGND sky130_ef_sc_hd__decap_40_12
XFILLER_61_723 VGND VGND VPWR VPWR sky130_fd_sc_hd__fill_1
XANTENNA__4851__S _4854_/S VGND VGND VPWR VPWR sky130_fd_sc_hd__diode_2
XTAP_TAPCELL_ROW_44_965 VGND VPWR sky130_fd_sc_hd__tapvpwrvgnd_1
XTAP_TAPCELL_ROW_44_954 VGND VPWR sky130_fd_sc_hd__tapvpwrvgnd_1
XANTENNA__3467__S _3477_/S VGND VGND VPWR VPWR sky130_fd_sc_hd__diode_2
X_3650_ hold855/X _4515_/A1 _3657_/S VGND VGND VPWR VPWR _3650_/X sky130_fd_sc_hd__mux2_1
XFILLER_127_541 VPWR VGND VPWR VGND sky130_ef_sc_hd__decap_40_12
X_3581_ hold471/X _4961_/A0 _3584_/S VGND VGND VPWR VPWR _3581_/X sky130_fd_sc_hd__mux2_1
XFILLER_9_186 VGND VGND VPWR VPWR sky130_fd_sc_hd__fill_1
XFILLER_127_585 VPWR VGND VPWR VGND sky130_ef_sc_hd__decap_40_12
XFILLER_115_725 VGND VGND VPWR VPWR sky130_fd_sc_hd__fill_2
XANTENNA__3752__A0 _4981_/A1 VGND VGND VPWR VPWR sky130_fd_sc_hd__diode_2
X_5320_ _5988_/CLK _5320_/D VGND VGND VPWR VPWR _5320_/Q sky130_fd_sc_hd__dfxtp_1
X_5251_ _6199_/CLK _5251_/D VGND VGND VPWR VPWR _5251_/Q sky130_fd_sc_hd__dfxtp_2
XTAP_TAPCELL_ROW_54_1108 VGND VPWR sky130_fd_sc_hd__tapvpwrvgnd_1
XFILLER_102_419 VGND VGND VPWR VPWR sky130_fd_sc_hd__fill_1
X_4202_ _4260_/S _4202_/B VGND VGND VPWR VPWR _4202_/Y sky130_fd_sc_hd__nor2_1
X_5182_ _3958_/A _5181_/X _5175_/S _2622_/Y _3951_/Y VGND VGND VPWR VPWR _5182_/Y
+ sky130_fd_sc_hd__o2111ai_1
X_4133_ _4133_/A1 _4218_/A _4117_/X _4132_/Y VGND VGND VPWR VPWR _4133_/X sky130_fd_sc_hd__a22o_1
XFILLER_96_697 VGND VGND VPWR VPWR sky130_fd_sc_hd__fill_2
XFILLER_84_837 VGND VGND VPWR VPWR sky130_fd_sc_hd__fill_4
X_4064_ _5983_/Q _5974_/Q _4262_/S VGND VGND VPWR VPWR _4065_/B sky130_fd_sc_hd__mux2_1
X_3015_ _3044_/A _3015_/B VGND VGND VPWR VPWR _3015_/X sky130_fd_sc_hd__or2_1
XANTENNA__3807__A1 _5234_/A0 VGND VGND VPWR VPWR sky130_fd_sc_hd__diode_2
XTAP_TAPCELL_ROW_69_1340 VGND VPWR sky130_fd_sc_hd__tapvpwrvgnd_1
XFILLER_37_742 VGND VGND VPWR VPWR sky130_fd_sc_hd__fill_1
XFILLER_83_369 VGND VGND VPWR VPWR sky130_fd_sc_hd__fill_1
XANTENNA__4480__A1 _5214_/A1 VGND VGND VPWR VPWR sky130_fd_sc_hd__diode_2
XFILLER_52_734 VGND VGND VPWR VPWR sky130_fd_sc_hd__fill_4
XFILLER_37_797 VPWR VGND VPWR VGND sky130_ef_sc_hd__decap_40_12
XFILLER_91_391 VGND VGND VPWR VPWR sky130_fd_sc_hd__fill_1
X_4966_ _4976_/A1 _4966_/A1 _4974_/S VGND VGND VPWR VPWR _4966_/X sky130_fd_sc_hd__mux2_1
XTAP_TAPCELL_ROW_22_626 VGND VPWR sky130_fd_sc_hd__tapvpwrvgnd_1
X_4897_ _4445_/A hold759/X _4906_/S VGND VGND VPWR VPWR _4897_/X sky130_fd_sc_hd__mux2_1
XFILLER_22_15 VPWR VGND VPWR VGND sky130_ef_sc_hd__decap_40_12
XTAP_TAPCELL_ROW_22_637 VGND VPWR sky130_fd_sc_hd__tapvpwrvgnd_1
X_3917_ hold75/X _5215_/A1 _3918_/S VGND VGND VPWR VPWR hold76/A sky130_fd_sc_hd__mux2_1
XFILLER_138_839 VGND VGND VPWR VPWR sky130_fd_sc_hd__fill_1
XFILLER_138_15 VPWR VGND VPWR VGND sky130_ef_sc_hd__decap_40_12
XANTENNA__2794__B2 _3075_/C1 VGND VGND VPWR VPWR sky130_fd_sc_hd__diode_2
X_3848_ _3848_/A _3852_/B VGND VGND VPWR VPWR _3848_/X sky130_fd_sc_hd__or2_1
XFILLER_20_697 VGND VGND VPWR VPWR sky130_fd_sc_hd__fill_2
X_3779_ hold627/X _5208_/A1 _3787_/S VGND VGND VPWR VPWR _3779_/X sky130_fd_sc_hd__mux2_1
X_5518_ _6437_/CLK _5518_/D VGND VGND VPWR VPWR _5518_/Q sky130_fd_sc_hd__dfxtp_1
XFILLER_118_585 VGND VGND VPWR VPWR sky130_fd_sc_hd__fill_2
XFILLER_106_725 VPWR VGND VPWR VGND sky130_ef_sc_hd__decap_40_12
XANTENNA_fanout201_X _5200_/A VGND VGND VPWR VPWR sky130_fd_sc_hd__diode_2
XFILLER_106_769 VPWR VGND VPWR VGND sky130_ef_sc_hd__decap_40_12
XANTENNA__4299__A1 _5042_/A1 VGND VGND VPWR VPWR sky130_fd_sc_hd__diode_2
X_5449_ _5784_/CLK _5449_/D VGND VGND VPWR VPWR _5449_/Q sky130_fd_sc_hd__dfxtp_1
XFILLER_105_279 VGND VGND VPWR VPWR sky130_fd_sc_hd__fill_1
XFILLER_99_491 VGND VGND VPWR VPWR sky130_fd_sc_hd__fill_1
XTAP_TAPCELL_ROW_93_1691 VGND VPWR sky130_fd_sc_hd__tapvpwrvgnd_1
Xfanout121 _5817_/Q VGND VGND VPWR VPWR _4899_/A0 sky130_fd_sc_hd__clkbuf_8
Xfanout110 hold2219/X VGND VGND VPWR VPWR _5051_/A1 sky130_fd_sc_hd__buf_4
XFILLER_86_141 VGND VGND VPWR VPWR sky130_fd_sc_hd__fill_2
Xfanout132 hold2233/X VGND VGND VPWR VPWR _5232_/A0 sky130_fd_sc_hd__buf_4
Xfanout143 _4794_/A VGND VGND VPWR VPWR _4789_/A sky130_fd_sc_hd__buf_4
XFILLER_59_333 VGND VGND VPWR VPWR sky130_fd_sc_hd__fill_2
Xfanout154 hold2213/X VGND VGND VPWR VPWR _4713_/S sky130_fd_sc_hd__buf_4
XANTENNA__4936__S _4944_/S VGND VGND VPWR VPWR sky130_fd_sc_hd__diode_2
Xfanout165 _4221_/S VGND VGND VPWR VPWR _4237_/S sky130_fd_sc_hd__clkbuf_8
Xfanout187 _3020_/A VGND VGND VPWR VPWR _3050_/A sky130_fd_sc_hd__buf_4
Xfanout198 _3033_/S VGND VGND VPWR VPWR _3077_/S sky130_fd_sc_hd__clkbuf_8
Xfanout176 hold2239/X VGND VGND VPWR VPWR _2995_/A sky130_fd_sc_hd__clkbuf_4
XFILLER_75_837 VGND VGND VPWR VPWR sky130_fd_sc_hd__fill_2
XFILLER_59_399 VGND VGND VPWR VPWR sky130_fd_sc_hd__fill_2
XFILLER_28_753 VGND VGND VPWR VPWR sky130_fd_sc_hd__fill_2
XFILLER_103_73 VGND VGND VPWR VPWR sky130_fd_sc_hd__fill_1
XFILLER_70_564 VGND VGND VPWR VPWR sky130_fd_sc_hd__fill_2
XANTENNA__4671__S _4810_/S VGND VGND VPWR VPWR sky130_fd_sc_hd__diode_2
XFILLER_15_447 VGND VGND VPWR VPWR sky130_fd_sc_hd__fill_1
XTAP_TAPCELL_ROW_120_2098 VGND VPWR sky130_fd_sc_hd__tapvpwrvgnd_1
XFILLER_70_575 VGND VGND VPWR VPWR sky130_fd_sc_hd__fill_4
XTAP_TAPCELL_ROW_41_913 VGND VPWR sky130_fd_sc_hd__tapvpwrvgnd_1
XANTENNA__3287__S _3295_/S VGND VGND VPWR VPWR sky130_fd_sc_hd__diode_2
XFILLER_129_839 VGND VGND VPWR VPWR sky130_fd_sc_hd__fill_1
XFILLER_7_613 VGND VGND VPWR VPWR sky130_fd_sc_hd__fill_2
XFILLER_11_653 VPWR VGND VPWR VGND sky130_ef_sc_hd__decap_40_12
XFILLER_11_697 VPWR VGND VPWR VGND sky130_ef_sc_hd__decap_40_12
XFILLER_109_585 VPWR VGND VPWR VGND sky130_ef_sc_hd__decap_40_12
XANTENNA__4082__S0 _4237_/S VGND VGND VPWR VPWR sky130_fd_sc_hd__diode_2
XFILLER_124_533 VPWR VGND VPWR VGND sky130_ef_sc_hd__decap_40_12
XFILLER_88_41 VGND VGND VPWR VPWR sky130_fd_sc_hd__fill_4
XFILLER_3_841 VGND VGND VPWR VPWR sky130_fd_sc_hd__fill_1
XTAP_TAPCELL_ROW_127_2208 VGND VPWR sky130_fd_sc_hd__tapvpwrvgnd_1
XANTENNA__4846__S _4854_/S VGND VGND VPWR VPWR sky130_fd_sc_hd__diode_2
XTAP_TAPCELL_ROW_109_1941 VGND VPWR sky130_fd_sc_hd__tapvpwrvgnd_1
XTAP_TAPCELL_ROW_109_1930 VGND VPWR sky130_fd_sc_hd__tapvpwrvgnd_1
XFILLER_77_185 VGND VGND VPWR VPWR sky130_fd_sc_hd__fill_1
XFILLER_19_753 VPWR VGND VPWR VGND sky130_ef_sc_hd__decap_40_12
XFILLER_19_797 VPWR VGND VPWR VGND sky130_ef_sc_hd__decap_40_12
XANTENNA__2890__A _3005_/A VGND VGND VPWR VPWR sky130_fd_sc_hd__diode_2
X_4820_ _4846_/A0 _4820_/A1 _4828_/S VGND VGND VPWR VPWR _4820_/X sky130_fd_sc_hd__mux2_1
XANTENNA__4434__X _4434_/X VGND VGND VPWR VPWR sky130_fd_sc_hd__diode_2
XANTENNA__4214__A1 _4264_/A1 VGND VGND VPWR VPWR sky130_fd_sc_hd__diode_2
XFILLER_21_417 VPWR VGND VPWR VGND sky130_ef_sc_hd__decap_40_12
X_4751_ _5717_/Q _5708_/Q _4810_/S VGND VGND VPWR VPWR _4752_/B sky130_fd_sc_hd__mux2_1
X_3702_ _5211_/A1 _4648_/A3 _3707_/S VGND VGND VPWR VPWR _3702_/X sky130_fd_sc_hd__mux2_1
X_4682_ _5472_/Q _5643_/Q _5634_/Q _5724_/Q _4773_/S _4789_/A VGND VGND VPWR VPWR
+ _4682_/X sky130_fd_sc_hd__mux4_1
XFILLER_135_809 VPWR VGND VPWR VGND sky130_ef_sc_hd__decap_40_12
X_6421_ _6421_/CLK _6421_/D VGND VGND VPWR VPWR _6459_/A sky130_fd_sc_hd__dfxtp_1
X_3633_ _3633_/A0 _4488_/A0 _3637_/S VGND VGND VPWR VPWR _3633_/X sky130_fd_sc_hd__mux2_1
XFILLER_127_393 VGND VGND VPWR VPWR sky130_fd_sc_hd__fill_1
XFILLER_108_29 VPWR VGND VPWR VGND sky130_ef_sc_hd__decap_40_12
X_6352_ _6403_/CLK _6352_/D VGND VGND VPWR VPWR _6352_/Q sky130_fd_sc_hd__dfxtp_1
X_3564_ _3585_/A _3668_/B _3668_/C VGND VGND VPWR VPWR _4483_/B sky130_fd_sc_hd__or3_4
X_3495_ _4846_/A0 _3495_/A1 _3503_/S VGND VGND VPWR VPWR _3495_/X sky130_fd_sc_hd__mux2_1
XFILLER_130_503 VPWR VGND VPWR VGND sky130_ef_sc_hd__decap_40_12
X_5303_ _6369_/CLK _5303_/D VGND VGND VPWR VPWR _5303_/Q sky130_fd_sc_hd__dfxtp_1
X_6283_ _6315_/CLK _6283_/D VGND VGND VPWR VPWR _6283_/Q sky130_fd_sc_hd__dfxtp_1
X_5234_ _5234_/A0 _5234_/A1 _5237_/S VGND VGND VPWR VPWR _6431_/D sky130_fd_sc_hd__mux2_1
XANTENNA__3226__A _4663_/A VGND VGND VPWR VPWR sky130_fd_sc_hd__diode_2
XFILLER_130_569 VPWR VGND VPWR VGND sky130_ef_sc_hd__decap_40_12
X_5165_ _5175_/S _5165_/B VGND VGND VPWR VPWR _5165_/Y sky130_fd_sc_hd__nand2_1
XFILLER_111_783 VGND VGND VPWR VPWR sky130_fd_sc_hd__fill_1
XANTENNA_fanout196_A _3033_/S VGND VGND VPWR VPWR sky130_fd_sc_hd__diode_2
Xhold1825 _4960_/X VGND VGND VPWR VPWR _6294_/D sky130_fd_sc_hd__dlygate4sd3_1
XANTENNA__3660__S _3667_/S VGND VGND VPWR VPWR sky130_fd_sc_hd__diode_2
Xhold1836 _5625_/Q VGND VGND VPWR VPWR _3591_/A0 sky130_fd_sc_hd__dlygate4sd3_1
XFILLER_57_837 VGND VGND VPWR VPWR sky130_fd_sc_hd__fill_2
X_4116_ _4260_/S _4116_/B VGND VGND VPWR VPWR _4116_/Y sky130_fd_sc_hd__nor2_1
Xhold1814 _5907_/Q VGND VGND VPWR VPWR _4049_/A1 sky130_fd_sc_hd__dlygate4sd3_1
Xhold1803 _3936_/X VGND VGND VPWR VPWR _5912_/D sky130_fd_sc_hd__dlygate4sd3_1
XANTENNA__2700__B2 _2635_/Y VGND VGND VPWR VPWR sky130_fd_sc_hd__diode_2
Xhold1869 _5570_/Q VGND VGND VPWR VPWR _3527_/A1 sky130_fd_sc_hd__dlygate4sd3_1
XFILLER_83_122 VGND VGND VPWR VPWR sky130_fd_sc_hd__fill_1
X_5096_ _3974_/B _5096_/B VGND VGND VPWR VPWR _5096_/Y sky130_fd_sc_hd__nand2b_1
Xhold1847 _5847_/Q VGND VGND VPWR VPWR _3865_/A1 sky130_fd_sc_hd__dlygate4sd3_1
Xhold1858 _4617_/X VGND VGND VPWR VPWR _6163_/D sky130_fd_sc_hd__dlygate4sd3_1
XFILLER_56_336 VGND VGND VPWR VPWR sky130_fd_sc_hd__fill_1
Xi2c_master_axil_225 VGND VGND VPWR VPWR i2c_master_axil_225/HI s_axil_rdata[31] sky130_fd_sc_hd__conb_1
XFILLER_71_306 VGND VGND VPWR VPWR sky130_fd_sc_hd__fill_1
Xi2c_master_axil_214 VGND VGND VPWR VPWR i2c_master_axil_214/HI s_axil_rdata[20] sky130_fd_sc_hd__conb_1
XFILLER_17_15 VPWR VGND VPWR VGND sky130_ef_sc_hd__decap_40_12
XFILLER_17_37 VGND VGND VPWR VPWR sky130_fd_sc_hd__fill_4
XTAP_TAPCELL_ROW_27_707 VGND VPWR sky130_fd_sc_hd__tapvpwrvgnd_1
X_4047_ _4032_/X _4046_/X _4047_/B1 _4218_/A VGND VGND VPWR VPWR _4047_/X sky130_fd_sc_hd__a2bb2o_1
XFILLER_83_188 VGND VGND VPWR VPWR sky130_fd_sc_hd__fill_1
XANTENNA__4491__S _4492_/S VGND VGND VPWR VPWR sky130_fd_sc_hd__diode_2
XFILLER_25_756 VPWR VGND VPWR VGND sky130_ef_sc_hd__decap_40_12
XFILLER_12_417 VGND VGND VPWR VPWR sky130_fd_sc_hd__fill_2
X_5998_ _6347_/CLK _5998_/D VGND VGND VPWR VPWR _5998_/Q sky130_fd_sc_hd__dfxtp_1
X_4949_ _5042_/A1 _4949_/A1 _4954_/S VGND VGND VPWR VPWR _4949_/X sky130_fd_sc_hd__mux2_1
XFILLER_24_288 VGND VGND VPWR VPWR sky130_fd_sc_hd__fill_4
XFILLER_138_669 VGND VGND VPWR VPWR sky130_fd_sc_hd__fill_2
XFILLER_126_809 VGND VGND VPWR VPWR sky130_fd_sc_hd__fill_2
XANTENNA__5166__C1 _5176_/A VGND VGND VPWR VPWR sky130_fd_sc_hd__diode_2
XFILLER_137_157 VGND VGND VPWR VPWR sky130_fd_sc_hd__fill_8
XTAP_TAPCELL_ROW_95_1731 VGND VPWR sky130_fd_sc_hd__tapvpwrvgnd_1
XTAP_TAPCELL_ROW_95_1720 VGND VPWR sky130_fd_sc_hd__tapvpwrvgnd_1
XFILLER_106_533 VPWR VGND VPWR VGND sky130_ef_sc_hd__decap_40_12
XANTENNA__4913__C1 _5176_/A VGND VGND VPWR VPWR sky130_fd_sc_hd__diode_2
XANTENNA__3192__A1 _5080_/A0 VGND VGND VPWR VPWR sky130_fd_sc_hd__diode_2
XFILLER_121_525 VPWR VGND VPWR VGND sky130_ef_sc_hd__decap_40_12
XFILLER_121_503 VGND VGND VPWR VPWR sky130_fd_sc_hd__fill_1
XTAP_TAPCELL_ROW_7_410 VGND VPWR sky130_fd_sc_hd__tapvpwrvgnd_1
XFILLER_0_811 VGND VGND VPWR VPWR sky130_fd_sc_hd__fill_1
XANTENNA__4666__S _4803_/S VGND VGND VPWR VPWR sky130_fd_sc_hd__diode_2
XANTENNA__2975__A _3050_/A VGND VGND VPWR VPWR sky130_fd_sc_hd__diode_2
XANTENNA__3570__S _3574_/S VGND VGND VPWR VPWR sky130_fd_sc_hd__diode_2
XFILLER_48_837 VGND VGND VPWR VPWR sky130_fd_sc_hd__fill_4
XANTENNA_fanout64_X _3036_/A1 VGND VGND VPWR VPWR sky130_fd_sc_hd__diode_2
XFILLER_75_634 VPWR VGND VPWR VGND sky130_ef_sc_hd__decap_40_12
XANTENNA__3142__Y _4993_/S VGND VGND VPWR VPWR sky130_fd_sc_hd__diode_2
XANTENNA__4444__A1 _4443_/X VGND VGND VPWR VPWR sky130_fd_sc_hd__diode_2
XFILLER_16_701 VPWR VGND VPWR VGND sky130_ef_sc_hd__decap_40_12
XTAP_TAPCELL_ROW_122_2127 VGND VPWR sky130_fd_sc_hd__tapvpwrvgnd_1
XFILLER_90_637 VGND VGND VPWR VPWR sky130_fd_sc_hd__fill_4
XANTENNA__2914__S _3072_/S VGND VGND VPWR VPWR sky130_fd_sc_hd__diode_2
XTAP_TAPCELL_ROW_104_1860 VGND VPWR sky130_fd_sc_hd__tapvpwrvgnd_1
XFILLER_90_20 VGND VGND VPWR VPWR sky130_fd_sc_hd__fill_8
XFILLER_43_586 VGND VGND VPWR VPWR sky130_fd_sc_hd__fill_4
XFILLER_129_669 VGND VGND VPWR VPWR sky130_fd_sc_hd__fill_2
XFILLER_117_809 VPWR VGND VPWR VGND sky130_ef_sc_hd__decap_40_12
XFILLER_11_461 VPWR VGND VPWR VGND sky130_ef_sc_hd__decap_40_12
XTAP_TAPCELL_ROW_13_489 VGND VPWR sky130_fd_sc_hd__tapvpwrvgnd_1
XANTENNA__3745__S _3745_/S VGND VGND VPWR VPWR sky130_fd_sc_hd__diode_2
XANTENNA__3707__A0 _4964_/A0 VGND VGND VPWR VPWR sky130_fd_sc_hd__diode_2
XFILLER_99_73 VGND VGND VPWR VPWR sky130_fd_sc_hd__fill_1
XTAP_TAPCELL_ROW_133_2289 VGND VPWR sky130_fd_sc_hd__tapvpwrvgnd_1
XFILLER_99_84 VGND VGND VPWR VPWR sky130_fd_sc_hd__fill_1
XANTENNA__3183__A1 _4883_/A1 VGND VGND VPWR VPWR sky130_fd_sc_hd__diode_2
XFILLER_124_363 VGND VGND VPWR VPWR sky130_fd_sc_hd__fill_1
XFILLER_98_737 VPWR VGND VPWR VGND sky130_ef_sc_hd__decap_40_12
X_3280_ _3278_/A _3280_/A2 _3279_/Y VGND VGND VPWR VPWR _5401_/D sky130_fd_sc_hd__o21a_1
XFILLER_3_671 VGND VGND VPWR VPWR sky130_fd_sc_hd__fill_1
XFILLER_112_569 VPWR VGND VPWR VGND sky130_ef_sc_hd__decap_40_12
XANTENNA__3480__S _3490_/S VGND VGND VPWR VPWR sky130_fd_sc_hd__diode_2
XANTENNA__4683__B2 _4792_/A1 VGND VGND VPWR VPWR sky130_fd_sc_hd__diode_2
XFILLER_78_494 VPWR VGND VPWR VGND sky130_ef_sc_hd__decap_40_12
XFILLER_17_3 VPWR VGND VPWR VGND sky130_ef_sc_hd__decap_40_12
XFILLER_39_837 VGND VGND VPWR VPWR sky130_fd_sc_hd__fill_2
XFILLER_81_615 VGND VGND VPWR VPWR sky130_fd_sc_hd__fill_1
XFILLER_53_317 VGND VGND VPWR VPWR sky130_fd_sc_hd__fill_4
XTAP_TAPCELL_ROW_49_1029 VGND VPWR sky130_fd_sc_hd__tapvpwrvgnd_1
XFILLER_19_561 VPWR VGND VPWR VGND sky130_ef_sc_hd__decap_40_12
X_5921_ _6312_/CLK _5921_/D VGND VGND VPWR VPWR _5921_/Q sky130_fd_sc_hd__dfxtp_1
XFILLER_46_380 VGND VGND VPWR VPWR sky130_fd_sc_hd__fill_2
XFILLER_34_553 VGND VGND VPWR VPWR sky130_fd_sc_hd__fill_2
X_5852_ _6057_/CLK _5852_/D VGND VGND VPWR VPWR _5852_/Q sky130_fd_sc_hd__dfxtp_1
XFILLER_61_361 VGND VGND VPWR VPWR sky130_fd_sc_hd__fill_2
XFILLER_34_564 VGND VGND VPWR VPWR sky130_fd_sc_hd__fill_4
XTAP_TAPCELL_ROW_62_1229 VGND VPWR sky130_fd_sc_hd__tapvpwrvgnd_1
XANTENNA__4199__B1 _3172_/B VGND VGND VPWR VPWR sky130_fd_sc_hd__diode_2
XFILLER_22_737 VPWR VGND VPWR VGND sky130_ef_sc_hd__decap_40_12
X_5783_ clkload8/A _5783_/D VGND VGND VPWR VPWR _5783_/Q sky130_fd_sc_hd__dfxtp_1
X_4803_ _6089_/Q _5887_/Q _4803_/S VGND VGND VPWR VPWR _4803_/X sky130_fd_sc_hd__mux2_1
X_2995_ _2995_/A _2995_/B VGND VGND VPWR VPWR _2995_/Y sky130_fd_sc_hd__nor2_1
X_4734_ _4791_/A1 _4733_/X _4791_/B1 VGND VGND VPWR VPWR _4734_/X sky130_fd_sc_hd__o21a_1
XANTENNA__2749__A1 _5233_/A0 VGND VGND VPWR VPWR sky130_fd_sc_hd__diode_2
XTAP_TAPCELL_ROW_32_776 VGND VPWR sky130_fd_sc_hd__tapvpwrvgnd_1
XFILLER_108_809 VGND VGND VPWR VPWR sky130_fd_sc_hd__fill_2
XFILLER_30_781 VPWR VGND VPWR VGND sky130_ef_sc_hd__decap_40_12
XTAP_TAPCELL_ROW_32_787 VGND VPWR sky130_fd_sc_hd__tapvpwrvgnd_1
XFILLER_135_617 VPWR VGND VPWR VGND sky130_ef_sc_hd__decap_40_12
XFILLER_119_39 VGND VGND VPWR VPWR sky130_fd_sc_hd__fill_1
X_4665_ _4802_/A _4665_/B VGND VGND VPWR VPWR _4665_/X sky130_fd_sc_hd__or2_1
Xhold911 _3209_/X VGND VGND VPWR VPWR _5369_/D sky130_fd_sc_hd__dlygate4sd3_1
Xhold922 _6429_/Q VGND VGND VPWR VPWR hold922/X sky130_fd_sc_hd__dlygate4sd3_1
X_3616_ hold710/X _4964_/A0 _3616_/S VGND VGND VPWR VPWR _3616_/X sky130_fd_sc_hd__mux2_1
Xhold900 _5331_/Q VGND VGND VPWR VPWR _3317_/A sky130_fd_sc_hd__dlygate4sd3_1
XTAP_TAPCELL_ROW_77_1450 VGND VPWR sky130_fd_sc_hd__tapvpwrvgnd_1
X_6404_ _6404_/CLK _6404_/D VGND VGND VPWR VPWR _6404_/Q sky130_fd_sc_hd__dfxtp_1
X_4596_ _5712_/Q _5703_/Q _5694_/Q _5898_/Q _4810_/S _4600_/A VGND VGND VPWR VPWR
+ _4596_/X sky130_fd_sc_hd__mux4_1
XANTENNA_fanout111_A _5823_/Q VGND VGND VPWR VPWR sky130_fd_sc_hd__diode_2
Xhold955 _3120_/X VGND VGND VPWR VPWR _5313_/D sky130_fd_sc_hd__dlygate4sd3_1
Xhold944 _5588_/Q VGND VGND VPWR VPWR hold944/X sky130_fd_sc_hd__dlygate4sd3_1
X_3547_ hold944/X _4517_/A1 _3552_/S VGND VGND VPWR VPWR _3547_/X sky130_fd_sc_hd__mux2_1
XTAP_TAPCELL_ROW_77_1461 VGND VPWR sky130_fd_sc_hd__tapvpwrvgnd_1
X_6335_ _6342_/CLK _6335_/D VGND VGND VPWR VPWR _6335_/Q sky130_fd_sc_hd__dfxtp_1
XANTENNA__4371__A0 _4929_/A1 VGND VGND VPWR VPWR sky130_fd_sc_hd__diode_2
Xhold933 _4494_/X VGND VGND VPWR VPWR _6099_/D sky130_fd_sc_hd__dlygate4sd3_1
XFILLER_135_27 VPWR VGND VPWR VGND sky130_ef_sc_hd__decap_40_12
XFILLER_103_525 VPWR VGND VPWR VGND sky130_ef_sc_hd__decap_40_12
Xhold988 _4729_/X VGND VGND VPWR VPWR _6167_/D sky130_fd_sc_hd__dlygate4sd3_1
Xhold966 _6318_/Q VGND VGND VPWR VPWR hold966/X sky130_fd_sc_hd__dlygate4sd3_1
Xhold977 _5790_/Q VGND VGND VPWR VPWR hold977/X sky130_fd_sc_hd__dlygate4sd3_1
X_3478_ _4868_/A _3517_/B VGND VGND VPWR VPWR _3490_/S sky130_fd_sc_hd__nor2_8
XTAP_TAPCELL_ROW_90_1650 VGND VPWR sky130_fd_sc_hd__tapvpwrvgnd_1
Xhold999 _5591_/Q VGND VGND VPWR VPWR hold999/X sky130_fd_sc_hd__dlygate4sd3_1
XANTENNA__4994__B _4994_/B VGND VGND VPWR VPWR sky130_fd_sc_hd__diode_2
X_6266_ _6302_/CLK _6266_/D VGND VGND VPWR VPWR _6266_/Q sky130_fd_sc_hd__dfxtp_1
Xhold1600 _5361_/Q VGND VGND VPWR VPWR _3199_/A0 sky130_fd_sc_hd__dlygate4sd3_1
X_6197_ _6233_/CLK _6197_/D VGND VGND VPWR VPWR _6197_/Q sky130_fd_sc_hd__dfxtp_1
XFILLER_97_781 VGND VGND VPWR VPWR sky130_fd_sc_hd__fill_2
XANTENNA_fanout199_X _3033_/S VGND VGND VPWR VPWR sky130_fd_sc_hd__diode_2
X_5217_ _5215_/S _5217_/A2 _3801_/A VGND VGND VPWR VPWR _5217_/Y sky130_fd_sc_hd__a21oi_1
XANTENNA__3390__S _3390_/S VGND VGND VPWR VPWR sky130_fd_sc_hd__diode_2
Xhold1644 _6181_/Q VGND VGND VPWR VPWR _4827_/A1 sky130_fd_sc_hd__dlygate4sd3_1
Xhold1611 _3433_/X VGND VGND VPWR VPWR _5484_/D sky130_fd_sc_hd__dlygate4sd3_1
Xhold1633 _6166_/Q VGND VGND VPWR VPWR _5090_/A1 sky130_fd_sc_hd__dlygate4sd3_1
X_5148_ _5838_/Q _5837_/Q _5194_/S VGND VGND VPWR VPWR _5148_/X sky130_fd_sc_hd__mux2_1
Xhold1622 _3394_/X VGND VGND VPWR VPWR _5451_/D sky130_fd_sc_hd__dlygate4sd3_1
X_5079_ _5235_/A0 _5079_/A1 _5081_/S VGND VGND VPWR VPWR _5079_/X sky130_fd_sc_hd__mux2_1
Xhold1655 _3514_/X VGND VGND VPWR VPWR _5558_/D sky130_fd_sc_hd__dlygate4sd3_1
XFILLER_84_453 VGND VGND VPWR VPWR sky130_fd_sc_hd__fill_4
Xhold1666 _6095_/Q VGND VGND VPWR VPWR _4489_/A1 sky130_fd_sc_hd__dlygate4sd3_1
XFILLER_72_604 VGND VGND VPWR VPWR sky130_fd_sc_hd__fill_2
Xhold1677 _3688_/X VGND VGND VPWR VPWR _5710_/D sky130_fd_sc_hd__dlygate4sd3_1
Xhold1688 _3861_/X VGND VGND VPWR VPWR _5843_/D sky130_fd_sc_hd__dlygate4sd3_1
Xhold1699 _5632_/Q VGND VGND VPWR VPWR _4618_/A2 sky130_fd_sc_hd__dlygate4sd3_1
XFILLER_56_177 VGND VGND VPWR VPWR sky130_fd_sc_hd__fill_1
XFILLER_44_306 VGND VGND VPWR VPWR sky130_fd_sc_hd__fill_2
XANTENNA__2988__A1 _3076_/A1 VGND VGND VPWR VPWR sky130_fd_sc_hd__diode_2
XFILLER_100_52 VGND VGND VPWR VPWR sky130_fd_sc_hd__fill_1
XANTENNA__3937__A0 _4983_/A1 VGND VGND VPWR VPWR sky130_fd_sc_hd__diode_2
XFILLER_100_85 VGND VGND VPWR VPWR sky130_fd_sc_hd__fill_1
XFILLER_21_781 VGND VGND VPWR VPWR sky130_fd_sc_hd__fill_2
XFILLER_40_589 VGND VGND VPWR VPWR sky130_fd_sc_hd__fill_1
XFILLER_138_477 VPWR VGND VPWR VGND sky130_ef_sc_hd__decap_40_12
XFILLER_121_3 VPWR VGND VPWR VGND sky130_ef_sc_hd__decap_40_12
XTAP_TAPCELL_ROW_10_448 VGND VPWR sky130_fd_sc_hd__tapvpwrvgnd_1
XFILLER_20_291 VGND VGND VPWR VPWR sky130_fd_sc_hd__fill_1
XFILLER_4_413 VGND VGND VPWR VPWR sky130_fd_sc_hd__fill_4
XFILLER_109_72 VGND VGND VPWR VPWR sky130_fd_sc_hd__fill_1
XANTENNA__3165__A1 _4213_/S VGND VGND VPWR VPWR sky130_fd_sc_hd__diode_2
XFILLER_95_729 VPWR VGND VPWR VGND sky130_ef_sc_hd__decap_40_12
XFILLER_0_641 VGND VGND VPWR VPWR sky130_fd_sc_hd__fill_2
XFILLER_88_781 VPWR VGND VPWR VGND sky130_ef_sc_hd__decap_40_12
XFILLER_85_31 VGND VGND VPWR VPWR sky130_fd_sc_hd__fill_4
XFILLER_0_685 VPWR VGND VPWR VGND sky130_ef_sc_hd__decap_40_12
XFILLER_47_155 VGND VGND VPWR VPWR sky130_fd_sc_hd__fill_1
XFILLER_75_486 VGND VGND VPWR VPWR sky130_fd_sc_hd__fill_2
XFILLER_63_615 VGND VGND VPWR VPWR sky130_fd_sc_hd__fill_1
XFILLER_62_147 VGND VGND VPWR VPWR sky130_fd_sc_hd__fill_1
XFILLER_16_531 VGND VGND VPWR VPWR sky130_fd_sc_hd__fill_1
XANTENNA__2979__B2 _3089_/C1 VGND VGND VPWR VPWR sky130_fd_sc_hd__diode_2
XFILLER_90_467 VGND VGND VPWR VPWR sky130_fd_sc_hd__fill_1
XANTENNA__6413__Q _6413_/Q VGND VGND VPWR VPWR sky130_fd_sc_hd__diode_2
XTAP_TAPCELL_ROW_135_2329 VGND VPWR sky130_fd_sc_hd__tapvpwrvgnd_1
XTAP_TAPCELL_ROW_135_2318 VGND VPWR sky130_fd_sc_hd__tapvpwrvgnd_1
X_2780_ _2967_/S _2779_/X _2773_/Y _2735_/A VGND VGND VPWR VPWR _2780_/Y sky130_fd_sc_hd__o211ai_1
XFILLER_12_781 VPWR VGND VPWR VGND sky130_ef_sc_hd__decap_40_12
XANTENNA__3475__S _3477_/S VGND VGND VPWR VPWR sky130_fd_sc_hd__diode_2
XFILLER_117_617 VPWR VGND VPWR VGND sky130_ef_sc_hd__decap_40_12
X_4450_ hold313/X _4449_/X _4457_/S VGND VGND VPWR VPWR _4450_/X sky130_fd_sc_hd__mux2_1
Xhold207 _4557_/X VGND VGND VPWR VPWR _6157_/D sky130_fd_sc_hd__dlygate4sd3_1
Xhold229 _3108_/X VGND VGND VPWR VPWR _5303_/D sky130_fd_sc_hd__dlygate4sd3_1
X_3401_ _3401_/A0 _4984_/A1 _3401_/S VGND VGND VPWR VPWR _3401_/X sky130_fd_sc_hd__mux2_1
X_4381_ hold623/X _4929_/A1 _4386_/S VGND VGND VPWR VPWR _4381_/X sky130_fd_sc_hd__mux2_1
Xhold218 _6120_/Q VGND VGND VPWR VPWR hold218/X sky130_fd_sc_hd__dlygate4sd3_1
XFILLER_131_119 VGND VGND VPWR VPWR sky130_fd_sc_hd__fill_1
XANTENNA__2903__A1 _3094_/C1 VGND VGND VPWR VPWR sky130_fd_sc_hd__diode_2
X_3332_ _3315_/X _3328_/Y _3331_/X _5099_/C VGND VGND VPWR VPWR _3338_/A sky130_fd_sc_hd__o31ai_2
XTAP_TAPCELL_ROW_59_1191 VGND VPWR sky130_fd_sc_hd__tapvpwrvgnd_1
XTAP_TAPCELL_ROW_59_1180 VGND VPWR sky130_fd_sc_hd__tapvpwrvgnd_1
X_6120_ _6120_/CLK _6120_/D VGND VGND VPWR VPWR _6120_/Q sky130_fd_sc_hd__dfxtp_1
XFILLER_98_545 VPWR VGND VPWR VGND sky130_ef_sc_hd__decap_40_12
XFILLER_98_589 VPWR VGND VPWR VGND sky130_ef_sc_hd__decap_40_12
XTAP_TAPCELL_ROW_72_1380 VGND VPWR sky130_fd_sc_hd__tapvpwrvgnd_1
X_6051_ _6405_/CLK _6051_/D VGND VGND VPWR VPWR _6051_/Q sky130_fd_sc_hd__dfxtp_1
X_3263_ _3263_/A _3263_/B _3263_/C _3229_/D VGND VGND VPWR VPWR _3267_/B sky130_fd_sc_hd__or4b_2
XANTENNA__4200__S0 _4257_/S VGND VGND VPWR VPWR sky130_fd_sc_hd__diode_2
X_3194_ _3208_/A _5225_/B VGND VGND VPWR VPWR _3206_/S sky130_fd_sc_hd__nor2_4
XFILLER_79_781 VGND VGND VPWR VPWR sky130_fd_sc_hd__fill_2
X_5002_ _5000_/B _4997_/X _4998_/Y _5001_/Y VGND VGND VPWR VPWR _5002_/X sky130_fd_sc_hd__a22o_1
XFILLER_93_294 VGND VGND VPWR VPWR sky130_fd_sc_hd__fill_4
XTAP_TAPCELL_ROW_37_857 VGND VPWR sky130_fd_sc_hd__tapvpwrvgnd_1
Xclkbuf_3_5__f_clk clkbuf_0_clk/X VGND VGND VPWR VPWR clkload4/A sky130_fd_sc_hd__clkbuf_16
XFILLER_22_501 VPWR VGND VPWR VGND sky130_ef_sc_hd__decap_40_12
X_5904_ _6122_/CLK _5904_/D VGND VGND VPWR VPWR _5904_/Q sky130_fd_sc_hd__dfxtp_1
XFILLER_34_361 VGND VGND VPWR VPWR sky130_fd_sc_hd__fill_2
X_5835_ _6338_/CLK _5835_/D VGND VGND VPWR VPWR _5835_/Q sky130_fd_sc_hd__dfxtp_1
XFILLER_22_523 VGND VGND VPWR VPWR sky130_fd_sc_hd__fill_1
X_2978_ _5245_/Q _6250_/Q _5410_/Q hold99/A _3072_/S _3044_/A VGND VGND VPWR VPWR
+ _2978_/X sky130_fd_sc_hd__mux4_1
X_5766_ _6307_/CLK _5766_/D VGND VGND VPWR VPWR _5766_/Q sky130_fd_sc_hd__dfxtp_1
XFILLER_108_617 VGND VGND VPWR VPWR sky130_fd_sc_hd__fill_2
XANTENNA__4019__S0 _4213_/S VGND VGND VPWR VPWR sky130_fd_sc_hd__diode_2
XANTENNA__3395__A1 _4978_/A1 VGND VGND VPWR VPWR sky130_fd_sc_hd__diode_2
XANTENNA__3385__S _3390_/S VGND VGND VPWR VPWR sky130_fd_sc_hd__diode_2
X_4717_ _5801_/Q _5792_/Q _4803_/S VGND VGND VPWR VPWR _4718_/B sky130_fd_sc_hd__mux2_1
X_5697_ _6122_/CLK _5697_/D VGND VGND VPWR VPWR _5697_/Q sky130_fd_sc_hd__dfxtp_1
XFILLER_108_628 VPWR VGND VPWR VGND sky130_ef_sc_hd__decap_40_12
X_4648_ hold105/X hold592/X _4648_/A2 _4648_/A3 _4773_/S _4789_/A VGND VGND VPWR VPWR
+ _4648_/X sky130_fd_sc_hd__mux4_1
XANTENNA_fanout114_X _4883_/A1 VGND VGND VPWR VPWR sky130_fd_sc_hd__diode_2
XANTENNA__4070__A _4212_/A VGND VGND VPWR VPWR sky130_fd_sc_hd__diode_2
XFILLER_30_15 VGND VGND VPWR VPWR sky130_fd_sc_hd__fill_2
XFILLER_123_609 VGND VGND VPWR VPWR sky130_fd_sc_hd__fill_4
Xhold730 _6130_/Q VGND VGND VPWR VPWR hold730/X sky130_fd_sc_hd__dlygate4sd3_1
Xhold752 _4466_/X VGND VGND VPWR VPWR _6074_/D sky130_fd_sc_hd__dlygate4sd3_1
Xhold763 _5604_/Q VGND VGND VPWR VPWR hold763/X sky130_fd_sc_hd__dlygate4sd3_1
Xhold741 _5957_/Q VGND VGND VPWR VPWR hold741/X sky130_fd_sc_hd__dlygate4sd3_1
X_4579_ _4802_/A _4579_/B VGND VGND VPWR VPWR _4579_/X sky130_fd_sc_hd__or2_1
XFILLER_103_311 VGND VGND VPWR VPWR sky130_fd_sc_hd__fill_1
Xhold796 _4531_/X VGND VGND VPWR VPWR _6133_/D sky130_fd_sc_hd__dlygate4sd3_1
X_6318_ _6342_/CLK _6318_/D VGND VGND VPWR VPWR _6318_/Q sky130_fd_sc_hd__dfxtp_1
XFILLER_1_449 VPWR VGND VPWR VGND sky130_ef_sc_hd__decap_40_12
Xhold785 _6312_/Q VGND VGND VPWR VPWR hold785/X sky130_fd_sc_hd__dlygate4sd3_1
Xhold774 _4496_/X VGND VGND VPWR VPWR _6101_/D sky130_fd_sc_hd__dlygate4sd3_1
XFILLER_131_653 VPWR VGND VPWR VGND sky130_ef_sc_hd__decap_40_12
X_6249_ _6254_/CLK _6249_/D VGND VGND VPWR VPWR _6249_/Q sky130_fd_sc_hd__dfxtp_1
Xhold2120 _5084_/X VGND VGND VPWR VPWR _5085_/B sky130_fd_sc_hd__dlygate4sd3_1
XFILLER_131_697 VPWR VGND VPWR VGND sky130_ef_sc_hd__decap_40_12
Xhold2142 _6258_/Q VGND VGND VPWR VPWR _4915_/A1 sky130_fd_sc_hd__dlygate4sd3_1
Xhold2164 _6386_/Q VGND VGND VPWR VPWR _3964_/B sky130_fd_sc_hd__dlygate4sd3_1
Xhold2131 _5002_/X VGND VGND VPWR VPWR _6328_/D sky130_fd_sc_hd__dlygate4sd3_1
XFILLER_29_111 VGND VGND VPWR VPWR sky130_fd_sc_hd__fill_1
Xhold2153 _3137_/X VGND VGND VPWR VPWR _5323_/D sky130_fd_sc_hd__dlygate4sd3_1
Xhold1452 _3473_/X VGND VGND VPWR VPWR _5520_/D sky130_fd_sc_hd__dlygate4sd3_1
Xhold2186 _5839_/Q VGND VGND VPWR VPWR _3850_/A sky130_fd_sc_hd__dlygate4sd3_1
Xhold2175 _5836_/Q VGND VGND VPWR VPWR _3844_/A sky130_fd_sc_hd__dlygate4sd3_1
Xhold2197 _5838_/Q VGND VGND VPWR VPWR _3848_/A sky130_fd_sc_hd__dlygate4sd3_1
Xhold1430 _4973_/X VGND VGND VPWR VPWR _6306_/D sky130_fd_sc_hd__dlygate4sd3_1
XANTENNA__4944__S _4944_/S VGND VGND VPWR VPWR sky130_fd_sc_hd__diode_2
Xhold1441 _5392_/Q VGND VGND VPWR VPWR _3354_/A1 sky130_fd_sc_hd__dlygate4sd3_1
Xhold1463 _5497_/Q VGND VGND VPWR VPWR _3447_/A0 sky130_fd_sc_hd__dlygate4sd3_1
Xhold1474 _5091_/X VGND VGND VPWR VPWR _6379_/D sky130_fd_sc_hd__dlygate4sd3_1
Xhold1485 _5462_/Q VGND VGND VPWR VPWR _4104_/A1 sky130_fd_sc_hd__dlygate4sd3_1
Xhold1496 _5411_/Q VGND VGND VPWR VPWR _3292_/A0 sky130_fd_sc_hd__dlygate4sd3_1
XFILLER_72_456 VGND VGND VPWR VPWR sky130_fd_sc_hd__fill_2
XFILLER_13_501 VGND VGND VPWR VPWR sky130_fd_sc_hd__fill_2
XTAP_TAPCELL_ROW_15_518 VGND VPWR sky130_fd_sc_hd__tapvpwrvgnd_1
XTAP_TAPCELL_ROW_15_529 VGND VPWR sky130_fd_sc_hd__tapvpwrvgnd_1
XFILLER_41_821 VPWR VGND VPWR VGND sky130_ef_sc_hd__decap_40_12
XFILLER_9_505 VPWR VGND VPWR VGND sky130_ef_sc_hd__decap_40_12
XANTENNA__4032__C1 _5343_/Q VGND VGND VPWR VPWR sky130_fd_sc_hd__diode_2
XANTENNA__6460__A _6460_/A VGND VGND VPWR VPWR sky130_fd_sc_hd__diode_2
XTAP_TAPCELL_ROW_117_2048 VGND VPWR sky130_fd_sc_hd__tapvpwrvgnd_1
XANTENNA__3295__S _3295_/S VGND VGND VPWR VPWR sky130_fd_sc_hd__diode_2
XANTENNA__3386__A1 _5043_/A1 VGND VGND VPWR VPWR sky130_fd_sc_hd__diode_2
XTAP_TAPCELL_ROW_117_2059 VGND VPWR sky130_fd_sc_hd__tapvpwrvgnd_1
XANTENNA__4335__A0 _5047_/A1 VGND VGND VPWR VPWR sky130_fd_sc_hd__diode_2
XTAP_TAPCELL_ROW_130_2248 VGND VPWR sky130_fd_sc_hd__tapvpwrvgnd_1
XANTENNA__4886__A1 _4886_/A1 VGND VGND VPWR VPWR sky130_fd_sc_hd__diode_2
XFILLER_5_777 VGND VGND VPWR VPWR sky130_fd_sc_hd__fill_4
XFILLER_106_193 VGND VGND VPWR VPWR sky130_fd_sc_hd__fill_1
XTAP_TAPCELL_ROW_112_1981 VGND VPWR sky130_fd_sc_hd__tapvpwrvgnd_1
XFILLER_122_697 VGND VGND VPWR VPWR sky130_fd_sc_hd__fill_2
XFILLER_110_837 VGND VGND VPWR VPWR sky130_fd_sc_hd__fill_4
XFILLER_96_85 VGND VGND VPWR VPWR sky130_fd_sc_hd__fill_1
XFILLER_95_559 VGND VGND VPWR VPWR sky130_fd_sc_hd__fill_1
Xhold90 hold90/A VGND VGND VPWR VPWR hold90/X sky130_fd_sc_hd__dlygate4sd3_1
XANTENNA__4854__S _4854_/S VGND VGND VPWR VPWR sky130_fd_sc_hd__diode_2
XFILLER_91_721 VGND VGND VPWR VPWR sky130_fd_sc_hd__fill_4
XFILLER_75_261 VPWR VGND VPWR VGND sky130_ef_sc_hd__decap_40_12
XFILLER_75_250 VGND VGND VPWR VPWR sky130_fd_sc_hd__fill_2
XFILLER_48_475 VGND VGND VPWR VPWR sky130_fd_sc_hd__fill_1
XFILLER_91_765 VPWR VGND VPWR VGND sky130_ef_sc_hd__decap_40_12
XFILLER_75_294 VGND VGND VPWR VPWR sky130_fd_sc_hd__fill_2
XFILLER_35_136 VGND VGND VPWR VPWR sky130_fd_sc_hd__fill_4
XFILLER_90_253 VGND VGND VPWR VPWR sky130_fd_sc_hd__fill_2
X_3950_ _3952_/C _3952_/D VGND VGND VPWR VPWR _3951_/A sky130_fd_sc_hd__or2_1
XFILLER_63_478 VGND VGND VPWR VPWR sky130_fd_sc_hd__fill_1
XTAP_TAPCELL_ROW_34_805 VGND VPWR sky130_fd_sc_hd__tapvpwrvgnd_1
XTAP_TAPCELL_ROW_34_816 VGND VPWR sky130_fd_sc_hd__tapvpwrvgnd_1
X_2901_ _6188_/Q _5482_/Q _3062_/S VGND VGND VPWR VPWR _2901_/X sky130_fd_sc_hd__mux2_1
XFILLER_16_361 VGND VGND VPWR VPWR sky130_fd_sc_hd__fill_2
XANTENNA__2821__B1 _3094_/C1 VGND VGND VPWR VPWR sky130_fd_sc_hd__diode_2
X_3881_ hold119/X _4484_/A0 _3889_/S VGND VGND VPWR VPWR _3881_/X sky130_fd_sc_hd__mux2_1
XFILLER_31_353 VGND VGND VPWR VPWR sky130_fd_sc_hd__fill_4
X_2832_ _6233_/Q _6209_/Q _3062_/S VGND VGND VPWR VPWR _2833_/B sky130_fd_sc_hd__mux2_1
X_5620_ _6298_/CLK _5620_/D VGND VGND VPWR VPWR _5620_/Q sky130_fd_sc_hd__dfxtp_1
XANTENNA__4023__C1 _4271_/S1 VGND VGND VPWR VPWR sky130_fd_sc_hd__diode_2
X_2763_ _3036_/A1 _2762_/X _3027_/A VGND VGND VPWR VPWR _2763_/X sky130_fd_sc_hd__o21a_1
X_5551_ _6369_/CLK _5551_/D VGND VGND VPWR VPWR _5551_/Q sky130_fd_sc_hd__dfxtp_1
XANTENNA__3377__B2 _4905_/A0 VGND VGND VPWR VPWR sky130_fd_sc_hd__diode_2
X_4502_ hold562/X _5202_/A1 _4502_/S VGND VGND VPWR VPWR _4502_/X sky130_fd_sc_hd__mux2_1
XFILLER_105_609 VGND VGND VPWR VPWR sky130_fd_sc_hd__fill_4
X_2694_ _2663_/B _3541_/S _2693_/Y VGND VGND VPWR VPWR _2694_/X sky130_fd_sc_hd__o21a_1
X_5482_ _6237_/CLK _5482_/D VGND VGND VPWR VPWR _5482_/Q sky130_fd_sc_hd__dfxtp_1
XFILLER_99_821 VPWR VGND VPWR VGND sky130_ef_sc_hd__decap_40_12
XANTENNA__4877__A1 _4903_/A0 VGND VGND VPWR VPWR sky130_fd_sc_hd__diode_2
X_4433_ _4433_/A1 _4457_/S _4430_/X _4432_/X VGND VGND VPWR VPWR _4433_/X sky130_fd_sc_hd__o22a_1
XFILLER_132_439 VGND VGND VPWR VPWR sky130_fd_sc_hd__fill_4
XFILLER_116_29 VPWR VGND VPWR VGND sky130_ef_sc_hd__decap_40_12
XANTENNA__2888__B1 _2995_/A VGND VGND VPWR VPWR sky130_fd_sc_hd__diode_2
X_4364_ hold584/X _5045_/A1 _4366_/S VGND VGND VPWR VPWR _4364_/X sky130_fd_sc_hd__mux2_1
XFILLER_113_653 VPWR VGND VPWR VGND sky130_ef_sc_hd__decap_40_12
XANTENNA__2983__S0 _2984_/S VGND VGND VPWR VPWR sky130_fd_sc_hd__diode_2
X_3315_ _6388_/Q _3315_/B VGND VGND VPWR VPWR _3315_/X sky130_fd_sc_hd__or2_2
X_6103_ _6121_/CLK hold50/X VGND VGND VPWR VPWR hold49/A sky130_fd_sc_hd__dfxtp_1
X_4295_ _4965_/A _5038_/A VGND VGND VPWR VPWR _4304_/S sky130_fd_sc_hd__nor2_4
XFILLER_113_697 VPWR VGND VPWR VGND sky130_ef_sc_hd__decap_40_12
XFILLER_101_837 VGND VGND VPWR VPWR sky130_fd_sc_hd__fill_2
XFILLER_100_303 VGND VGND VPWR VPWR sky130_fd_sc_hd__fill_1
XFILLER_58_239 VGND VGND VPWR VPWR sky130_fd_sc_hd__fill_1
XFILLER_58_217 VGND VGND VPWR VPWR sky130_fd_sc_hd__fill_1
X_3246_ _3244_/B _3241_/Y _3245_/Y _3237_/A VGND VGND VPWR VPWR _3246_/X sky130_fd_sc_hd__a22o_1
X_6034_ _6315_/CLK _6034_/D VGND VGND VPWR VPWR _6034_/Q sky130_fd_sc_hd__dfxtp_1
XANTENNA__3301__A1 _4886_/A1 VGND VGND VPWR VPWR sky130_fd_sc_hd__diode_2
XFILLER_94_581 VGND VGND VPWR VPWR sky130_fd_sc_hd__fill_4
XFILLER_27_615 VGND VGND VPWR VPWR sky130_fd_sc_hd__fill_1
X_3177_ _3177_/A _3177_/B VGND VGND VPWR VPWR _5343_/D sky130_fd_sc_hd__nor2_1
XANTENNA__3065__B1 _3096_/A1 VGND VGND VPWR VPWR sky130_fd_sc_hd__diode_2
XFILLER_81_242 VGND VGND VPWR VPWR sky130_fd_sc_hd__fill_2
XFILLER_14_309 VGND VGND VPWR VPWR sky130_fd_sc_hd__fill_2
XFILLER_25_15 VPWR VGND VPWR VGND sky130_ef_sc_hd__decap_40_12
XFILLER_26_169 VGND VGND VPWR VPWR sky130_fd_sc_hd__fill_1
XANTENNA__4065__A _4263_/A VGND VGND VPWR VPWR sky130_fd_sc_hd__diode_2
XANTENNA__5054__A1 _5826_/Q VGND VGND VPWR VPWR sky130_fd_sc_hd__diode_2
XTAP_TAPCELL_ROW_85_1582 VGND VPWR sky130_fd_sc_hd__tapvpwrvgnd_1
XTAP_TAPCELL_ROW_85_1571 VGND VPWR sky130_fd_sc_hd__tapvpwrvgnd_1
XFILLER_81_286 VGND VGND VPWR VPWR sky130_fd_sc_hd__fill_1
XFILLER_23_821 VPWR VGND VPWR VGND sky130_ef_sc_hd__decap_40_12
X_5818_ _5841_/CLK _5818_/D VGND VGND VPWR VPWR _5818_/Q sky130_fd_sc_hd__dfxtp_2
XFILLER_50_673 VGND VGND VPWR VPWR sky130_fd_sc_hd__fill_2
XFILLER_136_701 VPWR VGND VPWR VGND sky130_ef_sc_hd__decap_40_12
X_5749_ _6137_/CLK _5749_/D VGND VGND VPWR VPWR _5749_/Q sky130_fd_sc_hd__dfxtp_1
XTAP_TAPCELL_ROW_20_598 VGND VPWR sky130_fd_sc_hd__tapvpwrvgnd_1
XANTENNA__4939__S _4944_/S VGND VGND VPWR VPWR sky130_fd_sc_hd__diode_2
Xhold560 _5409_/Q VGND VGND VPWR VPWR hold560/X sky130_fd_sc_hd__dlygate4sd3_1
Xhold571 _4321_/X VGND VGND VPWR VPWR _5968_/D sky130_fd_sc_hd__dlygate4sd3_1
XFILLER_2_725 VPWR VGND VPWR VGND sky130_ef_sc_hd__decap_40_12
XANTENNA__3540__A1 _5080_/A0 VGND VGND VPWR VPWR sky130_fd_sc_hd__diode_2
Xhold593 _3611_/X VGND VGND VPWR VPWR _5642_/D sky130_fd_sc_hd__dlygate4sd3_1
Xhold582 _6082_/Q VGND VGND VPWR VPWR hold582/X sky130_fd_sc_hd__dlygate4sd3_1
XFILLER_2_769 VPWR VGND VPWR VGND sky130_ef_sc_hd__decap_40_12
XFILLER_104_697 VGND VGND VPWR VPWR sky130_fd_sc_hd__fill_2
XFILLER_77_548 VGND VGND VPWR VPWR sky130_fd_sc_hd__fill_1
XFILLER_66_33 VGND VGND VPWR VPWR sky130_fd_sc_hd__fill_1
XFILLER_92_529 VGND VGND VPWR VPWR sky130_fd_sc_hd__fill_2
Xhold1260 _4823_/X VGND VGND VPWR VPWR _6177_/D sky130_fd_sc_hd__dlygate4sd3_1
XFILLER_66_55 VGND VGND VPWR VPWR sky130_fd_sc_hd__fill_2
Xhold1293 _6069_/Q VGND VGND VPWR VPWR _4461_/A1 sky130_fd_sc_hd__dlygate4sd3_1
Xhold1271 _5760_/Q VGND VGND VPWR VPWR _3747_/A1 sky130_fd_sc_hd__dlygate4sd3_1
XFILLER_18_637 VGND VGND VPWR VPWR sky130_fd_sc_hd__fill_4
Xhold1282 _4351_/X VGND VGND VPWR VPWR _5994_/D sky130_fd_sc_hd__dlygate4sd3_1
XFILLER_60_404 VGND VGND VPWR VPWR sky130_fd_sc_hd__fill_1
XANTENNA__5045__A1 _5045_/A1 VGND VGND VPWR VPWR sky130_fd_sc_hd__diode_2
XTAP_TAPCELL_ROW_0_290 VGND VPWR sky130_fd_sc_hd__tapvpwrvgnd_1
XFILLER_13_331 VGND VGND VPWR VPWR sky130_fd_sc_hd__fill_1
XFILLER_15_70 VGND VGND VPWR VPWR sky130_fd_sc_hd__fill_1
XFILLER_40_150 VGND VGND VPWR VPWR sky130_fd_sc_hd__fill_4
XANTENNA__4422__B input4/X VGND VGND VPWR VPWR sky130_fd_sc_hd__diode_2
XFILLER_5_541 VPWR VGND VPWR VGND sky130_ef_sc_hd__decap_40_12
XFILLER_126_277 VGND VGND VPWR VPWR sky130_fd_sc_hd__fill_2
XFILLER_126_255 VGND VGND VPWR VPWR sky130_fd_sc_hd__fill_8
XANTENNA__4849__S _4854_/S VGND VGND VPWR VPWR sky130_fd_sc_hd__diode_2
XFILLER_5_585 VPWR VGND VPWR VGND sky130_ef_sc_hd__decap_40_12
XFILLER_96_813 VPWR VGND VPWR VGND sky130_ef_sc_hd__decap_40_12
XANTENNA__3531__A1 _4883_/A1 VGND VGND VPWR VPWR sky130_fd_sc_hd__diode_2
XANTENNA__2965__S0 _2963_/S VGND VGND VPWR VPWR sky130_fd_sc_hd__diode_2
X_3100_ _4881_/A _3208_/A VGND VGND VPWR VPWR _3112_/S sky130_fd_sc_hd__nor2_4
XFILLER_110_601 VPWR VGND VPWR VGND sky130_ef_sc_hd__decap_40_12
XFILLER_110_645 VPWR VGND VPWR VGND sky130_ef_sc_hd__decap_40_12
X_4080_ _4251_/A _4080_/B VGND VGND VPWR VPWR _4080_/X sky130_fd_sc_hd__or2_1
X_3031_ _3031_/A1 _3030_/X _3029_/X _3089_/C1 VGND VGND VPWR VPWR _3031_/X sky130_fd_sc_hd__o211a_1
XFILLER_64_754 VGND VGND VPWR VPWR sky130_fd_sc_hd__fill_2
XFILLER_91_573 VPWR VGND VPWR VGND sky130_ef_sc_hd__decap_40_12
XFILLER_91_540 VPWR VGND VPWR VGND sky130_ef_sc_hd__decap_40_12
XANTENNA__3598__A1 _5209_/A1 VGND VGND VPWR VPWR sky130_fd_sc_hd__diode_2
X_4982_ hold731/X _4982_/A1 _4984_/S VGND VGND VPWR VPWR _4982_/X sky130_fd_sc_hd__mux2_1
X_3933_ _4929_/A1 _4105_/A1 _3938_/S VGND VGND VPWR VPWR _3933_/X sky130_fd_sc_hd__mux2_1
XANTENNA__2832__S _3062_/S VGND VGND VPWR VPWR sky130_fd_sc_hd__diode_2
X_3864_ _4517_/A1 hold879/X _3869_/S VGND VGND VPWR VPWR _5846_/D sky130_fd_sc_hd__mux2_1
XANTENNA_hold2196_X _2666_/A VGND VGND VPWR VPWR sky130_fd_sc_hd__diode_2
XFILLER_20_813 VPWR VGND VPWR VGND sky130_ef_sc_hd__decap_40_12
X_2815_ _6425_/Q _5310_/Q _3072_/S VGND VGND VPWR VPWR _2815_/X sky130_fd_sc_hd__mux2_1
X_5603_ _6057_/CLK _5603_/D VGND VGND VPWR VPWR _5603_/Q sky130_fd_sc_hd__dfxtp_1
XFILLER_118_701 VPWR VGND VPWR VGND sky130_ef_sc_hd__decap_40_12
X_3795_ hold258/X _5214_/A1 _3797_/S VGND VGND VPWR VPWR _3795_/X sky130_fd_sc_hd__mux2_1
X_5534_ clkload6/A _5534_/D VGND VGND VPWR VPWR _5534_/Q sky130_fd_sc_hd__dfxtp_1
X_2746_ hold665/X _4886_/A1 _2753_/S VGND VGND VPWR VPWR _2746_/X sky130_fd_sc_hd__mux2_1
X_2677_ _3207_/B _3207_/C VGND VGND VPWR VPWR _2681_/B sky130_fd_sc_hd__nor2_2
XANTENNA__3663__S _3667_/S VGND VGND VPWR VPWR sky130_fd_sc_hd__diode_2
X_5465_ clkload8/A _5465_/D VGND VGND VPWR VPWR _5465_/Q sky130_fd_sc_hd__dfxtp_1
X_4416_ _5047_/A1 _4416_/A1 _4416_/S VGND VGND VPWR VPWR _4416_/X sky130_fd_sc_hd__mux2_1
XFILLER_99_673 VPWR VGND VPWR VGND sky130_ef_sc_hd__decap_40_12
X_5396_ _6382_/CLK _5396_/D VGND VGND VPWR VPWR _5396_/Q sky130_fd_sc_hd__dfxtp_2
XANTENNA__3222__A_N _4773_/S VGND VGND VPWR VPWR sky130_fd_sc_hd__diode_2
X_4347_ _5050_/B _4377_/B VGND VGND VPWR VPWR _4356_/S sky130_fd_sc_hd__nor2_4
X_4278_ hold73/X _5053_/A1 _4284_/S VGND VGND VPWR VPWR hold74/A sky130_fd_sc_hd__mux2_1
XTAP_TAPCELL_ROW_87_1611 VGND VPWR sky130_fd_sc_hd__tapvpwrvgnd_1
XTAP_TAPCELL_ROW_87_1600 VGND VPWR sky130_fd_sc_hd__tapvpwrvgnd_1
XANTENNA_fanout181_X _2962_/A VGND VGND VPWR VPWR sky130_fd_sc_hd__diode_2
X_3229_ _3263_/A _3263_/B _3263_/C _3229_/D VGND VGND VPWR VPWR _3231_/B sky130_fd_sc_hd__or4_1
X_6017_ _6349_/CLK _6017_/D VGND VGND VPWR VPWR _6017_/Q sky130_fd_sc_hd__dfxtp_1
XFILLER_100_199 VGND VGND VPWR VPWR sky130_fd_sc_hd__fill_2
XANTENNA__3372__A_N input5/X VGND VGND VPWR VPWR sky130_fd_sc_hd__diode_2
XFILLER_67_592 VGND VGND VPWR VPWR sky130_fd_sc_hd__fill_1
XFILLER_55_721 VGND VGND VPWR VPWR sky130_fd_sc_hd__fill_1
XFILLER_82_562 VGND VGND VPWR VPWR sky130_fd_sc_hd__fill_1
XFILLER_55_776 VGND VGND VPWR VPWR sky130_fd_sc_hd__fill_8
XFILLER_27_445 VGND VGND VPWR VPWR sky130_fd_sc_hd__fill_2
XFILLER_27_478 VGND VGND VPWR VPWR sky130_fd_sc_hd__fill_1
XFILLER_54_264 VGND VGND VPWR VPWR sky130_fd_sc_hd__fill_1
XFILLER_14_106 VGND VGND VPWR VPWR sky130_fd_sc_hd__fill_1
XFILLER_15_629 VPWR VGND VPWR VGND sky130_ef_sc_hd__decap_40_12
XANTENNA__3589__A1 _4958_/A0 VGND VGND VPWR VPWR sky130_fd_sc_hd__diode_2
XFILLER_42_448 VGND VGND VPWR VPWR sky130_fd_sc_hd__fill_1
XFILLER_14_139 VGND VGND VPWR VPWR sky130_fd_sc_hd__fill_1
XANTENNA__4523__A _4881_/A VGND VGND VPWR VPWR sky130_fd_sc_hd__diode_2
XTAP_TAPCELL_ROW_25_668 VGND VPWR sky130_fd_sc_hd__tapvpwrvgnd_1
XTAP_TAPCELL_ROW_25_679 VGND VPWR sky130_fd_sc_hd__tapvpwrvgnd_1
XFILLER_136_531 VGND VGND VPWR VPWR sky130_fd_sc_hd__fill_1
XANTENNA__3210__A0 _5820_/Q VGND VGND VPWR VPWR sky130_fd_sc_hd__diode_2
XTAP_TAPCELL_ROW_114_2007 VGND VPWR sky130_fd_sc_hd__tapvpwrvgnd_1
XTAP_TAPCELL_ROW_98_1773 VGND VPWR sky130_fd_sc_hd__tapvpwrvgnd_1
XFILLER_10_389 VPWR VGND VPWR VGND sky130_ef_sc_hd__decap_40_12
XANTENNA__3573__S _3574_/S VGND VGND VPWR VPWR sky130_fd_sc_hd__diode_2
XANTENNA__4669__S _4810_/S VGND VGND VPWR VPWR sky130_fd_sc_hd__diode_2
XANTENNA__3761__A1 _5042_/A1 VGND VGND VPWR VPWR sky130_fd_sc_hd__diode_2
XFILLER_124_737 VPWR VGND VPWR VGND sky130_ef_sc_hd__decap_40_12
XFILLER_2_533 VPWR VGND VPWR VGND sky130_ef_sc_hd__decap_40_12
Xhold390 _4890_/X VGND VGND VPWR VPWR _6239_/D sky130_fd_sc_hd__dlygate4sd3_1
XFILLER_78_813 VPWR VGND VPWR VGND sky130_ef_sc_hd__decap_40_12
XANTENNA_fanout94_X _5047_/A1 VGND VGND VPWR VPWR sky130_fd_sc_hd__diode_2
XFILLER_132_781 VPWR VGND VPWR VGND sky130_ef_sc_hd__decap_40_12
XFILLER_77_76 VGND VGND VPWR VPWR sky130_fd_sc_hd__fill_1
XANTENNA__2917__S _3077_/S VGND VGND VPWR VPWR sky130_fd_sc_hd__diode_2
XFILLER_58_570 VGND VGND VPWR VPWR sky130_fd_sc_hd__fill_1
XFILLER_46_710 VGND VGND VPWR VPWR sky130_fd_sc_hd__fill_4
XTAP_TAPCELL_ROW_5_382 VGND VPWR sky130_fd_sc_hd__tapvpwrvgnd_1
XTAP_TAPCELL_ROW_5_371 VGND VPWR sky130_fd_sc_hd__tapvpwrvgnd_1
XFILLER_18_401 VPWR VGND VPWR VGND sky130_ef_sc_hd__decap_40_12
XANTENNA_clkbuf_leaf_82_clk_A clkload1/A VGND VGND VPWR VPWR sky130_fd_sc_hd__diode_2
XTAP_TAPCELL_ROW_125_2169 VGND VPWR sky130_fd_sc_hd__tapvpwrvgnd_1
XFILLER_18_445 VPWR VGND VPWR VGND sky130_ef_sc_hd__decap_40_12
Xhold1090 _5941_/Q VGND VGND VPWR VPWR _4290_/A0 sky130_fd_sc_hd__dlygate4sd3_1
XFILLER_46_798 VPWR VGND VPWR VGND sky130_ef_sc_hd__decap_40_12
XFILLER_18_489 VPWR VGND VPWR VGND sky130_ef_sc_hd__decap_40_12
XFILLER_60_256 VGND VGND VPWR VPWR sky130_fd_sc_hd__fill_1
XTAP_TAPCELL_ROW_44_966 VGND VPWR sky130_fd_sc_hd__tapvpwrvgnd_1
XTAP_TAPCELL_ROW_44_955 VGND VPWR sky130_fd_sc_hd__tapvpwrvgnd_1
XANTENNA_clkbuf_leaf_97_clk_A clkload0/A VGND VGND VPWR VPWR sky130_fd_sc_hd__diode_2
XANTENNA__6421__Q _6459_/A VGND VGND VPWR VPWR sky130_fd_sc_hd__diode_2
XANTENNA_clkbuf_leaf_20_clk_A clkload3/A VGND VGND VPWR VPWR sky130_fd_sc_hd__diode_2
X_3580_ _3580_/A0 _5212_/A1 _3584_/S VGND VGND VPWR VPWR _3580_/X sky130_fd_sc_hd__mux2_1
XFILLER_127_553 VGND VGND VPWR VPWR sky130_fd_sc_hd__fill_4
XANTENNA__3483__S _3490_/S VGND VGND VPWR VPWR sky130_fd_sc_hd__diode_2
XFILLER_127_597 VPWR VGND VPWR VGND sky130_ef_sc_hd__decap_40_12
X_5250_ _6199_/CLK _5250_/D VGND VGND VPWR VPWR _5250_/Q sky130_fd_sc_hd__dfxtp_1
XTAP_TAPCELL_ROW_54_1109 VGND VPWR sky130_fd_sc_hd__tapvpwrvgnd_1
XANTENNA_clkbuf_leaf_35_clk_A clkload4/A VGND VGND VPWR VPWR sky130_fd_sc_hd__diode_2
XFILLER_47_3 VGND VGND VPWR VPWR sky130_fd_sc_hd__fill_1
XFILLER_5_393 VPWR VGND VPWR VGND sky130_ef_sc_hd__decap_40_12
X_4201_ _4252_/B1 _4200_/X _4197_/Y _4199_/Y VGND VGND VPWR VPWR _4202_/B sky130_fd_sc_hd__o2bb2a_1
XFILLER_123_781 VGND VGND VPWR VPWR sky130_fd_sc_hd__fill_2
X_5181_ _5185_/A1 _6258_/Q _5194_/S VGND VGND VPWR VPWR _5181_/X sky130_fd_sc_hd__mux2_1
XFILLER_96_643 VGND VGND VPWR VPWR sky130_fd_sc_hd__fill_1
XFILLER_68_356 VGND VGND VPWR VPWR sky130_fd_sc_hd__fill_8
XFILLER_3_51 VGND VGND VPWR VPWR sky130_fd_sc_hd__fill_4
X_4132_ _4218_/A _4132_/B VGND VGND VPWR VPWR _4132_/Y sky130_fd_sc_hd__nor2_1
XANTENNA__2827__S _2984_/S VGND VGND VPWR VPWR sky130_fd_sc_hd__diode_2
XFILLER_95_175 VGND VGND VPWR VPWR sky130_fd_sc_hd__fill_1
X_4063_ _4149_/A _4063_/B VGND VGND VPWR VPWR _4063_/X sky130_fd_sc_hd__and2_1
X_3014_ _6078_/Q _6370_/Q _3016_/S VGND VGND VPWR VPWR _3015_/B sky130_fd_sc_hd__mux2_1
XFILLER_95_186 VGND VGND VPWR VPWR sky130_fd_sc_hd__fill_4
XTAP_TAPCELL_ROW_69_1330 VGND VPWR sky130_fd_sc_hd__tapvpwrvgnd_1
XTAP_TAPCELL_ROW_69_1341 VGND VPWR sky130_fd_sc_hd__tapvpwrvgnd_1
XANTENNA__4217__C1 _5343_/Q VGND VGND VPWR VPWR sky130_fd_sc_hd__diode_2
XTAP_TAPCELL_ROW_82_1530 VGND VPWR sky130_fd_sc_hd__tapvpwrvgnd_1
XFILLER_52_757 VPWR VGND VPWR VGND sky130_ef_sc_hd__decap_40_12
X_4965_ _4965_/A _4965_/B VGND VGND VPWR VPWR _4974_/S sky130_fd_sc_hd__or2_4
XANTENNA_fanout141_A _4600_/A VGND VGND VPWR VPWR sky130_fd_sc_hd__diode_2
X_3916_ hold930/X _5214_/A1 _3918_/S VGND VGND VPWR VPWR _3916_/X sky130_fd_sc_hd__mux2_1
XFILLER_11_109 VGND VGND VPWR VPWR sky130_fd_sc_hd__fill_2
X_4896_ _5239_/A1 _4896_/A1 _4906_/S VGND VGND VPWR VPWR _4896_/X sky130_fd_sc_hd__mux2_1
XANTENNA_clkbuf_leaf_108_clk_A clkload0/A VGND VGND VPWR VPWR sky130_fd_sc_hd__diode_2
XFILLER_20_643 VGND VGND VPWR VPWR sky130_fd_sc_hd__fill_1
XTAP_TAPCELL_ROW_22_627 VGND VPWR sky130_fd_sc_hd__tapvpwrvgnd_1
X_3847_ input22/X _3837_/A _4922_/C _3846_/X _5176_/A VGND VGND VPWR VPWR _5837_/D
+ sky130_fd_sc_hd__o311a_1
XANTENNA__6331__Q _6460_/A VGND VGND VPWR VPWR sky130_fd_sc_hd__diode_2
XFILLER_22_27 VGND VGND VPWR VPWR sky130_fd_sc_hd__fill_1
XFILLER_138_27 VGND VGND VPWR VPWR sky130_fd_sc_hd__fill_1
XFILLER_118_531 VGND VGND VPWR VPWR sky130_fd_sc_hd__fill_1
XANTENNA__5193__B1 _5200_/A VGND VGND VPWR VPWR sky130_fd_sc_hd__diode_2
X_3778_ _4955_/B _4513_/B VGND VGND VPWR VPWR _3787_/S sky130_fd_sc_hd__nor2_4
XFILLER_133_501 VGND VGND VPWR VPWR sky130_fd_sc_hd__fill_2
X_5517_ _5565_/CLK _5517_/D VGND VGND VPWR VPWR _5517_/Q sky130_fd_sc_hd__dfxtp_1
XANTENNA__3743__A1 _5235_/A0 VGND VGND VPWR VPWR sky130_fd_sc_hd__diode_2
X_2729_ _3085_/A _2732_/C VGND VGND VPWR VPWR _2730_/B sky130_fd_sc_hd__and2_1
XANTENNA__4489__S _4492_/S VGND VGND VPWR VPWR sky130_fd_sc_hd__diode_2
XFILLER_4_809 VGND VGND VPWR VPWR sky130_fd_sc_hd__fill_2
XANTENNA__4940__A0 _4980_/A1 VGND VGND VPWR VPWR sky130_fd_sc_hd__diode_2
XFILLER_106_737 VPWR VGND VPWR VGND sky130_ef_sc_hd__decap_40_12
X_5448_ _5908_/CLK _5448_/D VGND VGND VPWR VPWR _5448_/Q sky130_fd_sc_hd__dfxtp_1
XFILLER_121_729 VPWR VGND VPWR VGND sky130_ef_sc_hd__decap_40_12
X_5379_ _6366_/CLK _5379_/D VGND VGND VPWR VPWR _5379_/Q sky130_fd_sc_hd__dfxtp_1
XFILLER_114_781 VPWR VGND VPWR VGND sky130_ef_sc_hd__decap_40_12
XTAP_TAPCELL_ROW_93_1692 VGND VPWR sky130_fd_sc_hd__tapvpwrvgnd_1
Xfanout122 hold2238/X VGND VGND VPWR VPWR _5237_/A0 sky130_fd_sc_hd__clkbuf_4
Xfanout111 _5823_/Q VGND VGND VPWR VPWR _4976_/A1 sky130_fd_sc_hd__clkbuf_4
Xfanout100 _5828_/Q VGND VGND VPWR VPWR _4981_/A1 sky130_fd_sc_hd__clkbuf_4
Xfanout133 _5811_/Q VGND VGND VPWR VPWR _4901_/A0 sky130_fd_sc_hd__clkbuf_4
Xfanout144 _4600_/A VGND VGND VPWR VPWR _4794_/A sky130_fd_sc_hd__clkbuf_8
Xfanout155 _4260_/S VGND VGND VPWR VPWR _4272_/S sky130_fd_sc_hd__buf_4
Xfanout188 _5267_/Q VGND VGND VPWR VPWR _3020_/A sky130_fd_sc_hd__clkbuf_4
XFILLER_87_665 VGND VGND VPWR VPWR sky130_fd_sc_hd__fill_4
Xfanout199 _5266_/Q VGND VGND VPWR VPWR _3033_/S sky130_fd_sc_hd__clkbuf_8
Xfanout177 _3027_/A VGND VGND VPWR VPWR _3085_/A sky130_fd_sc_hd__buf_4
Xfanout166 _4221_/S VGND VGND VPWR VPWR _4250_/S sky130_fd_sc_hd__buf_4
XFILLER_74_337 VGND VGND VPWR VPWR sky130_fd_sc_hd__fill_4
XTAP_TAPCELL_ROW_2_330 VGND VPWR sky130_fd_sc_hd__tapvpwrvgnd_1
XPHY_EDGE_ROW_29_Right_29 VGND VGND VPWR VPWR sky130_fd_sc_hd__decap_3
XFILLER_103_85 VGND VGND VPWR VPWR sky130_fd_sc_hd__fill_2
XFILLER_63_23 VGND VGND VPWR VPWR sky130_fd_sc_hd__fill_1
XANTENNA__4952__S _4954_/S VGND VGND VPWR VPWR sky130_fd_sc_hd__diode_2
XFILLER_70_554 VGND VGND VPWR VPWR sky130_fd_sc_hd__fill_4
XANTENNA__3568__S _3574_/S VGND VGND VPWR VPWR sky130_fd_sc_hd__diode_2
XFILLER_30_418 VGND VGND VPWR VPWR sky130_fd_sc_hd__fill_2
XTAP_TAPCELL_ROW_41_914 VGND VPWR sky130_fd_sc_hd__tapvpwrvgnd_1
XTAP_TAPCELL_ROW_120_2099 VGND VPWR sky130_fd_sc_hd__tapvpwrvgnd_1
XFILLER_8_29 VGND VGND VPWR VPWR sky130_fd_sc_hd__fill_4
XFILLER_11_665 VGND VGND VPWR VPWR sky130_fd_sc_hd__fill_4
XPHY_EDGE_ROW_38_Right_38 VGND VGND VPWR VPWR sky130_fd_sc_hd__decap_3
XANTENNA__5184__B1 _5085_/A VGND VGND VPWR VPWR sky130_fd_sc_hd__diode_2
XFILLER_10_186 VGND VGND VPWR VPWR sky130_fd_sc_hd__fill_2
XFILLER_124_501 VPWR VGND VPWR VGND sky130_ef_sc_hd__decap_40_12
XANTENNA__3734__A1 _4882_/A1 VGND VGND VPWR VPWR sky130_fd_sc_hd__diode_2
XANTENNA__4399__S _4406_/S VGND VGND VPWR VPWR sky130_fd_sc_hd__diode_2
XFILLER_7_669 VGND VGND VPWR VPWR sky130_fd_sc_hd__fill_2
XANTENNA__4082__S1 _4251_/A VGND VGND VPWR VPWR sky130_fd_sc_hd__diode_2
XFILLER_136_394 VGND VGND VPWR VPWR sky130_fd_sc_hd__fill_1
XFILLER_128_60 VGND VGND VPWR VPWR sky130_fd_sc_hd__fill_1
XFILLER_109_597 VPWR VGND VPWR VGND sky130_ef_sc_hd__decap_40_12
XFILLER_124_545 VPWR VGND VPWR VGND sky130_ef_sc_hd__decap_40_12
XFILLER_2_341 VPWR VGND VPWR VGND sky130_ef_sc_hd__decap_40_12
XFILLER_124_589 VPWR VGND VPWR VGND sky130_ef_sc_hd__decap_40_12
XANTENNA__3498__A0 _5811_/Q VGND VGND VPWR VPWR sky130_fd_sc_hd__diode_2
XFILLER_105_781 VGND VGND VPWR VPWR sky130_fd_sc_hd__fill_2
XFILLER_69_109 VGND VGND VPWR VPWR sky130_fd_sc_hd__fill_2
XFILLER_2_363 VGND VGND VPWR VPWR sky130_fd_sc_hd__fill_1
XFILLER_33_9 VGND VGND VPWR VPWR sky130_fd_sc_hd__fill_1
XTAP_TAPCELL_ROW_127_2209 VGND VPWR sky130_fd_sc_hd__tapvpwrvgnd_1
XANTENNA__5239__A1 _5239_/A1 VGND VGND VPWR VPWR sky130_fd_sc_hd__diode_2
XFILLER_93_613 VGND VGND VPWR VPWR sky130_fd_sc_hd__fill_2
XPHY_EDGE_ROW_47_Right_47 VGND VGND VPWR VPWR sky130_fd_sc_hd__decap_3
XTAP_TAPCELL_ROW_109_1931 VGND VPWR sky130_fd_sc_hd__tapvpwrvgnd_1
XFILLER_19_721 VGND VGND VPWR VPWR sky130_fd_sc_hd__fill_4
XTAP_TAPCELL_ROW_109_1942 VGND VPWR sky130_fd_sc_hd__tapvpwrvgnd_1
XFILLER_80_307 VGND VGND VPWR VPWR sky130_fd_sc_hd__fill_1
XANTENNA__6416__Q _6416_/Q VGND VGND VPWR VPWR sky130_fd_sc_hd__diode_2
XFILLER_19_765 VPWR VGND VPWR VGND sky130_ef_sc_hd__decap_40_12
XANTENNA__4862__S _4867_/S VGND VGND VPWR VPWR sky130_fd_sc_hd__diode_2
XFILLER_46_562 VGND VGND VPWR VPWR sky130_fd_sc_hd__fill_1
XFILLER_18_253 VGND VGND VPWR VPWR sky130_fd_sc_hd__fill_4
XANTENNA__3670__A0 _4484_/A0 VGND VGND VPWR VPWR sky130_fd_sc_hd__diode_2
XFILLER_61_532 VGND VGND VPWR VPWR sky130_fd_sc_hd__fill_1
XFILLER_34_757 VPWR VGND VPWR VGND sky130_ef_sc_hd__decap_40_12
XTAP_TAPCELL_ROW_64_1260 VGND VPWR sky130_fd_sc_hd__tapvpwrvgnd_1
XPHY_EDGE_ROW_56_Right_56 VGND VGND VPWR VPWR sky130_fd_sc_hd__decap_3
X_4750_ _5681_/Q hold14/A _5654_/Q _5672_/Q _4810_/S _4809_/A VGND VGND VPWR VPWR
+ _4750_/X sky130_fd_sc_hd__mux4_1
XFILLER_21_429 VPWR VGND VPWR VGND sky130_ef_sc_hd__decap_40_12
X_3701_ _5210_/A1 _4618_/A3 _3707_/S VGND VGND VPWR VPWR _3701_/X sky130_fd_sc_hd__mux2_1
X_4681_ _4791_/A1 _4678_/X _4791_/B1 VGND VGND VPWR VPWR _4681_/X sky130_fd_sc_hd__o21a_1
XFILLER_119_339 VGND VGND VPWR VPWR sky130_fd_sc_hd__fill_4
X_3632_ hold495/X _4517_/A1 _3637_/S VGND VGND VPWR VPWR _3632_/X sky130_fd_sc_hd__mux2_1
X_6420_ _6420_/CLK input2/X VGND VGND VPWR VPWR hold1/A sky130_fd_sc_hd__dfxtp_1
XFILLER_134_309 VGND VGND VPWR VPWR sky130_fd_sc_hd__fill_1
XFILLER_115_501 VGND VGND VPWR VPWR sky130_fd_sc_hd__fill_2
XANTENNA__4073__S1 _4212_/A VGND VGND VPWR VPWR sky130_fd_sc_hd__diode_2
X_6351_ _6351_/CLK _6351_/D VGND VGND VPWR VPWR _6351_/Q sky130_fd_sc_hd__dfxtp_1
XANTENNA__3725__A1 _5044_/A1 VGND VGND VPWR VPWR sky130_fd_sc_hd__diode_2
X_5302_ _6148_/CLK _5302_/D VGND VGND VPWR VPWR _5302_/Q sky130_fd_sc_hd__dfxtp_1
X_3563_ _4964_/A0 _4790_/A0 _3563_/S VGND VGND VPWR VPWR _3563_/X sky130_fd_sc_hd__mux2_1
XANTENNA__4102__S _5343_/Q VGND VGND VPWR VPWR sky130_fd_sc_hd__diode_2
X_3494_ _4445_/A _3494_/A1 _3503_/S VGND VGND VPWR VPWR _3494_/X sky130_fd_sc_hd__mux2_1
X_6282_ _6300_/CLK _6282_/D VGND VGND VPWR VPWR _6282_/Q sky130_fd_sc_hd__dfxtp_1
XFILLER_130_515 VPWR VGND VPWR VGND sky130_ef_sc_hd__decap_40_12
X_5233_ _5233_/A0 _5233_/A1 _5237_/S VGND VGND VPWR VPWR _5233_/X sky130_fd_sc_hd__mux2_1
XFILLER_103_729 VPWR VGND VPWR VGND sky130_ef_sc_hd__decap_40_12
XPHY_EDGE_ROW_65_Right_65 VGND VGND VPWR VPWR sky130_fd_sc_hd__decap_3
XFILLER_124_29 VPWR VGND VPWR VGND sky130_ef_sc_hd__decap_40_12
X_5164_ _3958_/A _5163_/X _5162_/Y _3947_/B VGND VGND VPWR VPWR _5165_/B sky130_fd_sc_hd__a2bb2o_1
XFILLER_96_473 VGND VGND VPWR VPWR sky130_fd_sc_hd__fill_1
Xhold1804 _5723_/Q VGND VGND VPWR VPWR _4648_/A3 sky130_fd_sc_hd__dlygate4sd3_1
XFILLER_56_304 VGND VGND VPWR VPWR sky130_fd_sc_hd__fill_4
Xhold1826 _5908_/Q VGND VGND VPWR VPWR _3932_/A1 sky130_fd_sc_hd__dlygate4sd3_1
X_4115_ _4252_/B1 _4114_/X _4111_/Y _4113_/Y VGND VGND VPWR VPWR _4116_/B sky130_fd_sc_hd__o2bb2a_1
Xhold1815 _3931_/X VGND VGND VPWR VPWR _5907_/D sky130_fd_sc_hd__dlygate4sd3_1
Xhold1859 _6209_/Q VGND VGND VPWR VPWR _4858_/A1 sky130_fd_sc_hd__dlygate4sd3_1
XANTENNA_fanout189_A _3086_/S VGND VGND VPWR VPWR sky130_fd_sc_hd__diode_2
Xhold1848 _5854_/Q VGND VGND VPWR VPWR _3873_/A1 sky130_fd_sc_hd__dlygate4sd3_1
X_5095_ _4002_/A _3998_/B _5207_/S VGND VGND VPWR VPWR _5095_/X sky130_fd_sc_hd__mux2_1
Xhold1837 _3591_/X VGND VGND VPWR VPWR _5625_/D sky130_fd_sc_hd__dlygate4sd3_1
Xi2c_master_axil_215 VGND VGND VPWR VPWR i2c_master_axil_215/HI s_axil_rdata[21] sky130_fd_sc_hd__conb_1
XTAP_TAPCELL_ROW_27_708 VGND VPWR sky130_fd_sc_hd__tapvpwrvgnd_1
X_4046_ _2634_/Y _4045_/X _4218_/A VGND VGND VPWR VPWR _4046_/X sky130_fd_sc_hd__a21o_1
Xi2c_master_axil_226 VGND VGND VPWR VPWR i2c_master_axil_226/HI s_axil_rresp[0] sky130_fd_sc_hd__conb_1
XANTENNA__4453__A2 _4457_/S VGND VGND VPWR VPWR sky130_fd_sc_hd__diode_2
XANTENNA__3661__A0 _6412_/Q VGND VGND VPWR VPWR sky130_fd_sc_hd__diode_2
XFILLER_17_49 VGND VGND VPWR VPWR sky130_fd_sc_hd__fill_4
XFILLER_25_768 VPWR VGND VPWR VGND sky130_ef_sc_hd__decap_40_12
XPHY_EDGE_ROW_74_Right_74 VGND VGND VPWR VPWR sky130_fd_sc_hd__decap_3
XFILLER_52_587 VGND VGND VPWR VPWR sky130_fd_sc_hd__fill_1
X_5997_ _6421_/CLK _5997_/D VGND VGND VPWR VPWR _5997_/Q sky130_fd_sc_hd__dfxtp_1
XANTENNA__3388__S _3390_/S VGND VGND VPWR VPWR sky130_fd_sc_hd__diode_2
XANTENNA_fanout144_X _4794_/A VGND VGND VPWR VPWR sky130_fd_sc_hd__diode_2
X_4948_ _4978_/A1 _4948_/A1 _4954_/S VGND VGND VPWR VPWR _4948_/X sky130_fd_sc_hd__mux2_1
XFILLER_33_59 VGND VGND VPWR VPWR sky130_fd_sc_hd__fill_1
XFILLER_138_615 VGND VGND VPWR VPWR sky130_fd_sc_hd__fill_1
X_4879_ hold411/X _4905_/A0 _4880_/S VGND VGND VPWR VPWR _4879_/X sky130_fd_sc_hd__mux2_1
XFILLER_20_473 VGND VGND VPWR VPWR sky130_fd_sc_hd__fill_2
XTAP_TAPCELL_ROW_95_1721 VGND VPWR sky130_fd_sc_hd__tapvpwrvgnd_1
XANTENNA__3716__A1 _4983_/A1 VGND VGND VPWR VPWR sky130_fd_sc_hd__diode_2
XTAP_TAPCELL_ROW_95_1732 VGND VPWR sky130_fd_sc_hd__tapvpwrvgnd_1
XFILLER_106_545 VPWR VGND VPWR VGND sky130_ef_sc_hd__decap_40_12
XPHY_EDGE_ROW_83_Right_83 VGND VGND VPWR VPWR sky130_fd_sc_hd__decap_3
XPHY_EDGE_ROW_18_Left_157 VGND VGND VPWR VPWR sky130_fd_sc_hd__decap_3
XFILLER_106_589 VPWR VGND VPWR VGND sky130_ef_sc_hd__decap_40_12
XTAP_TAPCELL_ROW_7_411 VGND VPWR sky130_fd_sc_hd__tapvpwrvgnd_1
XTAP_TAPCELL_ROW_7_400 VGND VPWR sky130_fd_sc_hd__tapvpwrvgnd_1
XANTENNA__4947__S _4954_/S VGND VGND VPWR VPWR sky130_fd_sc_hd__diode_2
XFILLER_121_559 VGND VGND VPWR VPWR sky130_fd_sc_hd__fill_1
XFILLER_121_537 VPWR VGND VPWR VGND sky130_ef_sc_hd__decap_40_12
XFILLER_58_45 VGND VGND VPWR VPWR sky130_fd_sc_hd__fill_1
XFILLER_75_646 VGND VGND VPWR VPWR sky130_fd_sc_hd__fill_4
XFILLER_47_337 VGND VGND VPWR VPWR sky130_fd_sc_hd__fill_8
XTAP_TAPCELL_ROW_122_2128 VGND VPWR sky130_fd_sc_hd__tapvpwrvgnd_1
XFILLER_55_370 VGND VGND VPWR VPWR sky130_fd_sc_hd__fill_4
XFILLER_16_713 VPWR VGND VPWR VGND sky130_ef_sc_hd__decap_40_12
XPHY_EDGE_ROW_92_Right_92 VGND VGND VPWR VPWR sky130_fd_sc_hd__decap_3
XFILLER_71_841 VGND VGND VPWR VPWR sky130_fd_sc_hd__fill_1
XFILLER_15_223 VGND VGND VPWR VPWR sky130_fd_sc_hd__fill_1
XFILLER_16_757 VPWR VGND VPWR VGND sky130_ef_sc_hd__decap_40_12
XPHY_EDGE_ROW_27_Left_166 VGND VGND VPWR VPWR sky130_fd_sc_hd__decap_3
XFILLER_28_595 VGND VGND VPWR VPWR sky130_fd_sc_hd__fill_1
XPHY_EDGE_ROW_133_Right_133 VGND VGND VPWR VPWR sky130_fd_sc_hd__decap_3
XTAP_TAPCELL_ROW_104_1861 VGND VPWR sky130_fd_sc_hd__tapvpwrvgnd_1
XANTENNA__3404__A0 _4976_/A1 VGND VGND VPWR VPWR sky130_fd_sc_hd__diode_2
XFILLER_129_615 VGND VGND VPWR VPWR sky130_fd_sc_hd__fill_1
XTAP_TAPCELL_ROW_137_2360 VGND VPWR sky130_fd_sc_hd__tapvpwrvgnd_1
XFILLER_11_473 VPWR VGND VPWR VGND sky130_ef_sc_hd__decap_40_12
XFILLER_23_81 VGND VGND VPWR VPWR sky130_fd_sc_hd__fill_8
XANTENNA__4904__A0 _4904_/A0 VGND VGND VPWR VPWR sky130_fd_sc_hd__diode_2
XFILLER_116_309 VGND VGND VPWR VPWR sky130_fd_sc_hd__fill_1
XFILLER_125_821 VPWR VGND VPWR VGND sky130_ef_sc_hd__decap_40_12
XPHY_EDGE_ROW_36_Left_175 VGND VGND VPWR VPWR sky130_fd_sc_hd__decap_3
XANTENNA__4380__A1 _5053_/A1 VGND VGND VPWR VPWR sky130_fd_sc_hd__diode_2
XFILLER_98_749 VGND VGND VPWR VPWR sky130_fd_sc_hd__fill_4
XANTENNA__4857__S _4867_/S VGND VGND VPWR VPWR sky130_fd_sc_hd__diode_2
XANTENNA__3761__S _3766_/S VGND VGND VPWR VPWR sky130_fd_sc_hd__diode_2
XFILLER_120_581 VGND VGND VPWR VPWR sky130_fd_sc_hd__fill_4
XANTENNA__4445__X _4445_/X VGND VGND VPWR VPWR sky130_fd_sc_hd__diode_2
XANTENNA__4592__S _4810_/S VGND VGND VPWR VPWR sky130_fd_sc_hd__diode_2
XPHY_EDGE_ROW_45_Left_184 VGND VGND VPWR VPWR sky130_fd_sc_hd__decap_3
XFILLER_0_41 VPWR VGND VPWR VGND sky130_ef_sc_hd__decap_40_12
XFILLER_19_573 VPWR VGND VPWR VGND sky130_ef_sc_hd__decap_40_12
X_5920_ clkload9/A _5920_/D VGND VGND VPWR VPWR _5920_/Q sky130_fd_sc_hd__dfxtp_1
XFILLER_62_841 VGND VGND VPWR VPWR sky130_fd_sc_hd__fill_1
XFILLER_0_85 VPWR VGND VPWR VGND sky130_ef_sc_hd__decap_40_12
X_5851_ _6098_/CLK _5851_/D VGND VGND VPWR VPWR _5851_/Q sky130_fd_sc_hd__dfxtp_1
X_2994_ _3096_/A1 _2993_/X _2990_/Y _2992_/Y VGND VGND VPWR VPWR _2995_/B sky130_fd_sc_hd__o2bb2a_1
XPHY_EDGE_ROW_100_Right_100 VGND VGND VPWR VPWR sky130_fd_sc_hd__decap_3
XANTENNA__3001__S _3030_/S VGND VGND VPWR VPWR sky130_fd_sc_hd__diode_2
XANTENNA__4199__A1 _4252_/A1 VGND VGND VPWR VPWR sky130_fd_sc_hd__diode_2
XFILLER_22_749 VGND VGND VPWR VPWR sky130_fd_sc_hd__fill_4
X_5782_ clkload8/A _5782_/D VGND VGND VPWR VPWR _5782_/Q sky130_fd_sc_hd__dfxtp_1
XFILLER_34_587 VGND VGND VPWR VPWR sky130_fd_sc_hd__fill_1
X_4802_ _4802_/A _4802_/B VGND VGND VPWR VPWR _4802_/X sky130_fd_sc_hd__or2_1
X_4733_ _4733_/A0 hold999/X _4795_/S VGND VGND VPWR VPWR _4733_/X sky130_fd_sc_hd__mux2_1
XFILLER_119_136 VGND VGND VPWR VPWR sky130_fd_sc_hd__fill_4
XFILLER_30_793 VPWR VGND VPWR VGND sky130_ef_sc_hd__decap_40_12
XTAP_TAPCELL_ROW_32_777 VGND VPWR sky130_fd_sc_hd__tapvpwrvgnd_1
X_6403_ _6403_/CLK _6403_/D VGND VGND VPWR VPWR _6403_/Q sky130_fd_sc_hd__dfxtp_1
XPHY_EDGE_ROW_54_Left_193 VGND VGND VPWR VPWR sky130_fd_sc_hd__decap_3
X_4664_ hold69/X hold977/X _4803_/S VGND VGND VPWR VPWR _4665_/B sky130_fd_sc_hd__mux2_1
XFILLER_135_629 VPWR VGND VPWR VGND sky130_ef_sc_hd__decap_40_12
XFILLER_128_681 VPWR VGND VPWR VGND sky130_ef_sc_hd__decap_40_12
Xhold901 _3150_/X VGND VGND VPWR VPWR _5331_/D sky130_fd_sc_hd__dlygate4sd3_1
X_3615_ hold399/X _5215_/A1 _3616_/S VGND VGND VPWR VPWR _3615_/X sky130_fd_sc_hd__mux2_1
X_4595_ _4811_/A1 _4594_/X _2628_/A VGND VGND VPWR VPWR _4595_/X sky130_fd_sc_hd__o21a_1
XANTENNA__3237__A _3237_/A VGND VGND VPWR VPWR sky130_fd_sc_hd__diode_2
Xhold912 _6317_/Q VGND VGND VPWR VPWR hold912/X sky130_fd_sc_hd__dlygate4sd3_1
Xhold923 _5232_/X VGND VGND VPWR VPWR _6429_/D sky130_fd_sc_hd__dlygate4sd3_1
Xhold945 _3547_/X VGND VGND VPWR VPWR _5588_/D sky130_fd_sc_hd__dlygate4sd3_1
XTAP_TAPCELL_ROW_77_1462 VGND VPWR sky130_fd_sc_hd__tapvpwrvgnd_1
XTAP_TAPCELL_ROW_77_1451 VGND VPWR sky130_fd_sc_hd__tapvpwrvgnd_1
X_3546_ _4621_/A1 _4958_/A0 _3552_/S VGND VGND VPWR VPWR _3546_/X sky130_fd_sc_hd__mux2_1
X_6334_ _6334_/CLK _6334_/D VGND VGND VPWR VPWR _6334_/Q sky130_fd_sc_hd__dfxtp_1
Xhold934 _6316_/Q VGND VGND VPWR VPWR hold934/X sky130_fd_sc_hd__dlygate4sd3_1
XANTENNA_fanout104_A _5042_/A1 VGND VGND VPWR VPWR sky130_fd_sc_hd__diode_2
Xhold989 _5425_/Q VGND VGND VPWR VPWR hold989/X sky130_fd_sc_hd__dlygate4sd3_1
XFILLER_89_727 VGND VGND VPWR VPWR sky130_fd_sc_hd__fill_1
Xhold967 _4986_/X VGND VGND VPWR VPWR _6318_/D sky130_fd_sc_hd__dlygate4sd3_1
Xhold978 _3782_/X VGND VGND VPWR VPWR _5790_/D sky130_fd_sc_hd__dlygate4sd3_1
XFILLER_1_609 VGND VGND VPWR VPWR sky130_fd_sc_hd__fill_4
X_6265_ _6316_/CLK _6265_/D VGND VGND VPWR VPWR _6265_/Q sky130_fd_sc_hd__dfxtp_1
Xhold956 _5664_/Q VGND VGND VPWR VPWR hold956/X sky130_fd_sc_hd__dlygate4sd3_1
XFILLER_135_39 VPWR VGND VPWR VGND sky130_ef_sc_hd__decap_40_12
X_3477_ _4906_/A0 hold936/X _3477_/S VGND VGND VPWR VPWR _3477_/X sky130_fd_sc_hd__mux2_1
XFILLER_103_559 VGND VGND VPWR VPWR sky130_fd_sc_hd__fill_1
XFILLER_103_537 VPWR VGND VPWR VGND sky130_ef_sc_hd__decap_40_12
XTAP_TAPCELL_ROW_90_1651 VGND VPWR sky130_fd_sc_hd__tapvpwrvgnd_1
XANTENNA__4994__C _5808_/D VGND VGND VPWR VPWR sky130_fd_sc_hd__diode_2
X_5216_ _5216_/A _5216_/B VGND VGND VPWR VPWR _5216_/Y sky130_fd_sc_hd__nand2_1
XANTENNA__4123__A1 _4264_/A1 VGND VGND VPWR VPWR sky130_fd_sc_hd__diode_2
Xhold1601 _3199_/X VGND VGND VPWR VPWR _5361_/D sky130_fd_sc_hd__dlygate4sd3_1
XFILLER_130_367 VGND VGND VPWR VPWR sky130_fd_sc_hd__fill_1
X_6196_ _6196_/CLK _6196_/D VGND VGND VPWR VPWR _6196_/Q sky130_fd_sc_hd__dfxtp_1
XANTENNA__3243__Y _3707_/S VGND VGND VPWR VPWR sky130_fd_sc_hd__diode_2
Xhold1612 _6254_/Q VGND VGND VPWR VPWR _4906_/A1 sky130_fd_sc_hd__dlygate4sd3_1
XFILLER_84_421 VGND VGND VPWR VPWR sky130_fd_sc_hd__fill_4
Xhold1634 _4703_/X VGND VGND VPWR VPWR _6166_/D sky130_fd_sc_hd__dlygate4sd3_1
X_5147_ _6393_/Q _5142_/B _3945_/A VGND VGND VPWR VPWR _5147_/Y sky130_fd_sc_hd__o21ai_1
XFILLER_56_112 VGND VGND VPWR VPWR sky130_fd_sc_hd__fill_1
Xhold1623 _5700_/Q VGND VGND VPWR VPWR _3677_/A1 sky130_fd_sc_hd__dlygate4sd3_1
XFILLER_28_15 VPWR VGND VPWR VGND sky130_ef_sc_hd__decap_40_12
X_5078_ _5234_/A0 _5078_/A1 _5081_/S VGND VGND VPWR VPWR _6369_/D sky130_fd_sc_hd__mux2_1
Xhold1656 _6218_/Q VGND VGND VPWR VPWR _4867_/A1 sky130_fd_sc_hd__dlygate4sd3_1
Xhold1645 _4827_/X VGND VGND VPWR VPWR _6181_/D sky130_fd_sc_hd__dlygate4sd3_1
Xhold1667 _4489_/X VGND VGND VPWR VPWR _6095_/D sky130_fd_sc_hd__dlygate4sd3_1
Xhold1678 _5429_/Q VGND VGND VPWR VPWR _3351_/A0 sky130_fd_sc_hd__dlygate4sd3_1
XFILLER_71_115 VPWR VGND VPWR VGND sky130_ef_sc_hd__decap_40_12
X_4029_ _5982_/Q _5973_/Q _5964_/Q hold65/A _4262_/S _4263_/A VGND VGND VPWR VPWR
+ _4029_/X sky130_fd_sc_hd__mux4_1
Xhold1689 _6302_/Q VGND VGND VPWR VPWR _4969_/A1 sky130_fd_sc_hd__dlygate4sd3_1
XFILLER_71_137 VGND VGND VPWR VPWR sky130_fd_sc_hd__fill_1
XFILLER_53_841 VGND VGND VPWR VPWR sky130_fd_sc_hd__fill_1
XFILLER_9_709 VPWR VGND VPWR VGND sky130_ef_sc_hd__decap_40_12
XFILLER_13_727 VGND VGND VPWR VPWR sky130_fd_sc_hd__fill_1
XFILLER_25_598 VGND VGND VPWR VPWR sky130_fd_sc_hd__fill_1
XFILLER_40_557 VGND VGND VPWR VPWR sky130_fd_sc_hd__fill_1
XFILLER_138_434 VGND VGND VPWR VPWR sky130_fd_sc_hd__fill_1
XTAP_TAPCELL_ROW_119_2090 VGND VPWR sky130_fd_sc_hd__tapvpwrvgnd_1
XTAP_TAPCELL_ROW_10_449 VGND VPWR sky130_fd_sc_hd__tapvpwrvgnd_1
XFILLER_138_489 VPWR VGND VPWR VGND sky130_ef_sc_hd__decap_40_12
XFILLER_114_3 VPWR VGND VPWR VGND sky130_ef_sc_hd__decap_40_12
XFILLER_107_821 VPWR VGND VPWR VGND sky130_ef_sc_hd__decap_40_12
XANTENNA__4362__A1 _4980_/A1 VGND VGND VPWR VPWR sky130_fd_sc_hd__diode_2
XFILLER_122_813 VPWR VGND VPWR VGND sky130_ef_sc_hd__decap_40_12
XFILLER_69_55 VGND VGND VPWR VPWR sky130_fd_sc_hd__fill_1
XFILLER_106_397 VGND VGND VPWR VPWR sky130_fd_sc_hd__fill_2
XANTENNA__2676__A1 _4906_/A0 VGND VGND VPWR VPWR sky130_fd_sc_hd__diode_2
XFILLER_102_581 VGND VGND VPWR VPWR sky130_fd_sc_hd__fill_4
XFILLER_88_793 VPWR VGND VPWR VGND sky130_ef_sc_hd__decap_40_12
XFILLER_75_410 VGND VGND VPWR VPWR sky130_fd_sc_hd__fill_2
XANTENNA__3873__A0 _4958_/A0 VGND VGND VPWR VPWR sky130_fd_sc_hd__diode_2
XFILLER_0_697 VGND VGND VPWR VPWR sky130_fd_sc_hd__fill_2
XFILLER_75_465 VGND VGND VPWR VPWR sky130_fd_sc_hd__fill_4
XANTENNA__4706__A _4789_/A VGND VGND VPWR VPWR sky130_fd_sc_hd__diode_2
XFILLER_62_115 VGND VGND VPWR VPWR sky130_fd_sc_hd__fill_1
XFILLER_44_841 VGND VGND VPWR VPWR sky130_fd_sc_hd__fill_1
XFILLER_18_81 VGND VGND VPWR VPWR sky130_fd_sc_hd__fill_2
XFILLER_71_671 VGND VGND VPWR VPWR sky130_fd_sc_hd__fill_1
XFILLER_16_587 VGND VGND VPWR VPWR sky130_fd_sc_hd__fill_1
XANTENNA__3928__A1 _5202_/A1 VGND VGND VPWR VPWR sky130_fd_sc_hd__diode_2
XTAP_TAPCELL_ROW_135_2319 VGND VPWR sky130_fd_sc_hd__tapvpwrvgnd_1
XFILLER_8_753 VGND VGND VPWR VPWR sky130_fd_sc_hd__fill_2
XFILLER_12_793 VPWR VGND VPWR VGND sky130_ef_sc_hd__decap_40_12
XFILLER_117_629 VPWR VGND VPWR VGND sky130_ef_sc_hd__decap_40_12
Xhold208 _5712_/Q VGND VGND VPWR VPWR hold208/X sky130_fd_sc_hd__dlygate4sd3_1
X_4380_ hold83/X _5053_/A1 _4386_/S VGND VGND VPWR VPWR hold84/A sky130_fd_sc_hd__mux2_1
X_3400_ hold675/X _4983_/A1 _3401_/S VGND VGND VPWR VPWR _3400_/X sky130_fd_sc_hd__mux2_1
XANTENNA__4353__A1 _4981_/A1 VGND VGND VPWR VPWR sky130_fd_sc_hd__diode_2
Xhold219 _4517_/X VGND VGND VPWR VPWR _6120_/D sky130_fd_sc_hd__dlygate4sd3_1
XFILLER_125_673 VPWR VGND VPWR VGND sky130_ef_sc_hd__decap_40_12
X_3331_ _3326_/X _3327_/Y _3325_/X VGND VGND VPWR VPWR _3331_/X sky130_fd_sc_hd__a21bo_1
XTAP_TAPCELL_ROW_59_1192 VGND VPWR sky130_fd_sc_hd__tapvpwrvgnd_1
XTAP_TAPCELL_ROW_59_1181 VGND VPWR sky130_fd_sc_hd__tapvpwrvgnd_1
XFILLER_98_557 VPWR VGND VPWR VGND sky130_ef_sc_hd__decap_40_12
XANTENNA_hold2236_A _5812_/Q VGND VGND VPWR VPWR sky130_fd_sc_hd__diode_2
X_3262_ _3265_/A _3265_/B _3237_/A VGND VGND VPWR VPWR _3262_/X sky130_fd_sc_hd__o21a_1
X_6050_ clkload9/A _6050_/D VGND VGND VPWR VPWR _6050_/Q sky130_fd_sc_hd__dfxtp_1
XANTENNA__3504__B _5069_/B VGND VGND VPWR VPWR sky130_fd_sc_hd__diode_2
X_3193_ hold536/X _5237_/A0 _3193_/S VGND VGND VPWR VPWR _3193_/X sky130_fd_sc_hd__mux2_1
XANTENNA__3864__A0 _4517_/A1 VGND VGND VPWR VPWR sky130_fd_sc_hd__diode_2
XTAP_TAPCELL_ROW_72_1381 VGND VPWR sky130_fd_sc_hd__tapvpwrvgnd_1
X_5001_ _5003_/B _5001_/B VGND VGND VPWR VPWR _5001_/Y sky130_fd_sc_hd__nand2_1
XANTENNA__4200__S1 _4241_/A VGND VGND VPWR VPWR sky130_fd_sc_hd__diode_2
XFILLER_93_273 VGND VGND VPWR VPWR sky130_fd_sc_hd__fill_4
XFILLER_81_446 VGND VGND VPWR VPWR sky130_fd_sc_hd__fill_2
XFILLER_66_498 VGND VGND VPWR VPWR sky130_fd_sc_hd__fill_1
XFILLER_35_841 VGND VGND VPWR VPWR sky130_fd_sc_hd__fill_1
XTAP_TAPCELL_ROW_37_858 VGND VPWR sky130_fd_sc_hd__tapvpwrvgnd_1
X_5903_ _6120_/CLK _5903_/D VGND VGND VPWR VPWR _5903_/Q sky130_fd_sc_hd__dfxtp_1
X_5834_ _6338_/CLK _5834_/D VGND VGND VPWR VPWR _5834_/Q sky130_fd_sc_hd__dfxtp_1
XFILLER_50_811 VGND VGND VPWR VPWR sky130_fd_sc_hd__fill_1
XTAP_TAPCELL_ROW_17_560 VGND VPWR sky130_fd_sc_hd__tapvpwrvgnd_1
XFILLER_22_513 VGND VGND VPWR VPWR sky130_fd_sc_hd__fill_2
X_2977_ _3052_/A1 _2976_/X _3076_/A1 VGND VGND VPWR VPWR _2977_/X sky130_fd_sc_hd__o21a_1
XPHY_EDGE_ROW_62_Left_201 VGND VGND VPWR VPWR sky130_fd_sc_hd__decap_3
XANTENNA__3666__S _3667_/S VGND VGND VPWR VPWR sky130_fd_sc_hd__diode_2
X_5765_ _6307_/CLK _5765_/D VGND VGND VPWR VPWR _5765_/Q sky130_fd_sc_hd__dfxtp_1
XANTENNA__4019__S1 _4212_/A VGND VGND VPWR VPWR sky130_fd_sc_hd__diode_2
X_5696_ _6120_/CLK _5696_/D VGND VGND VPWR VPWR _5696_/Q sky130_fd_sc_hd__dfxtp_1
X_4716_ _6122_/Q _6113_/Q _4801_/S VGND VGND VPWR VPWR _4716_/X sky130_fd_sc_hd__mux2_1
XFILLER_107_106 VGND VGND VPWR VPWR sky130_fd_sc_hd__fill_4
X_4647_ _4647_/A1 _4676_/A _4631_/X _4646_/Y VGND VGND VPWR VPWR _4647_/X sky130_fd_sc_hd__a22o_1
Xhold720 _5638_/Q VGND VGND VPWR VPWR hold720/X sky130_fd_sc_hd__dlygate4sd3_1
XANTENNA__4344__A1 _5046_/A1 VGND VGND VPWR VPWR sky130_fd_sc_hd__diode_2
XFILLER_104_813 VPWR VGND VPWR VGND sky130_ef_sc_hd__decap_40_12
Xhold764 _3567_/X VGND VGND VPWR VPWR _5604_/D sky130_fd_sc_hd__dlygate4sd3_1
X_6317_ _6351_/CLK _6317_/D VGND VGND VPWR VPWR _6317_/Q sky130_fd_sc_hd__dfxtp_1
Xhold742 _4309_/X VGND VGND VPWR VPWR _5957_/D sky130_fd_sc_hd__dlygate4sd3_1
XANTENNA_fanout107_X _4978_/A1 VGND VGND VPWR VPWR sky130_fd_sc_hd__diode_2
Xhold753 _6310_/Q VGND VGND VPWR VPWR hold753/X sky130_fd_sc_hd__dlygate4sd3_1
Xhold731 _6314_/Q VGND VGND VPWR VPWR hold731/X sky130_fd_sc_hd__dlygate4sd3_1
X_4578_ _5796_/Q _5787_/Q _4801_/S VGND VGND VPWR VPWR _4579_/B sky130_fd_sc_hd__mux2_1
XFILLER_115_172 VGND VGND VPWR VPWR sky130_fd_sc_hd__fill_1
X_3529_ _4906_/A0 _3529_/A1 _3529_/S VGND VGND VPWR VPWR _3529_/X sky130_fd_sc_hd__mux2_1
Xhold775 _5593_/Q VGND VGND VPWR VPWR hold775/X sky130_fd_sc_hd__dlygate4sd3_1
Xhold786 _4980_/X VGND VGND VPWR VPWR _6312_/D sky130_fd_sc_hd__dlygate4sd3_1
Xhold797 _5743_/Q VGND VGND VPWR VPWR hold797/X sky130_fd_sc_hd__dlygate4sd3_1
XFILLER_131_665 VGND VGND VPWR VPWR sky130_fd_sc_hd__fill_4
X_6248_ _6248_/CLK _6248_/D VGND VGND VPWR VPWR _6248_/Q sky130_fd_sc_hd__dfxtp_1
Xhold2110 _3375_/X VGND VGND VPWR VPWR _5438_/D sky130_fd_sc_hd__dlygate4sd3_1
XPHY_EDGE_ROW_71_Left_210 VGND VGND VPWR VPWR sky130_fd_sc_hd__decap_3
Xhold2121 _5916_/Q VGND VGND VPWR VPWR _3988_/B sky130_fd_sc_hd__dlygate4sd3_1
X_6179_ _6380_/CLK _6179_/D VGND VGND VPWR VPWR _6179_/Q sky130_fd_sc_hd__dfxtp_1
Xhold2132 _5384_/Q VGND VGND VPWR VPWR _3223_/B sky130_fd_sc_hd__dlygate4sd3_1
Xhold2143 _6329_/Q VGND VGND VPWR VPWR _5003_/A sky130_fd_sc_hd__dlygate4sd3_1
Xhold2154 _5322_/Q VGND VGND VPWR VPWR _2638_/A sky130_fd_sc_hd__dlygate4sd3_1
XFILLER_130_197 VGND VGND VPWR VPWR sky130_fd_sc_hd__fill_1
Xhold1420 _3210_/X VGND VGND VPWR VPWR _5370_/D sky130_fd_sc_hd__dlygate4sd3_1
XFILLER_69_281 VGND VGND VPWR VPWR sky130_fd_sc_hd__fill_1
Xhold2187 _5835_/Q VGND VGND VPWR VPWR _3842_/A sky130_fd_sc_hd__dlygate4sd3_1
Xhold2165 _5109_/X VGND VGND VPWR VPWR _6386_/D sky130_fd_sc_hd__dlygate4sd3_1
XFILLER_57_443 VGND VGND VPWR VPWR sky130_fd_sc_hd__fill_1
Xhold2176 _5400_/Q VGND VGND VPWR VPWR hold2176/X sky130_fd_sc_hd__dlygate4sd3_1
Xhold1431 _6087_/Q VGND VGND VPWR VPWR _4480_/A0 sky130_fd_sc_hd__dlygate4sd3_1
Xhold1442 _3256_/X VGND VGND VPWR VPWR _5392_/D sky130_fd_sc_hd__dlygate4sd3_1
Xhold1475 _5566_/Q VGND VGND VPWR VPWR _3523_/A1 sky130_fd_sc_hd__dlygate4sd3_1
XFILLER_85_785 VPWR VGND VPWR VGND sky130_ef_sc_hd__decap_40_12
XFILLER_84_251 VGND VGND VPWR VPWR sky130_fd_sc_hd__fill_1
Xhold1464 _3447_/X VGND VGND VPWR VPWR _5497_/D sky130_fd_sc_hd__dlygate4sd3_1
Xhold1486 _5721_/Q VGND VGND VPWR VPWR _3700_/A1 sky130_fd_sc_hd__dlygate4sd3_1
Xhold1453 _6299_/Q VGND VGND VPWR VPWR _4966_/A1 sky130_fd_sc_hd__dlygate4sd3_1
XFILLER_29_167 VGND VGND VPWR VPWR sky130_fd_sc_hd__fill_1
Xhold2198 _5321_/Q VGND VGND VPWR VPWR _3131_/A sky130_fd_sc_hd__dlygate4sd3_1
Xhold1497 _3292_/X VGND VGND VPWR VPWR _5411_/D sky130_fd_sc_hd__dlygate4sd3_1
XFILLER_26_841 VGND VGND VPWR VPWR sky130_fd_sc_hd__fill_1
XANTENNA__4804__C1 _4663_/A VGND VGND VPWR VPWR sky130_fd_sc_hd__diode_2
XFILLER_72_479 VGND VGND VPWR VPWR sky130_fd_sc_hd__fill_1
XTAP_TAPCELL_ROW_15_519 VGND VPWR sky130_fd_sc_hd__tapvpwrvgnd_1
XFILLER_41_833 VGND VGND VPWR VPWR sky130_fd_sc_hd__fill_4
XANTENNA__2830__A1 _3031_/A1 VGND VGND VPWR VPWR sky130_fd_sc_hd__diode_2
XTAP_TAPCELL_ROW_101_1820 VGND VPWR sky130_fd_sc_hd__tapvpwrvgnd_1
XFILLER_9_517 VPWR VGND VPWR VGND sky130_ef_sc_hd__decap_40_12
XFILLER_13_557 VGND VGND VPWR VPWR sky130_fd_sc_hd__fill_2
XFILLER_71_78 VGND VGND VPWR VPWR sky130_fd_sc_hd__fill_4
XTAP_TAPCELL_ROW_117_2049 VGND VPWR sky130_fd_sc_hd__tapvpwrvgnd_1
XTAP_TAPCELL_ROW_130_2249 VGND VPWR sky130_fd_sc_hd__tapvpwrvgnd_1
XFILLER_107_673 VPWR VGND VPWR VGND sky130_ef_sc_hd__decap_40_12
XFILLER_122_643 VGND VGND VPWR VPWR sky130_fd_sc_hd__fill_1
XFILLER_4_299 VGND VGND VPWR VPWR sky130_fd_sc_hd__fill_1
XFILLER_110_805 VGND VGND VPWR VPWR sky130_fd_sc_hd__fill_4
XFILLER_96_31 VGND VGND VPWR VPWR sky130_fd_sc_hd__fill_1
XFILLER_121_153 VGND VGND VPWR VPWR sky130_fd_sc_hd__fill_1
XTAP_TAPCELL_ROW_112_1982 VGND VPWR sky130_fd_sc_hd__tapvpwrvgnd_1
XFILLER_0_461 VPWR VGND VPWR VGND sky130_ef_sc_hd__decap_40_12
Xhold91 hold91/A VGND VGND VPWR VPWR hold91/X sky130_fd_sc_hd__dlygate4sd3_1
Xhold80 hold80/A VGND VGND VPWR VPWR hold80/X sky130_fd_sc_hd__dlygate4sd3_1
XFILLER_75_273 VGND VGND VPWR VPWR sky130_fd_sc_hd__fill_4
XFILLER_63_446 VGND VGND VPWR VPWR sky130_fd_sc_hd__fill_2
XFILLER_17_841 VGND VGND VPWR VPWR sky130_fd_sc_hd__fill_1
XANTENNA__3074__A1 _3072_/S VGND VGND VPWR VPWR sky130_fd_sc_hd__diode_2
XFILLER_91_777 VGND VGND VPWR VPWR sky130_fd_sc_hd__fill_4
XTAP_TAPCELL_ROW_34_806 VGND VPWR sky130_fd_sc_hd__tapvpwrvgnd_1
XTAP_TAPCELL_ROW_34_817 VGND VPWR sky130_fd_sc_hd__tapvpwrvgnd_1
XFILLER_35_159 VGND VGND VPWR VPWR sky130_fd_sc_hd__fill_2
XANTENNA__4870__S _4880_/S VGND VGND VPWR VPWR sky130_fd_sc_hd__diode_2
X_2900_ _3005_/A _2900_/B VGND VGND VPWR VPWR _2900_/X sky130_fd_sc_hd__or2_1
XFILLER_16_373 VPWR VGND VPWR VGND sky130_ef_sc_hd__decap_40_12
XFILLER_32_811 VGND VGND VPWR VPWR sky130_fd_sc_hd__fill_1
XANTENNA__2821__A1 _3036_/A1 VGND VGND VPWR VPWR sky130_fd_sc_hd__diode_2
Xclkbuf_leaf_70_clk clkload2/A VGND VGND VPWR VPWR _6382_/CLK sky130_fd_sc_hd__clkbuf_8
X_3880_ _4493_/B _3880_/B VGND VGND VPWR VPWR _3889_/S sky130_fd_sc_hd__nor2_4
XFILLER_43_192 VGND VGND VPWR VPWR sky130_fd_sc_hd__fill_1
XANTENNA__3486__S _3490_/S VGND VGND VPWR VPWR sky130_fd_sc_hd__diode_2
X_2831_ _2826_/X _2830_/X _2995_/A VGND VGND VPWR VPWR _2831_/Y sky130_fd_sc_hd__o21ai_1
XFILLER_31_387 VGND VGND VPWR VPWR sky130_fd_sc_hd__fill_4
X_2762_ _5513_/Q _5525_/Q _3051_/S VGND VGND VPWR VPWR _2762_/X sky130_fd_sc_hd__mux2_1
X_5550_ _6137_/CLK _5550_/D VGND VGND VPWR VPWR _5550_/Q sky130_fd_sc_hd__dfxtp_1
XANTENNA__3377__A2 _4994_/B VGND VGND VPWR VPWR sky130_fd_sc_hd__diode_2
X_5481_ _6199_/CLK _5481_/D VGND VGND VPWR VPWR _5481_/Q sky130_fd_sc_hd__dfxtp_1
X_4501_ hold661/X _5215_/A1 _4502_/S VGND VGND VPWR VPWR _4501_/X sky130_fd_sc_hd__mux2_1
X_2693_ _2663_/B _3541_/S _5222_/A VGND VGND VPWR VPWR _2693_/Y sky130_fd_sc_hd__a21oi_1
X_4432_ _5088_/A0 _4994_/B _4445_/B _4889_/A1 _4431_/X VGND VGND VPWR VPWR _4432_/X
+ sky130_fd_sc_hd__a221o_2
XFILLER_132_418 VGND VGND VPWR VPWR sky130_fd_sc_hd__fill_2
XTAP_TAPCELL_ROW_74_1410 VGND VPWR sky130_fd_sc_hd__tapvpwrvgnd_1
XFILLER_99_833 VGND VGND VPWR VPWR sky130_fd_sc_hd__fill_4
X_4363_ _4363_/A0 _4981_/A1 _4366_/S VGND VGND VPWR VPWR _4363_/X sky130_fd_sc_hd__mux2_1
XFILLER_113_665 VGND VGND VPWR VPWR sky130_fd_sc_hd__fill_4
X_3314_ _6387_/Q _6385_/Q _6386_/Q VGND VGND VPWR VPWR _3315_/B sky130_fd_sc_hd__or3b_2
X_6102_ _6114_/CLK _6102_/D VGND VGND VPWR VPWR _6102_/Q sky130_fd_sc_hd__dfxtp_1
X_4294_ hold610/X _4984_/A1 _4294_/S VGND VGND VPWR VPWR _4294_/X sky130_fd_sc_hd__mux2_1
XFILLER_98_376 VGND VGND VPWR VPWR sky130_fd_sc_hd__fill_1
X_3245_ _4503_/A _3607_/A VGND VGND VPWR VPWR _3245_/Y sky130_fd_sc_hd__nor2_1
X_6033_ _6314_/CLK _6033_/D VGND VGND VPWR VPWR _6033_/Q sky130_fd_sc_hd__dfxtp_1
XFILLER_132_29 VGND VGND VPWR VPWR sky130_fd_sc_hd__fill_4
XFILLER_67_785 VPWR VGND VPWR VGND sky130_ef_sc_hd__decap_40_12
XFILLER_66_251 VGND VGND VPWR VPWR sky130_fd_sc_hd__fill_1
X_3176_ _3175_/A _3175_/B _5200_/A VGND VGND VPWR VPWR _3177_/B sky130_fd_sc_hd__o21ai_1
XFILLER_82_755 VGND VGND VPWR VPWR sky130_fd_sc_hd__fill_1
XFILLER_54_424 VGND VGND VPWR VPWR sky130_fd_sc_hd__fill_2
XANTENNA_fanout171_A _4221_/S VGND VGND VPWR VPWR sky130_fd_sc_hd__diode_2
XFILLER_25_27 VGND VGND VPWR VPWR sky130_fd_sc_hd__fill_1
XTAP_TAPCELL_ROW_85_1572 VGND VPWR sky130_fd_sc_hd__tapvpwrvgnd_1
XANTENNA__4780__S _4810_/S VGND VGND VPWR VPWR sky130_fd_sc_hd__diode_2
XFILLER_23_833 VGND VGND VPWR VPWR sky130_fd_sc_hd__fill_4
XFILLER_25_38 VGND VGND VPWR VPWR sky130_fd_sc_hd__fill_1
XFILLER_35_671 VGND VGND VPWR VPWR sky130_fd_sc_hd__fill_1
X_5817_ _5820_/CLK _5817_/D VGND VGND VPWR VPWR _5817_/Q sky130_fd_sc_hd__dfxtp_2
XFILLER_22_365 VPWR VGND VPWR VGND sky130_ef_sc_hd__decap_40_12
X_5748_ _6399_/CLK _5748_/D VGND VGND VPWR VPWR _5748_/Q sky130_fd_sc_hd__dfxtp_1
XFILLER_136_713 VPWR VGND VPWR VGND sky130_ef_sc_hd__decap_40_12
XFILLER_136_757 VPWR VGND VPWR VGND sky130_ef_sc_hd__decap_40_12
XANTENNA_clkbuf_3_5__f_clk_A clkbuf_0_clk/X VGND VGND VPWR VPWR sky130_fd_sc_hd__diode_2
XANTENNA__4317__A1 _5051_/A1 VGND VGND VPWR VPWR sky130_fd_sc_hd__diode_2
XTAP_TAPCELL_ROW_20_599 VGND VPWR sky130_fd_sc_hd__tapvpwrvgnd_1
X_5679_ _5682_/CLK _5679_/D VGND VGND VPWR VPWR _5679_/Q sky130_fd_sc_hd__dfxtp_1
XFILLER_135_256 VGND VGND VPWR VPWR sky130_fd_sc_hd__fill_1
XANTENNA__3128__C _4451_/A VGND VGND VPWR VPWR sky130_fd_sc_hd__diode_2
Xhold550 _3124_/X VGND VGND VPWR VPWR _5317_/D sky130_fd_sc_hd__dlygate4sd3_1
XFILLER_123_429 VGND VGND VPWR VPWR sky130_fd_sc_hd__fill_1
Xhold572 _5501_/Q VGND VGND VPWR VPWR hold572/X sky130_fd_sc_hd__dlygate4sd3_1
Xhold561 _3290_/X VGND VGND VPWR VPWR _5409_/D sky130_fd_sc_hd__dlygate4sd3_1
XFILLER_2_737 VPWR VGND VPWR VGND sky130_ef_sc_hd__decap_40_12
XFILLER_104_643 VGND VGND VPWR VPWR sky130_fd_sc_hd__fill_1
XFILLER_77_505 VGND VGND VPWR VPWR sky130_fd_sc_hd__fill_2
Xhold583 _4475_/X VGND VGND VPWR VPWR _6082_/D sky130_fd_sc_hd__dlygate4sd3_1
Xhold594 _6033_/Q VGND VGND VPWR VPWR hold594/X sky130_fd_sc_hd__dlygate4sd3_1
XFILLER_106_41 VGND VGND VPWR VPWR sky130_fd_sc_hd__fill_1
XANTENNA_fanout84_A _5211_/A1 VGND VGND VPWR VPWR sky130_fd_sc_hd__diode_2
XFILLER_106_96 VGND VGND VPWR VPWR sky130_fd_sc_hd__fill_2
XFILLER_66_12 VGND VGND VPWR VPWR sky130_fd_sc_hd__fill_4
Xhold1261 _6190_/Q VGND VGND VPWR VPWR _4837_/A1 sky130_fd_sc_hd__dlygate4sd3_1
Xhold1250 _5287_/Q VGND VGND VPWR VPWR _3148_/A1 sky130_fd_sc_hd__dlygate4sd3_1
Xhold1283 _5539_/Q VGND VGND VPWR VPWR _3494_/A1 sky130_fd_sc_hd__dlygate4sd3_1
Xhold1294 _4461_/X VGND VGND VPWR VPWR _6069_/D sky130_fd_sc_hd__dlygate4sd3_1
Xhold1272 _3747_/X VGND VGND VPWR VPWR _5760_/D sky130_fd_sc_hd__dlygate4sd3_1
XFILLER_17_115 VGND VGND VPWR VPWR sky130_fd_sc_hd__fill_8
XFILLER_17_148 VGND VGND VPWR VPWR sky130_fd_sc_hd__fill_1
XFILLER_72_287 VGND VGND VPWR VPWR sky130_fd_sc_hd__fill_1
XTAP_TAPCELL_ROW_0_280 VGND VPWR sky130_fd_sc_hd__tapvpwrvgnd_1
XFILLER_14_811 VGND VGND VPWR VPWR sky130_fd_sc_hd__fill_1
Xclkbuf_leaf_52_clk clkload6/A VGND VGND VPWR VPWR _6238_/CLK sky130_fd_sc_hd__clkbuf_8
XTAP_TAPCELL_ROW_0_291 VGND VPWR sky130_fd_sc_hd__tapvpwrvgnd_1
XFILLER_13_354 VPWR VGND VPWR VGND sky130_ef_sc_hd__decap_40_12
XANTENNA__4556__A1 _4901_/A0 VGND VGND VPWR VPWR sky130_fd_sc_hd__diode_2
XANTENNA__4308__A1 _5040_/A1 VGND VGND VPWR VPWR sky130_fd_sc_hd__diode_2
XFILLER_5_553 VGND VGND VPWR VPWR sky130_fd_sc_hd__fill_4
XTAP_TAPCELL_ROW_56_1140 VGND VPWR sky130_fd_sc_hd__tapvpwrvgnd_1
XFILLER_5_597 VPWR VGND VPWR VGND sky130_ef_sc_hd__decap_40_12
XANTENNA__2965__S1 _2962_/A VGND VGND VPWR VPWR sky130_fd_sc_hd__diode_2
XFILLER_110_613 VPWR VGND VPWR VGND sky130_ef_sc_hd__decap_40_12
XFILLER_96_825 VPWR VGND VPWR VGND sky130_ef_sc_hd__decap_40_12
XANTENNA__4865__S _4867_/S VGND VGND VPWR VPWR sky130_fd_sc_hd__diode_2
XFILLER_95_313 VGND VGND VPWR VPWR sky130_fd_sc_hd__fill_2
XFILLER_1_781 VGND VGND VPWR VPWR sky130_fd_sc_hd__fill_2
XFILLER_110_657 VPWR VGND VPWR VGND sky130_ef_sc_hd__decap_40_12
XFILLER_95_357 VGND VGND VPWR VPWR sky130_fd_sc_hd__fill_1
XFILLER_95_335 VGND VGND VPWR VPWR sky130_fd_sc_hd__fill_1
XANTENNA__3295__A1 _4906_/A0 VGND VGND VPWR VPWR sky130_fd_sc_hd__diode_2
X_3030_ _3743_/A0 hold688/X _3030_/S VGND VGND VPWR VPWR _3030_/X sky130_fd_sc_hd__mux2_1
XANTENNA__4492__A0 _6406_/Q VGND VGND VPWR VPWR sky130_fd_sc_hd__diode_2
XFILLER_49_785 VPWR VGND VPWR VGND sky130_ef_sc_hd__decap_40_12
XFILLER_48_262 VGND VGND VPWR VPWR sky130_fd_sc_hd__fill_2
XANTENNA__3047__A1 _3076_/A1 VGND VGND VPWR VPWR sky130_fd_sc_hd__diode_2
XFILLER_91_552 VGND VGND VPWR VPWR sky130_fd_sc_hd__fill_8
XFILLER_91_585 VPWR VGND VPWR VGND sky130_ef_sc_hd__decap_40_12
XFILLER_17_671 VGND VGND VPWR VPWR sky130_fd_sc_hd__fill_1
XFILLER_23_107 VGND VGND VPWR VPWR sky130_fd_sc_hd__fill_4
X_4981_ hold409/X _4981_/A1 _4984_/S VGND VGND VPWR VPWR _4981_/X sky130_fd_sc_hd__mux2_1
Xclkbuf_leaf_43_clk clkload4/A VGND VGND VPWR VPWR _6438_/CLK sky130_fd_sc_hd__clkbuf_8
XFILLER_51_449 VGND VGND VPWR VPWR sky130_fd_sc_hd__fill_8
X_3932_ _4978_/A1 _3932_/A1 _3938_/S VGND VGND VPWR VPWR _3932_/X sky130_fd_sc_hd__mux2_1
X_3863_ _5210_/A1 _3863_/A1 _3869_/S VGND VGND VPWR VPWR _3863_/X sky130_fd_sc_hd__mux2_1
XANTENNA_clkbuf_leaf_9_clk_A clkbuf_leaf_9_clk/A VGND VGND VPWR VPWR sky130_fd_sc_hd__diode_2
XFILLER_20_825 VPWR VGND VPWR VGND sky130_ef_sc_hd__decap_40_12
X_2814_ _3044_/A _2814_/B VGND VGND VPWR VPWR _2814_/X sky130_fd_sc_hd__or2_1
XANTENNA__4547__A1 _5816_/Q VGND VGND VPWR VPWR sky130_fd_sc_hd__diode_2
X_5602_ _6098_/CLK _5602_/D VGND VGND VPWR VPWR _5602_/Q sky130_fd_sc_hd__dfxtp_1
XANTENNA__4105__S _4237_/S VGND VGND VPWR VPWR sky130_fd_sc_hd__diode_2
XFILLER_118_713 VPWR VGND VPWR VGND sky130_ef_sc_hd__decap_40_12
X_5533_ _6233_/CLK _5533_/D VGND VGND VPWR VPWR _5533_/Q sky130_fd_sc_hd__dfxtp_1
X_3794_ _3794_/A0 _4961_/A0 _3797_/S VGND VGND VPWR VPWR _3794_/X sky130_fd_sc_hd__mux2_1
XFILLER_118_757 VPWR VGND VPWR VGND sky130_ef_sc_hd__decap_40_12
X_2745_ hold425/X _4846_/A0 _2753_/S VGND VGND VPWR VPWR _2745_/X sky130_fd_sc_hd__mux2_1
XFILLER_133_727 VGND VGND VPWR VPWR sky130_fd_sc_hd__fill_1
XFILLER_117_245 VGND VGND VPWR VPWR sky130_fd_sc_hd__fill_1
X_2676_ _2676_/A0 _4906_/A0 _5241_/S VGND VGND VPWR VPWR _2676_/X sky130_fd_sc_hd__mux2_1
X_5464_ clkload7/A _5464_/D VGND VGND VPWR VPWR _5464_/Q sky130_fd_sc_hd__dfxtp_1
X_4415_ _5046_/A1 _4415_/A1 _4416_/S VGND VGND VPWR VPWR _4415_/X sky130_fd_sc_hd__mux2_1
X_5395_ _6421_/CLK _5395_/D VGND VGND VPWR VPWR _5395_/Q sky130_fd_sc_hd__dfxtp_1
XFILLER_99_641 VPWR VGND VPWR VGND sky130_ef_sc_hd__decap_40_12
X_4346_ _4346_/A _5323_/Q _4924_/C VGND VGND VPWR VPWR _4377_/B sky130_fd_sc_hd__or3_4
XFILLER_101_613 VGND VGND VPWR VPWR sky130_fd_sc_hd__fill_2
XFILLER_99_685 VPWR VGND VPWR VGND sky130_ef_sc_hd__decap_40_12
XANTENNA__4775__S _4778_/S VGND VGND VPWR VPWR sky130_fd_sc_hd__diode_2
X_4277_ hold297/X _5040_/A1 _4284_/S VGND VGND VPWR VPWR _4277_/X sky130_fd_sc_hd__mux2_1
XANTENNA__3286__A1 _4445_/A VGND VGND VPWR VPWR sky130_fd_sc_hd__diode_2
XTAP_TAPCELL_ROW_87_1612 VGND VPWR sky130_fd_sc_hd__tapvpwrvgnd_1
XTAP_TAPCELL_ROW_87_1601 VGND VPWR sky130_fd_sc_hd__tapvpwrvgnd_1
X_3228_ _3228_/A _3228_/B VGND VGND VPWR VPWR _3229_/D sky130_fd_sc_hd__xnor2_1
X_6016_ _6347_/CLK _6016_/D VGND VGND VPWR VPWR _6016_/Q sky130_fd_sc_hd__dfxtp_1
XANTENNA__4347__Y _4356_/S VGND VGND VPWR VPWR sky130_fd_sc_hd__diode_2
XFILLER_82_530 VGND VGND VPWR VPWR sky130_fd_sc_hd__fill_2
X_3159_ _3162_/A _3161_/B _5034_/B VGND VGND VPWR VPWR _5338_/D sky130_fd_sc_hd__o21a_1
Xclkbuf_leaf_34_clk clkload4/A VGND VGND VPWR VPWR _6148_/CLK sky130_fd_sc_hd__clkbuf_8
XTAP_TAPCELL_ROW_25_669 VGND VPWR sky130_fd_sc_hd__tapvpwrvgnd_1
XANTENNA__4538__A1 _5228_/A0 VGND VGND VPWR VPWR sky130_fd_sc_hd__diode_2
XTAP_TAPCELL_ROW_114_2008 VGND VPWR sky130_fd_sc_hd__tapvpwrvgnd_1
XFILLER_108_234 VGND VGND VPWR VPWR sky130_fd_sc_hd__fill_1
XTAP_TAPCELL_ROW_98_1774 VGND VPWR sky130_fd_sc_hd__tapvpwrvgnd_1
XTAP_TAPCELL_ROW_98_1763 VGND VPWR sky130_fd_sc_hd__tapvpwrvgnd_1
XFILLER_136_587 VGND VGND VPWR VPWR sky130_fd_sc_hd__fill_1
XFILLER_124_749 VGND VGND VPWR VPWR sky130_fd_sc_hd__fill_4
XFILLER_2_501 VPWR VGND VPWR VGND sky130_ef_sc_hd__decap_40_12
Xhold380 _4529_/X VGND VGND VPWR VPWR _6131_/D sky130_fd_sc_hd__dlygate4sd3_1
XFILLER_7_3 VPWR VGND VPWR VGND sky130_ef_sc_hd__decap_40_12
XFILLER_2_545 VPWR VGND VPWR VGND sky130_ef_sc_hd__decap_40_12
XFILLER_132_793 VPWR VGND VPWR VGND sky130_ef_sc_hd__decap_40_12
Xhold391 _5529_/Q VGND VGND VPWR VPWR hold391/X sky130_fd_sc_hd__dlygate4sd3_1
XFILLER_89_173 VGND VGND VPWR VPWR sky130_fd_sc_hd__fill_2
XFILLER_78_825 VPWR VGND VPWR VGND sky130_ef_sc_hd__decap_40_12
XFILLER_77_55 VGND VGND VPWR VPWR sky130_fd_sc_hd__fill_1
XFILLER_2_589 VPWR VGND VPWR VGND sky130_ef_sc_hd__decap_40_12
XANTENNA_fanout87_X _5210_/A1 VGND VGND VPWR VPWR sky130_fd_sc_hd__diode_2
XTAP_TAPCELL_ROW_129_2240 VGND VPWR sky130_fd_sc_hd__tapvpwrvgnd_1
XFILLER_77_335 VGND VGND VPWR VPWR sky130_fd_sc_hd__fill_1
XANTENNA__4685__S _4778_/S VGND VGND VPWR VPWR sky130_fd_sc_hd__diode_2
XFILLER_93_839 VGND VGND VPWR VPWR sky130_fd_sc_hd__fill_1
XFILLER_92_305 VGND VGND VPWR VPWR sky130_fd_sc_hd__fill_2
XTAP_TAPCELL_ROW_51_1070 VGND VPWR sky130_fd_sc_hd__tapvpwrvgnd_1
XTAP_TAPCELL_ROW_5_372 VGND VPWR sky130_fd_sc_hd__tapvpwrvgnd_1
XFILLER_18_413 VGND VGND VPWR VPWR sky130_fd_sc_hd__fill_4
Xhold1080 _6264_/Q VGND VGND VPWR VPWR _4927_/A0 sky130_fd_sc_hd__dlygate4sd3_1
XFILLER_18_457 VPWR VGND VPWR VGND sky130_ef_sc_hd__decap_40_12
Xhold1091 _4290_/X VGND VGND VPWR VPWR _5941_/D sky130_fd_sc_hd__dlygate4sd3_1
XFILLER_33_405 VGND VGND VPWR VPWR sky130_fd_sc_hd__fill_2
Xclkbuf_leaf_25_clk clkload3/A VGND VGND VPWR VPWR _6261_/CLK sky130_fd_sc_hd__clkbuf_8
XANTENNA__4777__A1 _4792_/A1 VGND VGND VPWR VPWR sky130_fd_sc_hd__diode_2
XFILLER_45_298 VGND VGND VPWR VPWR sky130_fd_sc_hd__fill_1
XTAP_TAPCELL_ROW_44_967 VGND VPWR sky130_fd_sc_hd__tapvpwrvgnd_1
XTAP_TAPCELL_ROW_44_956 VGND VPWR sky130_fd_sc_hd__tapvpwrvgnd_1
XFILLER_14_641 VGND VGND VPWR VPWR sky130_fd_sc_hd__fill_2
XANTENNA__4529__A1 _5075_/A0 VGND VGND VPWR VPWR sky130_fd_sc_hd__diode_2
XFILLER_9_111 VGND VGND VPWR VPWR sky130_fd_sc_hd__fill_1
XANTENNA__3201__A1 _5232_/A0 VGND VGND VPWR VPWR sky130_fd_sc_hd__diode_2
XANTENNA__3764__S _3766_/S VGND VGND VPWR VPWR sky130_fd_sc_hd__diode_2
XFILLER_115_727 VGND VGND VPWR VPWR sky130_fd_sc_hd__fill_1
XFILLER_5_361 VPWR VGND VPWR VGND sky130_ef_sc_hd__decap_40_12
XFILLER_114_237 VGND VGND VPWR VPWR sky130_fd_sc_hd__fill_1
XANTENNA_hold2051_A _6058_/Q VGND VGND VPWR VPWR sky130_fd_sc_hd__diode_2
X_4200_ _5775_/Q _6033_/Q _5943_/Q _6314_/Q _4257_/S _4241_/A VGND VGND VPWR VPWR
+ _4200_/X sky130_fd_sc_hd__mux4_1
X_5180_ _5180_/A1 _5179_/X _5176_/A VGND VGND VPWR VPWR _5180_/X sky130_fd_sc_hd__o21a_1
XANTENNA__2712__A0 _4980_/A1 VGND VGND VPWR VPWR sky130_fd_sc_hd__diode_2
XFILLER_110_421 VPWR VGND VPWR VGND sky130_ef_sc_hd__decap_40_12
X_4131_ _4272_/S _4130_/X _4124_/Y _5343_/Q VGND VGND VPWR VPWR _4132_/B sky130_fd_sc_hd__o211a_1
XANTENNA__4465__A0 _5817_/Q VGND VGND VPWR VPWR sky130_fd_sc_hd__diode_2
XFILLER_96_699 VGND VGND VPWR VPWR sky130_fd_sc_hd__fill_1
X_4062_ _5947_/Q _6335_/Q _5929_/Q _6318_/Q _4228_/S _4263_/A VGND VGND VPWR VPWR
+ _4063_/B sky130_fd_sc_hd__mux4_1
X_3013_ _5305_/Q _5378_/Q _5366_/Q _6147_/Q _2984_/S _2985_/A VGND VGND VPWR VPWR
+ _3013_/X sky130_fd_sc_hd__mux4_1
XFILLER_83_327 VGND VGND VPWR VPWR sky130_fd_sc_hd__fill_1
XTAP_TAPCELL_ROW_69_1331 VGND VPWR sky130_fd_sc_hd__tapvpwrvgnd_1
XFILLER_49_593 VGND VGND VPWR VPWR sky130_fd_sc_hd__fill_2
XANTENNA__3004__S _3062_/S VGND VGND VPWR VPWR sky130_fd_sc_hd__diode_2
XTAP_TAPCELL_ROW_69_1342 VGND VPWR sky130_fd_sc_hd__tapvpwrvgnd_1
XTAP_TAPCELL_ROW_82_1531 VGND VPWR sky130_fd_sc_hd__tapvpwrvgnd_1
X_4964_ _4964_/A0 _4964_/A1 _4964_/S VGND VGND VPWR VPWR _4964_/X sky130_fd_sc_hd__mux2_1
Xclkbuf_leaf_16_clk clkbuf_leaf_9_clk/A VGND VGND VPWR VPWR _6409_/CLK sky130_fd_sc_hd__clkbuf_8
XFILLER_52_769 VPWR VGND VPWR VGND sky130_ef_sc_hd__decap_40_12
X_3915_ _3915_/A0 _5213_/A1 _3918_/S VGND VGND VPWR VPWR _3915_/X sky130_fd_sc_hd__mux2_1
X_4895_ _5238_/A1 hold938/X _4906_/S VGND VGND VPWR VPWR _4895_/X sky130_fd_sc_hd__mux2_1
XANTENNA__3440__A1 _4883_/A1 VGND VGND VPWR VPWR sky130_fd_sc_hd__diode_2
XTAP_TAPCELL_ROW_22_628 VGND VPWR sky130_fd_sc_hd__tapvpwrvgnd_1
X_3846_ _3846_/A _3852_/B VGND VGND VPWR VPWR _3846_/X sky130_fd_sc_hd__or2_1
X_3777_ _3777_/A _5383_/Q _5384_/Q VGND VGND VPWR VPWR _4513_/B sky130_fd_sc_hd__or3b_4
XFILLER_20_699 VGND VGND VPWR VPWR sky130_fd_sc_hd__fill_1
X_5516_ _6438_/CLK _5516_/D VGND VGND VPWR VPWR _5516_/Q sky130_fd_sc_hd__dfxtp_1
X_2728_ _5222_/A _2728_/B _2732_/C VGND VGND VPWR VPWR _5267_/D sky130_fd_sc_hd__nor3_1
XFILLER_118_587 VGND VGND VPWR VPWR sky130_fd_sc_hd__fill_1
XFILLER_106_749 VGND VGND VPWR VPWR sky130_fd_sc_hd__fill_4
X_5447_ _5784_/CLK _5447_/D VGND VGND VPWR VPWR _5447_/Q sky130_fd_sc_hd__dfxtp_1
XFILLER_133_557 VGND VGND VPWR VPWR sky130_fd_sc_hd__fill_2
X_2659_ _3083_/S _2645_/A _3207_/B _3030_/S VGND VGND VPWR VPWR _2722_/A sky130_fd_sc_hd__a22o_1
XANTENNA__4153__C1 _4271_/S1 VGND VGND VPWR VPWR sky130_fd_sc_hd__diode_2
X_5378_ _6366_/CLK _5378_/D VGND VGND VPWR VPWR _5378_/Q sky130_fd_sc_hd__dfxtp_1
XTAP_TAPCELL_ROW_93_1693 VGND VPWR sky130_fd_sc_hd__tapvpwrvgnd_1
Xfanout112 _5238_/A1 VGND VGND VPWR VPWR _4882_/A1 sky130_fd_sc_hd__buf_4
XFILLER_59_313 VPWR VGND VPWR VGND sky130_ef_sc_hd__decap_40_12
Xfanout101 hold2222/X VGND VGND VPWR VPWR _5044_/A1 sky130_fd_sc_hd__clkbuf_4
XFILLER_114_793 VPWR VGND VPWR VGND sky130_ef_sc_hd__decap_40_12
Xfanout123 _5816_/Q VGND VGND VPWR VPWR _4906_/A0 sky130_fd_sc_hd__clkbuf_4
Xfanout134 hold2227/X VGND VGND VPWR VPWR _5075_/A0 sky130_fd_sc_hd__buf_4
XFILLER_59_346 VGND VGND VPWR VPWR sky130_fd_sc_hd__fill_2
XFILLER_59_335 VGND VGND VPWR VPWR sky130_fd_sc_hd__fill_1
Xfanout145 hold2200/X VGND VGND VPWR VPWR _4600_/A sky130_fd_sc_hd__clkbuf_4
X_4329_ _5053_/A1 _4329_/A1 _4335_/S VGND VGND VPWR VPWR _4329_/X sky130_fd_sc_hd__mux2_1
Xfanout156 hold2240/X VGND VGND VPWR VPWR _4260_/S sky130_fd_sc_hd__buf_4
Xfanout178 _3027_/A VGND VGND VPWR VPWR _3076_/A1 sky130_fd_sc_hd__buf_4
Xfanout189 _3086_/S VGND VGND VPWR VPWR _2963_/S sky130_fd_sc_hd__clkbuf_8
Xfanout167 _4257_/S VGND VGND VPWR VPWR _4258_/S sky130_fd_sc_hd__clkbuf_8
XPHY_EDGE_ROW_114_Right_114 VGND VGND VPWR VPWR sky130_fd_sc_hd__decap_3
XFILLER_75_839 VGND VGND VPWR VPWR sky130_fd_sc_hd__fill_1
XANTENNA__4456__B1 _3366_/X VGND VGND VPWR VPWR sky130_fd_sc_hd__diode_2
XTAP_TAPCELL_ROW_2_331 VGND VPWR sky130_fd_sc_hd__tapvpwrvgnd_1
XFILLER_103_31 VGND VGND VPWR VPWR sky130_fd_sc_hd__fill_2
XFILLER_90_809 VGND VGND VPWR VPWR sky130_fd_sc_hd__fill_2
XFILLER_27_221 VGND VGND VPWR VPWR sky130_fd_sc_hd__fill_1
XFILLER_28_755 VGND VGND VPWR VPWR sky130_fd_sc_hd__fill_1
XFILLER_63_13 VGND VGND VPWR VPWR sky130_fd_sc_hd__fill_1
XFILLER_15_405 VPWR VGND VPWR VGND sky130_ef_sc_hd__decap_40_12
XFILLER_63_57 VGND VGND VPWR VPWR sky130_fd_sc_hd__fill_1
XFILLER_43_769 VPWR VGND VPWR VGND sky130_ef_sc_hd__decap_40_12
XFILLER_15_449 VPWR VGND VPWR VGND sky130_ef_sc_hd__decap_40_12
XFILLER_70_566 VGND VGND VPWR VPWR sky130_fd_sc_hd__fill_1
XFILLER_42_257 VGND VGND VPWR VPWR sky130_fd_sc_hd__fill_2
XTAP_TAPCELL_ROW_41_915 VGND VPWR sky130_fd_sc_hd__tapvpwrvgnd_1
XANTENNA__3431__A1 _4887_/A1 VGND VGND VPWR VPWR sky130_fd_sc_hd__diode_2
XFILLER_7_615 VGND VGND VPWR VPWR sky130_fd_sc_hd__fill_1
XFILLER_137_841 VGND VGND VPWR VPWR sky130_fd_sc_hd__fill_1
XANTENNA__4931__A1 _4981_/A1 VGND VGND VPWR VPWR sky130_fd_sc_hd__diode_2
XFILLER_124_513 VPWR VGND VPWR VGND sky130_ef_sc_hd__decap_40_12
XFILLER_3_821 VPWR VGND VPWR VGND sky130_ef_sc_hd__decap_40_12
XFILLER_12_83 VGND VGND VPWR VPWR sky130_fd_sc_hd__fill_1
XFILLER_124_557 VPWR VGND VPWR VGND sky130_ef_sc_hd__decap_40_12
XANTENNA__3042__S0 _2984_/S VGND VGND VPWR VPWR sky130_fd_sc_hd__diode_2
XFILLER_2_353 VGND VGND VPWR VPWR sky130_fd_sc_hd__fill_8
XFILLER_2_386 VGND VGND VPWR VPWR sky130_fd_sc_hd__fill_1
XFILLER_66_817 VGND VGND VPWR VPWR sky130_fd_sc_hd__fill_2
XANTENNA__4447__B1 _4445_/X VGND VGND VPWR VPWR sky130_fd_sc_hd__diode_2
XTAP_TAPCELL_ROW_109_1932 VGND VPWR sky130_fd_sc_hd__tapvpwrvgnd_1
XFILLER_93_669 VGND VGND VPWR VPWR sky130_fd_sc_hd__fill_2
XFILLER_92_157 VGND VGND VPWR VPWR sky130_fd_sc_hd__fill_2
XFILLER_81_809 VPWR VGND VPWR VGND sky130_ef_sc_hd__decap_40_12
XFILLER_58_390 VGND VGND VPWR VPWR sky130_fd_sc_hd__fill_1
XFILLER_92_168 VGND VGND VPWR VPWR sky130_fd_sc_hd__fill_4
XFILLER_19_777 VGND VGND VPWR VPWR sky130_fd_sc_hd__fill_4
XFILLER_37_80 VGND VGND VPWR VPWR sky130_fd_sc_hd__fill_2
XANTENNA__3759__S _3766_/S VGND VGND VPWR VPWR sky130_fd_sc_hd__diode_2
XFILLER_34_769 VPWR VGND VPWR VGND sky130_ef_sc_hd__decap_40_12
XTAP_TAPCELL_ROW_64_1261 VGND VPWR sky130_fd_sc_hd__tapvpwrvgnd_1
XFILLER_33_268 VGND VGND VPWR VPWR sky130_fd_sc_hd__fill_1
XFILLER_33_279 VGND VGND VPWR VPWR sky130_fd_sc_hd__fill_1
XANTENNA__3422__A1 _5215_/A1 VGND VGND VPWR VPWR sky130_fd_sc_hd__diode_2
X_3700_ _5209_/A1 _3700_/A1 _3707_/S VGND VGND VPWR VPWR _3700_/X sky130_fd_sc_hd__mux2_1
X_4680_ _4789_/A _4680_/B VGND VGND VPWR VPWR _4680_/X sky130_fd_sc_hd__or2_1
XANTENNA__3494__S _3503_/S VGND VGND VPWR VPWR sky130_fd_sc_hd__diode_2
XFILLER_128_841 VGND VGND VPWR VPWR sky130_fd_sc_hd__fill_1
X_3631_ hold538/X _4958_/A0 _3637_/S VGND VGND VPWR VPWR _3631_/X sky130_fd_sc_hd__mux2_1
X_6350_ _6405_/CLK _6350_/D VGND VGND VPWR VPWR _6350_/Q sky130_fd_sc_hd__dfxtp_1
X_3562_ _4521_/A1 _3562_/A1 _3562_/S VGND VGND VPWR VPWR _5601_/D sky130_fd_sc_hd__mux2_1
X_5301_ _6366_/CLK _5301_/D VGND VGND VPWR VPWR _5301_/Q sky130_fd_sc_hd__dfxtp_1
XFILLER_6_681 VPWR VGND VPWR VGND sky130_ef_sc_hd__decap_40_12
X_3493_ _5239_/A1 _3493_/A1 _3503_/S VGND VGND VPWR VPWR _3493_/X sky130_fd_sc_hd__mux2_1
XFILLER_115_557 VGND VGND VPWR VPWR sky130_fd_sc_hd__fill_2
X_6281_ _6302_/CLK _6281_/D VGND VGND VPWR VPWR _6281_/Q sky130_fd_sc_hd__dfxtp_1
XFILLER_130_527 VGND VGND VPWR VPWR sky130_fd_sc_hd__fill_4
XANTENNA__3489__A1 _4905_/A0 VGND VGND VPWR VPWR sky130_fd_sc_hd__diode_2
X_5232_ _5232_/A0 hold922/X _5237_/S VGND VGND VPWR VPWR _5232_/X sky130_fd_sc_hd__mux2_1
XFILLER_88_419 VGND VGND VPWR VPWR sky130_fd_sc_hd__fill_1
Xclkbuf_leaf_5_clk clkbuf_leaf_9_clk/A VGND VGND VPWR VPWR _6341_/CLK sky130_fd_sc_hd__clkbuf_8
XFILLER_111_741 VPWR VGND VPWR VGND sky130_ef_sc_hd__decap_40_12
X_5163_ _6255_/Q _5840_/Q _5194_/S VGND VGND VPWR VPWR _5163_/X sky130_fd_sc_hd__mux2_1
Xhold1805 _3702_/X VGND VGND VPWR VPWR _5723_/D sky130_fd_sc_hd__dlygate4sd3_1
XFILLER_69_666 VGND VGND VPWR VPWR sky130_fd_sc_hd__fill_4
Xhold1827 _3932_/X VGND VGND VPWR VPWR _5908_/D sky130_fd_sc_hd__dlygate4sd3_1
X_4114_ _5772_/Q _6030_/Q _5940_/Q _6311_/Q _4258_/S _4241_/A VGND VGND VPWR VPWR
+ _4114_/X sky130_fd_sc_hd__mux4_1
Xhold1816 _5909_/Q VGND VGND VPWR VPWR _4105_/A1 sky130_fd_sc_hd__dlygate4sd3_1
Xhold1838 _6361_/Q VGND VGND VPWR VPWR _5070_/A1 sky130_fd_sc_hd__dlygate4sd3_1
XFILLER_111_785 VPWR VGND VPWR VGND sky130_ef_sc_hd__decap_40_12
XFILLER_83_113 VGND VGND VPWR VPWR sky130_fd_sc_hd__fill_1
X_5094_ _6382_/Q _5094_/A1 _5094_/S VGND VGND VPWR VPWR _5094_/X sky130_fd_sc_hd__mux2_1
XANTENNA__4438__B1 _3801_/B VGND VGND VPWR VPWR sky130_fd_sc_hd__diode_2
XFILLER_57_839 VGND VGND VPWR VPWR sky130_fd_sc_hd__fill_1
XFILLER_56_327 VGND VGND VPWR VPWR sky130_fd_sc_hd__fill_1
Xhold1849 _6017_/Q VGND VGND VPWR VPWR _4376_/A1 sky130_fd_sc_hd__dlygate4sd3_1
XANTENNA__4989__A1 _5043_/A1 VGND VGND VPWR VPWR sky130_fd_sc_hd__diode_2
X_4045_ _4044_/X _4038_/X _4260_/S VGND VGND VPWR VPWR _4045_/X sky130_fd_sc_hd__mux2_1
Xi2c_master_axil_216 VGND VGND VPWR VPWR i2c_master_axil_216/HI s_axil_rdata[22] sky130_fd_sc_hd__conb_1
XTAP_TAPCELL_ROW_27_709 VGND VPWR sky130_fd_sc_hd__tapvpwrvgnd_1
Xi2c_master_axil_227 VGND VGND VPWR VPWR i2c_master_axil_227/HI s_axil_rresp[1] sky130_fd_sc_hd__conb_1
XFILLER_25_725 VGND VGND VPWR VPWR sky130_fd_sc_hd__fill_2
XFILLER_12_419 VGND VGND VPWR VPWR sky130_fd_sc_hd__fill_1
XFILLER_24_257 VGND VGND VPWR VPWR sky130_fd_sc_hd__fill_1
X_5996_ clkload9/A _5996_/D VGND VGND VPWR VPWR _5996_/Q sky130_fd_sc_hd__dfxtp_1
X_4947_ _5824_/Q _4947_/A1 _4954_/S VGND VGND VPWR VPWR _4947_/X sky130_fd_sc_hd__mux2_1
XFILLER_33_27 VGND VGND VPWR VPWR sky130_fd_sc_hd__fill_4
XFILLER_33_49 VGND VGND VPWR VPWR sky130_fd_sc_hd__fill_4
X_4878_ hold811/X _4904_/A0 _4880_/S VGND VGND VPWR VPWR _4878_/X sky130_fd_sc_hd__mux2_1
XFILLER_119_841 VGND VGND VPWR VPWR sky130_fd_sc_hd__fill_1
X_3829_ input23/X _5044_/A1 _3835_/S VGND VGND VPWR VPWR _5828_/D sky130_fd_sc_hd__mux2_1
XTAP_TAPCELL_ROW_95_1722 VGND VPWR sky130_fd_sc_hd__tapvpwrvgnd_1
XFILLER_134_811 VGND VGND VPWR VPWR sky130_fd_sc_hd__fill_1
XANTENNA_clkbuf_leaf_81_clk_A clkload1/A VGND VGND VPWR VPWR sky130_fd_sc_hd__diode_2
XFILLER_118_395 VGND VGND VPWR VPWR sky130_fd_sc_hd__fill_2
XFILLER_106_557 VPWR VGND VPWR VGND sky130_ef_sc_hd__decap_40_12
XTAP_TAPCELL_ROW_7_412 VGND VPWR sky130_fd_sc_hd__tapvpwrvgnd_1
XTAP_TAPCELL_ROW_7_401 VGND VPWR sky130_fd_sc_hd__tapvpwrvgnd_1
XFILLER_0_813 VGND VGND VPWR VPWR sky130_fd_sc_hd__fill_2
XFILLER_121_549 VGND VGND VPWR VPWR sky130_fd_sc_hd__fill_8
XANTENNA__4772__S0 _4773_/S VGND VGND VPWR VPWR sky130_fd_sc_hd__diode_2
XANTENNA_clkbuf_leaf_96_clk_A clkbuf_leaf_9_clk/A VGND VGND VPWR VPWR sky130_fd_sc_hd__diode_2
XFILLER_114_41 VGND VGND VPWR VPWR sky130_fd_sc_hd__fill_2
XANTENNA__4429__B1 _4457_/S VGND VGND VPWR VPWR sky130_fd_sc_hd__diode_2
XFILLER_47_316 VGND VGND VPWR VPWR sky130_fd_sc_hd__fill_2
XANTENNA__4816__X _4828_/S VGND VGND VPWR VPWR sky130_fd_sc_hd__diode_2
XFILLER_63_809 VPWR VGND VPWR VGND sky130_ef_sc_hd__decap_40_12
XTAP_TAPCELL_ROW_122_2129 VGND VPWR sky130_fd_sc_hd__tapvpwrvgnd_1
XFILLER_16_725 VPWR VGND VPWR VGND sky130_ef_sc_hd__decap_40_12
XANTENNA__3652__A1 _4517_/A1 VGND VGND VPWR VPWR sky130_fd_sc_hd__diode_2
XFILLER_130_51 VGND VGND VPWR VPWR sky130_fd_sc_hd__fill_1
XTAP_TAPCELL_ROW_104_1862 VGND VPWR sky130_fd_sc_hd__tapvpwrvgnd_1
XFILLER_16_769 VPWR VGND VPWR VGND sky130_ef_sc_hd__decap_40_12
XANTENNA_clkbuf_leaf_34_clk_A clkload4/A VGND VGND VPWR VPWR sky130_fd_sc_hd__diode_2
XFILLER_11_441 VGND VGND VPWR VPWR sky130_fd_sc_hd__fill_4
XTAP_TAPCELL_ROW_137_2361 VGND VPWR sky130_fd_sc_hd__tapvpwrvgnd_1
XTAP_TAPCELL_ROW_137_2350 VGND VPWR sky130_fd_sc_hd__tapvpwrvgnd_1
XANTENNA_clkbuf_leaf_49_clk_A clkload4/A VGND VGND VPWR VPWR sky130_fd_sc_hd__diode_2
XFILLER_99_31 VGND VGND VPWR VPWR sky130_fd_sc_hd__fill_1
XFILLER_7_445 VGND VGND VPWR VPWR sky130_fd_sc_hd__fill_2
XFILLER_11_485 VPWR VGND VPWR VGND sky130_ef_sc_hd__decap_40_12
XFILLER_137_671 VGND VGND VPWR VPWR sky130_fd_sc_hd__fill_1
XANTENNA__2915__B1 _3075_/C1 VGND VGND VPWR VPWR sky130_fd_sc_hd__diode_2
XFILLER_125_833 VGND VGND VPWR VPWR sky130_fd_sc_hd__fill_4
XFILLER_99_53 VGND VGND VPWR VPWR sky130_fd_sc_hd__fill_2
XFILLER_112_505 VPWR VGND VPWR VGND sky130_ef_sc_hd__decap_40_12
XFILLER_3_673 VPWR VGND VPWR VGND sky130_ef_sc_hd__decap_40_12
XANTENNA__4117__C1 _5343_/Q VGND VGND VPWR VPWR sky130_fd_sc_hd__diode_2
XFILLER_124_387 VGND VGND VPWR VPWR sky130_fd_sc_hd__fill_1
XANTENNA_clkbuf_leaf_107_clk_A clkload0/A VGND VGND VPWR VPWR sky130_fd_sc_hd__diode_2
XANTENNA__2694__A2 _3541_/S VGND VGND VPWR VPWR sky130_fd_sc_hd__diode_2
XFILLER_93_422 VGND VGND VPWR VPWR sky130_fd_sc_hd__fill_1
XANTENNA__3891__A1 _4484_/A0 VGND VGND VPWR VPWR sky130_fd_sc_hd__diode_2
XFILLER_38_305 VGND VGND VPWR VPWR sky130_fd_sc_hd__fill_2
XFILLER_39_839 VGND VGND VPWR VPWR sky130_fd_sc_hd__fill_1
XANTENNA__4873__S _4880_/S VGND VGND VPWR VPWR sky130_fd_sc_hd__diode_2
XFILLER_93_433 VGND VGND VPWR VPWR sky130_fd_sc_hd__fill_4
XFILLER_65_146 VGND VGND VPWR VPWR sky130_fd_sc_hd__fill_4
XFILLER_54_809 VGND VGND VPWR VPWR sky130_fd_sc_hd__fill_2
XFILLER_19_541 VPWR VGND VPWR VGND sky130_ef_sc_hd__decap_40_12
XFILLER_80_105 VGND VGND VPWR VPWR sky130_fd_sc_hd__fill_1
XFILLER_53_308 VGND VGND VPWR VPWR sky130_fd_sc_hd__fill_1
XFILLER_0_53 VGND VGND VPWR VPWR sky130_fd_sc_hd__fill_2
XANTENNA__3489__S _3490_/S VGND VGND VPWR VPWR sky130_fd_sc_hd__diode_2
XANTENNA__4840__A0 _4905_/A0 VGND VGND VPWR VPWR sky130_fd_sc_hd__diode_2
XFILLER_19_585 VPWR VGND VPWR VGND sky130_ef_sc_hd__decap_40_12
XANTENNA__3643__A1 _4488_/A0 VGND VGND VPWR VPWR sky130_fd_sc_hd__diode_2
XFILLER_61_363 VGND VGND VPWR VPWR sky130_fd_sc_hd__fill_1
X_5850_ _5850_/CLK _5850_/D VGND VGND VPWR VPWR _5850_/Q sky130_fd_sc_hd__dfxtp_1
XFILLER_0_97 VPWR VGND VPWR VGND sky130_ef_sc_hd__decap_40_12
XFILLER_34_555 VGND VGND VPWR VPWR sky130_fd_sc_hd__fill_1
X_2993_ _5246_/Q _6251_/Q _5411_/Q _5509_/Q _3077_/S _3020_/A VGND VGND VPWR VPWR
+ _2993_/X sky130_fd_sc_hd__mux4_1
X_5781_ _5908_/CLK _5781_/D VGND VGND VPWR VPWR _5781_/Q sky130_fd_sc_hd__dfxtp_1
X_4801_ _6107_/Q _5896_/Q _4801_/S VGND VGND VPWR VPWR _4802_/B sky130_fd_sc_hd__mux2_1
X_4732_ _4789_/A _4732_/B VGND VGND VPWR VPWR _4732_/X sky130_fd_sc_hd__or2_1
X_4663_ _4663_/A _4663_/B VGND VGND VPWR VPWR _4663_/X sky130_fd_sc_hd__and2_1
XTAP_TAPCELL_ROW_32_778 VGND VPWR sky130_fd_sc_hd__tapvpwrvgnd_1
X_3614_ hold289/X _5214_/A1 _3616_/S VGND VGND VPWR VPWR _3614_/X sky130_fd_sc_hd__mux2_1
X_6402_ _6402_/CLK _6402_/D VGND VGND VPWR VPWR _6402_/Q sky130_fd_sc_hd__dfxtp_1
XTAP_TAPCELL_ROW_12_480 VGND VPWR sky130_fd_sc_hd__tapvpwrvgnd_1
XANTENNA__3159__B1 _5034_/B VGND VGND VPWR VPWR sky130_fd_sc_hd__diode_2
XFILLER_116_811 VGND VGND VPWR VPWR sky130_fd_sc_hd__fill_1
Xhold902 _5274_/Q VGND VGND VPWR VPWR hold902/X sky130_fd_sc_hd__dlygate4sd3_1
X_4594_ _5649_/Q _5667_/Q _4810_/S VGND VGND VPWR VPWR _4594_/X sky130_fd_sc_hd__mux2_1
Xhold913 _4985_/X VGND VGND VPWR VPWR _6317_/D sky130_fd_sc_hd__dlygate4sd3_1
XFILLER_128_693 VGND VGND VPWR VPWR sky130_fd_sc_hd__fill_4
XTAP_TAPCELL_ROW_77_1452 VGND VPWR sky130_fd_sc_hd__tapvpwrvgnd_1
X_6333_ _6409_/CLK _6333_/D VGND VGND VPWR VPWR _6333_/Q sky130_fd_sc_hd__dfxtp_1
X_3545_ _3545_/A0 _4515_/A1 _3552_/S VGND VGND VPWR VPWR _3545_/X sky130_fd_sc_hd__mux2_1
Xhold946 _5394_/Q VGND VGND VPWR VPWR hold946/X sky130_fd_sc_hd__dlygate4sd3_1
Xhold924 _5939_/Q VGND VGND VPWR VPWR hold924/X sky130_fd_sc_hd__dlygate4sd3_1
Xhold935 _4984_/X VGND VGND VPWR VPWR _6316_/D sky130_fd_sc_hd__dlygate4sd3_1
X_3476_ _4905_/A0 _3476_/A1 _3477_/S VGND VGND VPWR VPWR _3476_/X sky130_fd_sc_hd__mux2_1
Xhold979 _5599_/Q VGND VGND VPWR VPWR hold979/X sky130_fd_sc_hd__dlygate4sd3_1
XFILLER_0_109 VGND VGND VPWR VPWR sky130_fd_sc_hd__fill_2
X_6264_ _6300_/CLK _6264_/D VGND VGND VPWR VPWR _6264_/Q sky130_fd_sc_hd__dfxtp_1
Xhold968 _5662_/Q VGND VGND VPWR VPWR hold968/X sky130_fd_sc_hd__dlygate4sd3_1
Xhold957 _3636_/X VGND VGND VPWR VPWR _5664_/D sky130_fd_sc_hd__dlygate4sd3_1
XFILLER_103_549 VGND VGND VPWR VPWR sky130_fd_sc_hd__fill_8
XTAP_TAPCELL_ROW_90_1652 VGND VPWR sky130_fd_sc_hd__tapvpwrvgnd_1
X_5215_ _5215_/A0 _5215_/A1 _5215_/S VGND VGND VPWR VPWR _5215_/X sky130_fd_sc_hd__mux2_1
X_6195_ _6239_/CLK _6195_/D VGND VGND VPWR VPWR _6195_/Q sky130_fd_sc_hd__dfxtp_1
Xhold1613 _4906_/X VGND VGND VPWR VPWR _6254_/D sky130_fd_sc_hd__dlygate4sd3_1
XFILLER_97_783 VGND VGND VPWR VPWR sky130_fd_sc_hd__fill_1
X_5146_ _5142_/A _5160_/A _5145_/Y _2682_/A VGND VGND VPWR VPWR _5146_/X sky130_fd_sc_hd__o211a_1
Xhold1602 _5766_/Q VGND VGND VPWR VPWR _4193_/A0 sky130_fd_sc_hd__dlygate4sd3_1
Xhold1624 _3677_/X VGND VGND VPWR VPWR _5700_/D sky130_fd_sc_hd__dlygate4sd3_1
XFILLER_28_27 VGND VGND VPWR VPWR sky130_fd_sc_hd__fill_1
XFILLER_29_305 VGND VGND VPWR VPWR sky130_fd_sc_hd__fill_4
Xhold1635 _5927_/Q VGND VGND VPWR VPWR _4274_/A0 sky130_fd_sc_hd__dlygate4sd3_1
Xhold1646 _6363_/Q VGND VGND VPWR VPWR _5072_/A1 sky130_fd_sc_hd__dlygate4sd3_1
X_5077_ _5233_/A0 _5077_/A1 _5081_/S VGND VGND VPWR VPWR _5077_/X sky130_fd_sc_hd__mux2_1
Xhold1657 _4867_/X VGND VGND VPWR VPWR _6218_/D sky130_fd_sc_hd__dlygate4sd3_1
Xhold1668 _5283_/Q VGND VGND VPWR VPWR _2753_/A0 sky130_fd_sc_hd__dlygate4sd3_1
XFILLER_45_809 VPWR VGND VPWR VGND sky130_ef_sc_hd__decap_40_12
XFILLER_72_606 VGND VGND VPWR VPWR sky130_fd_sc_hd__fill_1
X_4028_ _4264_/A1 _4027_/X _4149_/A VGND VGND VPWR VPWR _4028_/X sky130_fd_sc_hd__o21a_1
Xhold1679 _3351_/X VGND VGND VPWR VPWR _5429_/D sky130_fd_sc_hd__dlygate4sd3_1
XANTENNA__4831__A0 _4883_/A1 VGND VGND VPWR VPWR sky130_fd_sc_hd__diode_2
XFILLER_71_127 VGND VGND VPWR VPWR sky130_fd_sc_hd__fill_2
XANTENNA__3634__A1 _5213_/A1 VGND VGND VPWR VPWR sky130_fd_sc_hd__diode_2
XFILLER_25_555 VGND VGND VPWR VPWR sky130_fd_sc_hd__fill_4
X_5979_ _5988_/CLK _5979_/D VGND VGND VPWR VPWR _5979_/Q sky130_fd_sc_hd__dfxtp_1
XFILLER_21_783 VGND VGND VPWR VPWR sky130_fd_sc_hd__fill_1
XFILLER_138_457 VPWR VGND VPWR VGND sky130_ef_sc_hd__decap_40_12
XTAP_TAPCELL_ROW_119_2080 VGND VPWR sky130_fd_sc_hd__tapvpwrvgnd_1
XFILLER_60_69 VGND VGND VPWR VPWR sky130_fd_sc_hd__fill_2
XANTENNA__4898__A0 _5241_/A1 VGND VGND VPWR VPWR sky130_fd_sc_hd__diode_2
XTAP_TAPCELL_ROW_119_2091 VGND VPWR sky130_fd_sc_hd__tapvpwrvgnd_1
XFILLER_119_671 VGND VGND VPWR VPWR sky130_fd_sc_hd__fill_1
XFILLER_134_641 VGND VGND VPWR VPWR sky130_fd_sc_hd__fill_2
XFILLER_107_833 VGND VGND VPWR VPWR sky130_fd_sc_hd__fill_4
XFILLER_107_3 VPWR VGND VPWR VGND sky130_ef_sc_hd__decap_40_12
XANTENNA__3862__S _3869_/S VGND VGND VPWR VPWR sky130_fd_sc_hd__diode_2
XTAP_TAPCELL_ROW_132_2280 VGND VPWR sky130_fd_sc_hd__tapvpwrvgnd_1
XFILLER_122_825 VPWR VGND VPWR VGND sky130_ef_sc_hd__decap_40_12
XFILLER_106_365 VGND VGND VPWR VPWR sky130_fd_sc_hd__fill_4
XFILLER_79_227 VPWR VGND VPWR VGND sky130_ef_sc_hd__decap_40_12
XFILLER_95_709 VPWR VGND VPWR VGND sky130_ef_sc_hd__decap_40_12
XANTENNA__4456__A1_N _5396_/Q VGND VGND VPWR VPWR sky130_fd_sc_hd__diode_2
XFILLER_0_643 VGND VGND VPWR VPWR sky130_fd_sc_hd__fill_1
XFILLER_87_271 VGND VGND VPWR VPWR sky130_fd_sc_hd__fill_1
XFILLER_75_422 VGND VGND VPWR VPWR sky130_fd_sc_hd__fill_2
XFILLER_47_113 VGND VGND VPWR VPWR sky130_fd_sc_hd__fill_4
XFILLER_47_102 VGND VGND VPWR VPWR sky130_fd_sc_hd__fill_2
XANTENNA__5075__A0 _5075_/A0 VGND VGND VPWR VPWR sky130_fd_sc_hd__diode_2
XANTENNA_input27_A s_axil_wdata[9] VGND VGND VPWR VPWR sky130_fd_sc_hd__diode_2
XFILLER_85_55 VGND VGND VPWR VPWR sky130_fd_sc_hd__fill_1
XANTENNA__4822__A0 _4887_/A1 VGND VGND VPWR VPWR sky130_fd_sc_hd__diode_2
XANTENNA__3625__A1 _3926_/A1 VGND VGND VPWR VPWR sky130_fd_sc_hd__diode_2
XTAP_TAPCELL_ROW_48_1020 VGND VPWR sky130_fd_sc_hd__tapvpwrvgnd_1
XFILLER_16_533 VPWR VGND VPWR VGND sky130_ef_sc_hd__decap_40_12
XANTENNA__2941__S _3030_/S VGND VGND VPWR VPWR sky130_fd_sc_hd__diode_2
XTAP_TAPCELL_ROW_61_1220 VGND VPWR sky130_fd_sc_hd__tapvpwrvgnd_1
XFILLER_43_396 VGND VGND VPWR VPWR sky130_fd_sc_hd__fill_1
XFILLER_34_70 VGND VGND VPWR VPWR sky130_fd_sc_hd__fill_4
XFILLER_125_641 VPWR VGND VPWR VGND sky130_ef_sc_hd__decap_40_12
Xhold209 _3691_/X VGND VGND VPWR VPWR _5712_/D sky130_fd_sc_hd__dlygate4sd3_1
XANTENNA__3561__A0 _3926_/A1 VGND VGND VPWR VPWR sky130_fd_sc_hd__diode_2
X_3330_ _3326_/X _3327_/Y _3328_/Y VGND VGND VPWR VPWR _3337_/A sky130_fd_sc_hd__a21o_1
XTAP_TAPCELL_ROW_59_1182 VGND VPWR sky130_fd_sc_hd__tapvpwrvgnd_1
XFILLER_125_685 VPWR VGND VPWR VGND sky130_ef_sc_hd__decap_40_12
XANTENNA__3073__A _3092_/A VGND VGND VPWR VPWR sky130_fd_sc_hd__diode_2
XFILLER_98_569 VPWR VGND VPWR VGND sky130_ef_sc_hd__decap_40_12
X_3261_ _6326_/Q _5396_/Q VGND VGND VPWR VPWR _5094_/S sky130_fd_sc_hd__nand2b_4
X_5000_ _5000_/A _5000_/B VGND VGND VPWR VPWR _5001_/B sky130_fd_sc_hd__nand2_1
X_3192_ _3192_/A0 _5080_/A0 _3193_/S VGND VGND VPWR VPWR _3192_/X sky130_fd_sc_hd__mux2_1
XFILLER_79_783 VGND VGND VPWR VPWR sky130_fd_sc_hd__fill_1
XTAP_TAPCELL_ROW_72_1382 VGND VPWR sky130_fd_sc_hd__tapvpwrvgnd_1
XPHY_EDGE_ROW_0_Left_139 VGND VGND VPWR VPWR sky130_fd_sc_hd__decap_3
XFILLER_22_3 VPWR VGND VPWR VGND sky130_ef_sc_hd__decap_40_12
XFILLER_94_753 VGND VGND VPWR VPWR sky130_fd_sc_hd__fill_2
XFILLER_27_809 VPWR VGND VPWR VGND sky130_ef_sc_hd__decap_40_12
XANTENNA__3801__A _3801_/A VGND VGND VPWR VPWR sky130_fd_sc_hd__diode_2
XANTENNA__3616__A1 _4964_/A0 VGND VGND VPWR VPWR sky130_fd_sc_hd__diode_2
XFILLER_19_360 VPWR VGND VPWR VGND sky130_ef_sc_hd__decap_40_12
XFILLER_19_393 VPWR VGND VPWR VGND sky130_ef_sc_hd__decap_40_12
XTAP_TAPCELL_ROW_37_848 VGND VPWR sky130_fd_sc_hd__tapvpwrvgnd_1
X_5902_ _5902_/CLK _5902_/D VGND VGND VPWR VPWR _5902_/Q sky130_fd_sc_hd__dfxtp_1
XFILLER_34_352 VGND VGND VPWR VPWR sky130_fd_sc_hd__fill_1
XTAP_TAPCELL_ROW_37_859 VGND VPWR sky130_fd_sc_hd__tapvpwrvgnd_1
X_5833_ _6338_/CLK _5833_/D VGND VGND VPWR VPWR _5833_/Q sky130_fd_sc_hd__dfxtp_1
XTAP_TAPCELL_ROW_17_550 VGND VPWR sky130_fd_sc_hd__tapvpwrvgnd_1
XTAP_TAPCELL_ROW_17_561 VGND VPWR sky130_fd_sc_hd__tapvpwrvgnd_1
XFILLER_34_363 VGND VGND VPWR VPWR sky130_fd_sc_hd__fill_1
XFILLER_14_29 VGND VGND VPWR VPWR sky130_fd_sc_hd__fill_4
XANTENNA__2704__X _4451_/A VGND VGND VPWR VPWR sky130_fd_sc_hd__diode_2
X_2976_ _5520_/Q _5532_/Q _3051_/S VGND VGND VPWR VPWR _2976_/X sky130_fd_sc_hd__mux2_1
X_5764_ _6313_/CLK _5764_/D VGND VGND VPWR VPWR _5764_/Q sky130_fd_sc_hd__dfxtp_1
X_4715_ _4714_/X _4709_/X _4799_/A VGND VGND VPWR VPWR _4715_/X sky130_fd_sc_hd__mux2_1
X_5695_ _5902_/CLK _5695_/D VGND VGND VPWR VPWR _5695_/Q sky130_fd_sc_hd__dfxtp_1
X_4646_ _4676_/A _4646_/B VGND VGND VPWR VPWR _4646_/Y sky130_fd_sc_hd__nor2_1
XFILLER_116_641 VGND VGND VPWR VPWR sky130_fd_sc_hd__fill_2
Xhold721 _3605_/X VGND VGND VPWR VPWR _5638_/D sky130_fd_sc_hd__dlygate4sd3_1
Xhold710 _5647_/Q VGND VGND VPWR VPWR hold710/X sky130_fd_sc_hd__dlygate4sd3_1
XANTENNA__4778__S _4778_/S VGND VGND VPWR VPWR sky130_fd_sc_hd__diode_2
X_4577_ _4663_/A _4577_/B VGND VGND VPWR VPWR _4577_/X sky130_fd_sc_hd__and2_1
Xhold754 _4978_/X VGND VGND VPWR VPWR _6310_/D sky130_fd_sc_hd__dlygate4sd3_1
X_6316_ _6316_/CLK _6316_/D VGND VGND VPWR VPWR _6316_/Q sky130_fd_sc_hd__dfxtp_1
Xhold732 _4982_/X VGND VGND VPWR VPWR _6314_/D sky130_fd_sc_hd__dlygate4sd3_1
Xhold743 _5901_/Q VGND VGND VPWR VPWR hold743/X sky130_fd_sc_hd__dlygate4sd3_1
X_3528_ _5815_/Q _3528_/A1 _3529_/S VGND VGND VPWR VPWR _3528_/X sky130_fd_sc_hd__mux2_1
XFILLER_104_825 VPWR VGND VPWR VGND sky130_ef_sc_hd__decap_40_12
Xhold776 _3552_/X VGND VGND VPWR VPWR _5593_/D sky130_fd_sc_hd__dlygate4sd3_1
Xhold787 _5734_/Q VGND VGND VPWR VPWR hold787/X sky130_fd_sc_hd__dlygate4sd3_1
Xhold765 _5896_/Q VGND VGND VPWR VPWR hold765/X sky130_fd_sc_hd__dlygate4sd3_1
X_6247_ _6248_/CLK _6247_/D VGND VGND VPWR VPWR _6247_/Q sky130_fd_sc_hd__dfxtp_1
X_3459_ hold99/X _4889_/A1 _3463_/S VGND VGND VPWR VPWR _3459_/X sky130_fd_sc_hd__mux2_1
Xhold2111 _5440_/Q VGND VGND VPWR VPWR _3381_/A1 sky130_fd_sc_hd__dlygate4sd3_1
Xhold2100 _5131_/X VGND VGND VPWR VPWR _6390_/D sky130_fd_sc_hd__dlygate4sd3_1
Xhold798 _3725_/X VGND VGND VPWR VPWR _5743_/D sky130_fd_sc_hd__dlygate4sd3_1
XFILLER_39_37 VGND VGND VPWR VPWR sky130_fd_sc_hd__fill_1
XFILLER_130_187 VGND VGND VPWR VPWR sky130_fd_sc_hd__fill_1
X_6178_ _6239_/CLK _6178_/D VGND VGND VPWR VPWR _6178_/Q sky130_fd_sc_hd__dfxtp_1
Xhold2133 _3242_/X VGND VGND VPWR VPWR _5384_/D sky130_fd_sc_hd__dlygate4sd3_1
Xhold2122 _5008_/B VGND VGND VPWR VPWR _5048_/B sky130_fd_sc_hd__dlygate4sd3_1
Xhold2144 _5005_/X VGND VGND VPWR VPWR _6329_/D sky130_fd_sc_hd__dlygate4sd3_1
Xhold1410 _5705_/Q VGND VGND VPWR VPWR _3683_/A1 sky130_fd_sc_hd__dlygate4sd3_1
Xhold2188 _5840_/Q VGND VGND VPWR VPWR _3852_/A sky130_fd_sc_hd__dlygate4sd3_1
X_5129_ _3958_/A _5128_/X _5127_/Y _3940_/B VGND VGND VPWR VPWR _5130_/B sky130_fd_sc_hd__a2bb2o_1
Xhold2166 _6262_/Q VGND VGND VPWR VPWR _5199_/A1 sky130_fd_sc_hd__dlygate4sd3_1
Xhold2177 _3276_/B VGND VGND VPWR VPWR _3280_/A2 sky130_fd_sc_hd__dlygate4sd3_1
Xhold1432 _4480_/X VGND VGND VPWR VPWR _6087_/D sky130_fd_sc_hd__dlygate4sd3_1
Xhold1421 _5780_/Q VGND VGND VPWR VPWR _3770_/A1 sky130_fd_sc_hd__dlygate4sd3_1
XFILLER_18_809 VGND VGND VPWR VPWR sky130_fd_sc_hd__fill_2
Xhold1443 _5764_/Q VGND VGND VPWR VPWR _4137_/A0 sky130_fd_sc_hd__dlygate4sd3_1
Xhold2155 _2704_/B VGND VGND VPWR VPWR _3160_/B sky130_fd_sc_hd__dlygate4sd3_1
Xhold1476 _3523_/X VGND VGND VPWR VPWR _5566_/D sky130_fd_sc_hd__dlygate4sd3_1
Xhold1465 _6428_/Q VGND VGND VPWR VPWR _5231_/A1 sky130_fd_sc_hd__dlygate4sd3_1
XFILLER_85_797 VPWR VGND VPWR VGND sky130_ef_sc_hd__decap_40_12
XFILLER_85_764 VPWR VGND VPWR VGND sky130_ef_sc_hd__decap_40_12
XFILLER_84_263 VGND VGND VPWR VPWR sky130_fd_sc_hd__fill_1
XFILLER_72_403 VGND VGND VPWR VPWR sky130_fd_sc_hd__fill_4
Xhold2199 _5833_/Q VGND VGND VPWR VPWR _3838_/A0 sky130_fd_sc_hd__dlygate4sd3_1
Xhold1454 _4966_/X VGND VGND VPWR VPWR _6299_/D sky130_fd_sc_hd__dlygate4sd3_1
XFILLER_72_414 VGND VGND VPWR VPWR sky130_fd_sc_hd__fill_4
Xhold1487 _3700_/X VGND VGND VPWR VPWR _5721_/D sky130_fd_sc_hd__dlygate4sd3_1
XFILLER_44_138 VGND VGND VPWR VPWR sky130_fd_sc_hd__fill_2
XFILLER_44_127 VGND VGND VPWR VPWR sky130_fd_sc_hd__fill_2
Xhold1498 _6015_/Q VGND VGND VPWR VPWR _4374_/A1 sky130_fd_sc_hd__dlygate4sd3_1
XFILLER_72_458 VGND VGND VPWR VPWR sky130_fd_sc_hd__fill_1
XANTENNA__4280__A1 _5043_/A1 VGND VGND VPWR VPWR sky130_fd_sc_hd__diode_2
XFILLER_13_503 VGND VGND VPWR VPWR sky130_fd_sc_hd__fill_1
XFILLER_40_300 VGND VGND VPWR VPWR sky130_fd_sc_hd__fill_4
XTAP_TAPCELL_ROW_101_1821 VGND VPWR sky130_fd_sc_hd__tapvpwrvgnd_1
XTAP_TAPCELL_ROW_101_1810 VGND VPWR sky130_fd_sc_hd__tapvpwrvgnd_1
XANTENNA__4032__A1 _4272_/S VGND VGND VPWR VPWR sky130_fd_sc_hd__diode_2
XFILLER_9_529 VPWR VGND VPWR VGND sky130_ef_sc_hd__decap_40_12
XFILLER_138_265 VGND VGND VPWR VPWR sky130_fd_sc_hd__fill_1
XFILLER_107_641 VPWR VGND VPWR VGND sky130_ef_sc_hd__decap_40_12
XANTENNA__5139__A1_N _3958_/A VGND VGND VPWR VPWR sky130_fd_sc_hd__diode_2
XANTENNA__3592__S _3595_/S VGND VGND VPWR VPWR sky130_fd_sc_hd__diode_2
XFILLER_107_685 VPWR VGND VPWR VGND sky130_ef_sc_hd__decap_40_12
XFILLER_136_83 VGND VGND VPWR VPWR sky130_fd_sc_hd__fill_1
XFILLER_122_699 VGND VGND VPWR VPWR sky130_fd_sc_hd__fill_1
XTAP_TAPCELL_ROW_112_1983 VGND VPWR sky130_fd_sc_hd__tapvpwrvgnd_1
XFILLER_48_400 VGND VGND VPWR VPWR sky130_fd_sc_hd__fill_8
XFILLER_0_473 VGND VGND VPWR VPWR sky130_fd_sc_hd__fill_2
XFILLER_48_444 VGND VGND VPWR VPWR sky130_fd_sc_hd__fill_2
Xhold92 hold92/A VGND VGND VPWR VPWR hold92/X sky130_fd_sc_hd__dlygate4sd3_1
Xhold81 hold81/A VGND VGND VPWR VPWR hold81/X sky130_fd_sc_hd__dlygate4sd3_1
XFILLER_75_241 VGND VGND VPWR VPWR sky130_fd_sc_hd__fill_4
XFILLER_48_477 VGND VGND VPWR VPWR sky130_fd_sc_hd__fill_4
Xhold70 hold70/A VGND VGND VPWR VPWR hold70/X sky130_fd_sc_hd__dlygate4sd3_1
XFILLER_75_285 VGND VGND VPWR VPWR sky130_fd_sc_hd__fill_1
XTAP_TAPCELL_ROW_34_807 VGND VPWR sky130_fd_sc_hd__tapvpwrvgnd_1
XFILLER_16_363 VGND VGND VPWR VPWR sky130_fd_sc_hd__fill_1
XFILLER_16_385 VPWR VGND VPWR VGND sky130_ef_sc_hd__decap_40_12
XANTENNA__2671__S _5241_/S VGND VGND VPWR VPWR sky130_fd_sc_hd__diode_2
X_2830_ _3031_/A1 _2829_/X _2828_/X _3089_/C1 VGND VGND VPWR VPWR _2830_/X sky130_fd_sc_hd__o211a_1
XFILLER_31_311 VGND VGND VPWR VPWR sky130_fd_sc_hd__fill_1
XANTENNA__4023__A1 _4264_/A1 VGND VGND VPWR VPWR sky130_fd_sc_hd__diode_2
X_2761_ _3050_/A _2761_/B VGND VGND VPWR VPWR _2761_/X sky130_fd_sc_hd__or2_1
X_2692_ _4868_/A _3438_/A VGND VGND VPWR VPWR _3541_/S sky130_fd_sc_hd__nor2_8
X_5480_ _6238_/CLK _5480_/D VGND VGND VPWR VPWR _5480_/Q sky130_fd_sc_hd__dfxtp_1
X_4500_ hold588/X _5214_/A1 _4502_/S VGND VGND VPWR VPWR _4500_/X sky130_fd_sc_hd__mux2_1
XFILLER_117_449 VGND VGND VPWR VPWR sky130_fd_sc_hd__fill_1
XANTENNA_1 _3027_/B VGND VGND VPWR VPWR sky130_fd_sc_hd__diode_2
X_4431_ _5835_/Q input5/X input4/X VGND VGND VPWR VPWR _4431_/X sky130_fd_sc_hd__and3_1
XFILLER_6_52 VGND VGND VPWR VPWR sky130_fd_sc_hd__fill_2
XTAP_TAPCELL_ROW_74_1411 VGND VPWR sky130_fd_sc_hd__tapvpwrvgnd_1
X_4362_ hold45/X _4980_/A1 _4366_/S VGND VGND VPWR VPWR hold46/A sky130_fd_sc_hd__mux2_1
X_3313_ _5035_/C _3311_/Y _3312_/Y _2649_/Y VGND VGND VPWR VPWR _5099_/C sky130_fd_sc_hd__a22oi_2
X_4293_ hold801/X _4983_/A1 _4294_/S VGND VGND VPWR VPWR _4293_/X sky130_fd_sc_hd__mux2_1
X_6101_ _6414_/CLK _6101_/D VGND VGND VPWR VPWR _6101_/Q sky130_fd_sc_hd__dfxtp_1
XFILLER_101_839 VGND VGND VPWR VPWR sky130_fd_sc_hd__fill_1
XFILLER_86_528 VGND VGND VPWR VPWR sky130_fd_sc_hd__fill_4
X_3244_ _3617_/C _3244_/B _3223_/B VGND VGND VPWR VPWR _3607_/A sky130_fd_sc_hd__or3b_4
X_6032_ _6314_/CLK _6032_/D VGND VGND VPWR VPWR _6032_/Q sky130_fd_sc_hd__dfxtp_1
XFILLER_82_701 VGND VGND VPWR VPWR sky130_fd_sc_hd__fill_1
XFILLER_27_617 VGND VGND VPWR VPWR sky130_fd_sc_hd__fill_1
X_3175_ _3175_/A _3175_/B VGND VGND VPWR VPWR _3177_/A sky130_fd_sc_hd__and2_1
XFILLER_67_797 VGND VGND VPWR VPWR sky130_fd_sc_hd__fill_2
XFILLER_81_244 VGND VGND VPWR VPWR sky130_fd_sc_hd__fill_1
XTAP_TAPCELL_ROW_85_1573 VGND VPWR sky130_fd_sc_hd__tapvpwrvgnd_1
XFILLER_34_160 VGND VGND VPWR VPWR sky130_fd_sc_hd__fill_1
XFILLER_22_311 VGND VGND VPWR VPWR sky130_fd_sc_hd__fill_2
X_5816_ _5841_/CLK _5816_/D VGND VGND VPWR VPWR _5816_/Q sky130_fd_sc_hd__dfxtp_2
XFILLER_50_664 VGND VGND VPWR VPWR sky130_fd_sc_hd__fill_4
XFILLER_22_377 VPWR VGND VPWR VGND sky130_ef_sc_hd__decap_40_12
X_2959_ _3036_/A1 _2958_/X _3096_/A1 VGND VGND VPWR VPWR _2959_/X sky130_fd_sc_hd__o21a_1
X_5747_ _6404_/CLK _5747_/D VGND VGND VPWR VPWR _5747_/Q sky130_fd_sc_hd__dfxtp_1
XFILLER_136_725 VPWR VGND VPWR VGND sky130_ef_sc_hd__decap_40_12
XANTENNA__3773__A0 _5044_/A1 VGND VGND VPWR VPWR sky130_fd_sc_hd__diode_2
XFILLER_136_769 VPWR VGND VPWR VGND sky130_ef_sc_hd__decap_40_12
X_5678_ _5681_/CLK _5678_/D VGND VGND VPWR VPWR _5678_/Q sky130_fd_sc_hd__dfxtp_1
XANTENNA__3525__A0 _4889_/A1 VGND VGND VPWR VPWR sky130_fd_sc_hd__diode_2
X_4629_ _4791_/B1 _4628_/X _4625_/Y _4627_/Y VGND VGND VPWR VPWR _4630_/B sky130_fd_sc_hd__o2bb2a_1
Xhold551 _5360_/Q VGND VGND VPWR VPWR hold551/X sky130_fd_sc_hd__dlygate4sd3_1
Xhold540 _6148_/Q VGND VGND VPWR VPWR hold540/X sky130_fd_sc_hd__dlygate4sd3_1
XFILLER_2_749 VGND VGND VPWR VPWR sky130_fd_sc_hd__fill_4
Xhold562 _6107_/Q VGND VGND VPWR VPWR hold562/X sky130_fd_sc_hd__dlygate4sd3_1
Xhold573 _3452_/X VGND VGND VPWR VPWR _5501_/D sky130_fd_sc_hd__dlygate4sd3_1
Xhold584 _6006_/Q VGND VGND VPWR VPWR hold584/X sky130_fd_sc_hd__dlygate4sd3_1
Xhold595 _4394_/X VGND VGND VPWR VPWR _6033_/D sky130_fd_sc_hd__dlygate4sd3_1
XFILLER_104_699 VGND VGND VPWR VPWR sky130_fd_sc_hd__fill_1
XANTENNA__3828__A1 _5043_/A1 VGND VGND VPWR VPWR sky130_fd_sc_hd__diode_2
XANTENNA__4176__S1 _4178_/A VGND VGND VPWR VPWR sky130_fd_sc_hd__diode_2
Xhold1240 _5519_/Q VGND VGND VPWR VPWR _3472_/A1 sky130_fd_sc_hd__dlygate4sd3_1
Xhold1251 _3148_/X VGND VGND VPWR VPWR _5329_/D sky130_fd_sc_hd__dlygate4sd3_1
Xhold1284 _3494_/X VGND VGND VPWR VPWR _5539_/D sky130_fd_sc_hd__dlygate4sd3_1
XFILLER_122_41 VGND VGND VPWR VPWR sky130_fd_sc_hd__fill_2
Xhold1273 _5753_/Q VGND VGND VPWR VPWR _3739_/A0 sky130_fd_sc_hd__dlygate4sd3_1
Xhold1262 _4837_/X VGND VGND VPWR VPWR _6190_/D sky130_fd_sc_hd__dlygate4sd3_1
XFILLER_73_723 VGND VGND VPWR VPWR sky130_fd_sc_hd__fill_1
XFILLER_72_222 VGND VGND VPWR VPWR sky130_fd_sc_hd__fill_2
XFILLER_72_233 VGND VGND VPWR VPWR sky130_fd_sc_hd__fill_2
Xhold1295 _6332_/Q VGND VGND VPWR VPWR _5034_/A sky130_fd_sc_hd__dlygate4sd3_1
XANTENNA__4971__S _4974_/S VGND VGND VPWR VPWR sky130_fd_sc_hd__diode_2
XTAP_TAPCELL_ROW_0_281 VGND VPWR sky130_fd_sc_hd__tapvpwrvgnd_1
XANTENNA__3587__S _3595_/S VGND VGND VPWR VPWR sky130_fd_sc_hd__diode_2
XTAP_TAPCELL_ROW_0_292 VGND VPWR sky130_fd_sc_hd__tapvpwrvgnd_1
XFILLER_13_366 VPWR VGND VPWR VGND sky130_ef_sc_hd__decap_40_12
XFILLER_127_725 VGND VGND VPWR VPWR sky130_fd_sc_hd__fill_2
XANTENNA__3516__A0 _5237_/A0 VGND VGND VPWR VPWR sky130_fd_sc_hd__diode_2
XPHY_EDGE_ROW_128_Right_128 VGND VGND VPWR VPWR sky130_fd_sc_hd__decap_3
XFILLER_107_482 VGND VGND VPWR VPWR sky130_fd_sc_hd__fill_1
XTAP_TAPCELL_ROW_56_1141 VGND VPWR sky130_fd_sc_hd__tapvpwrvgnd_1
XANTENNA__4211__S _4213_/S VGND VGND VPWR VPWR sky130_fd_sc_hd__diode_2
XFILLER_122_485 VGND VGND VPWR VPWR sky130_fd_sc_hd__fill_1
XFILLER_110_625 VPWR VGND VPWR VGND sky130_ef_sc_hd__decap_40_12
XFILLER_96_837 VGND VGND VPWR VPWR sky130_fd_sc_hd__fill_4
XANTENNA__3819__A1 _2666_/A VGND VGND VPWR VPWR sky130_fd_sc_hd__diode_2
XFILLER_110_669 VPWR VGND VPWR VGND sky130_ef_sc_hd__decap_40_12
XFILLER_83_509 VGND VGND VPWR VPWR sky130_fd_sc_hd__fill_1
XFILLER_76_550 VGND VGND VPWR VPWR sky130_fd_sc_hd__fill_1
XFILLER_63_200 VGND VGND VPWR VPWR sky130_fd_sc_hd__fill_1
XFILLER_49_797 VPWR VGND VPWR VGND sky130_ef_sc_hd__decap_40_12
XFILLER_36_403 VGND VGND VPWR VPWR sky130_fd_sc_hd__fill_1
XPHY_EDGE_ROW_90_Left_229 VGND VGND VPWR VPWR sky130_fd_sc_hd__decap_3
XFILLER_91_597 VPWR VGND VPWR VGND sky130_ef_sc_hd__decap_40_12
XTAP_TAPCELL_ROW_47_998 VGND VPWR sky130_fd_sc_hd__tapvpwrvgnd_1
X_4980_ hold785/X _4980_/A1 _4984_/S VGND VGND VPWR VPWR _4980_/X sky130_fd_sc_hd__mux2_1
XANTENNA__3497__S _3503_/S VGND VGND VPWR VPWR sky130_fd_sc_hd__diode_2
X_3931_ _5040_/A1 _4049_/A1 _3938_/S VGND VGND VPWR VPWR _3931_/X sky130_fd_sc_hd__mux2_1
X_3862_ _4515_/A1 _3862_/A1 _3869_/S VGND VGND VPWR VPWR _5844_/D sky130_fd_sc_hd__mux2_1
XFILLER_31_130 VGND VGND VPWR VPWR sky130_fd_sc_hd__fill_1
XFILLER_32_675 VGND VGND VPWR VPWR sky130_fd_sc_hd__fill_1
X_2813_ _6071_/Q _6363_/Q _3016_/S VGND VGND VPWR VPWR _2814_/B sky130_fd_sc_hd__mux2_1
X_5601_ _6297_/CLK _5601_/D VGND VGND VPWR VPWR _5601_/Q sky130_fd_sc_hd__dfxtp_1
XFILLER_20_837 VGND VGND VPWR VPWR sky130_fd_sc_hd__fill_4
XFILLER_118_725 VPWR VGND VPWR VGND sky130_ef_sc_hd__decap_40_12
X_5532_ _6222_/CLK _5532_/D VGND VGND VPWR VPWR _5532_/Q sky130_fd_sc_hd__dfxtp_1
XANTENNA__3755__A0 _4984_/A1 VGND VGND VPWR VPWR sky130_fd_sc_hd__diode_2
X_3793_ hold301/X _5212_/A1 _3797_/S VGND VGND VPWR VPWR _3793_/X sky130_fd_sc_hd__mux2_1
X_2744_ hold902/X _5228_/A0 _2753_/S VGND VGND VPWR VPWR _2744_/X sky130_fd_sc_hd__mux2_1
X_2675_ hold23/X _4905_/A0 _5241_/S VGND VGND VPWR VPWR hold24/A sky130_fd_sc_hd__mux2_1
XFILLER_118_769 VPWR VGND VPWR VGND sky130_ef_sc_hd__decap_40_12
XANTENNA__3507__A0 _5819_/Q VGND VGND VPWR VPWR sky130_fd_sc_hd__diode_2
X_5463_ _5784_/CLK _5463_/D VGND VGND VPWR VPWR _5463_/Q sky130_fd_sc_hd__dfxtp_1
X_4414_ _5045_/A1 _4414_/A1 _4416_/S VGND VGND VPWR VPWR _4414_/X sky130_fd_sc_hd__mux2_1
X_5394_ _6408_/CLK _5394_/D VGND VGND VPWR VPWR _5394_/Q sky130_fd_sc_hd__dfxtp_1
XFILLER_99_653 VPWR VGND VPWR VGND sky130_ef_sc_hd__decap_40_12
XANTENNA__4180__B1 _4252_/B1 VGND VGND VPWR VPWR sky130_fd_sc_hd__diode_2
X_4345_ hold659/X _5047_/A1 _4345_/S VGND VGND VPWR VPWR _4345_/X sky130_fd_sc_hd__mux2_1
XFILLER_99_697 VPWR VGND VPWR VGND sky130_ef_sc_hd__decap_40_12
XFILLER_87_837 VGND VGND VPWR VPWR sky130_fd_sc_hd__fill_2
X_4276_ hold473/X _5051_/A1 _4284_/S VGND VGND VPWR VPWR _4276_/X sky130_fd_sc_hd__mux2_1
XPHY_EDGE_ROW_129_Left_268 VGND VGND VPWR VPWR sky130_fd_sc_hd__decap_3
XFILLER_101_669 VGND VGND VPWR VPWR sky130_fd_sc_hd__fill_2
XTAP_TAPCELL_ROW_87_1602 VGND VPWR sky130_fd_sc_hd__tapvpwrvgnd_1
XFILLER_86_358 VGND VGND VPWR VPWR sky130_fd_sc_hd__fill_4
XFILLER_67_561 VPWR VGND VPWR VGND sky130_ef_sc_hd__decap_40_12
X_3227_ _4811_/A1 _3236_/A _3221_/X _3223_/X _3226_/X VGND VGND VPWR VPWR _3263_/C
+ sky130_fd_sc_hd__a2111o_1
X_6015_ _6421_/CLK _6015_/D VGND VGND VPWR VPWR _6015_/Q sky130_fd_sc_hd__dfxtp_1
X_3158_ _5427_/Q _5338_/Q VGND VGND VPWR VPWR _3258_/S sky130_fd_sc_hd__nand2b_4
XFILLER_15_609 VGND VGND VPWR VPWR sky130_fd_sc_hd__fill_4
XFILLER_27_447 VGND VGND VPWR VPWR sky130_fd_sc_hd__fill_1
X_3089_ _3029_/A _3086_/X _3087_/X _3088_/X _3089_/C1 VGND VGND VPWR VPWR _3089_/X
+ sky130_fd_sc_hd__o221a_1
XFILLER_42_417 VGND VGND VPWR VPWR sky130_fd_sc_hd__fill_2
XFILLER_11_837 VGND VGND VPWR VPWR sky130_fd_sc_hd__fill_2
XPHY_EDGE_ROW_138_Left_277 VGND VGND VPWR VPWR sky130_fd_sc_hd__decap_3
XFILLER_109_725 VGND VGND VPWR VPWR sky130_fd_sc_hd__fill_2
XANTENNA__4094__S0 _4264_/A1 VGND VGND VPWR VPWR sky130_fd_sc_hd__diode_2
XFILLER_136_533 VPWR VGND VPWR VGND sky130_ef_sc_hd__decap_40_12
XTAP_TAPCELL_ROW_114_2009 VGND VPWR sky130_fd_sc_hd__tapvpwrvgnd_1
XTAP_TAPCELL_ROW_98_1764 VGND VPWR sky130_fd_sc_hd__tapvpwrvgnd_1
XTAP_TAPCELL_ROW_98_1775 VGND VPWR sky130_fd_sc_hd__tapvpwrvgnd_1
XFILLER_2_513 VPWR VGND VPWR VGND sky130_ef_sc_hd__decap_40_12
XFILLER_104_441 VGND VGND VPWR VPWR sky130_fd_sc_hd__fill_2
XFILLER_77_12 VGND VGND VPWR VPWR sky130_fd_sc_hd__fill_1
Xhold381 _5947_/Q VGND VGND VPWR VPWR hold381/X sky130_fd_sc_hd__dlygate4sd3_1
XANTENNA__4966__S _4974_/S VGND VGND VPWR VPWR sky130_fd_sc_hd__diode_2
XFILLER_2_557 VPWR VGND VPWR VGND sky130_ef_sc_hd__decap_40_12
Xhold370 _3626_/X VGND VGND VPWR VPWR _5655_/D sky130_fd_sc_hd__dlygate4sd3_1
Xhold392 _3483_/X VGND VGND VPWR VPWR _5529_/D sky130_fd_sc_hd__dlygate4sd3_1
XFILLER_78_837 VGND VGND VPWR VPWR sky130_fd_sc_hd__fill_4
XFILLER_77_23 VPWR VGND VPWR VGND sky130_ef_sc_hd__decap_40_12
XTAP_TAPCELL_ROW_129_2241 VGND VPWR sky130_fd_sc_hd__tapvpwrvgnd_1
XTAP_TAPCELL_ROW_129_2230 VGND VPWR sky130_fd_sc_hd__tapvpwrvgnd_1
XTAP_TAPCELL_ROW_51_1071 VGND VPWR sky130_fd_sc_hd__tapvpwrvgnd_1
XTAP_TAPCELL_ROW_51_1060 VGND VPWR sky130_fd_sc_hd__tapvpwrvgnd_1
XTAP_TAPCELL_ROW_5_373 VGND VPWR sky130_fd_sc_hd__tapvpwrvgnd_1
XANTENNA__4474__A1 _5208_/A1 VGND VGND VPWR VPWR sky130_fd_sc_hd__diode_2
Xhold1070 _6252_/Q VGND VGND VPWR VPWR _4904_/A1 sky130_fd_sc_hd__dlygate4sd3_1
XFILLER_85_391 VGND VGND VPWR VPWR sky130_fd_sc_hd__fill_1
Xhold1092 _5658_/Q VGND VGND VPWR VPWR _3630_/A0 sky130_fd_sc_hd__dlygate4sd3_1
Xhold1081 _4927_/X VGND VGND VPWR VPWR _6264_/D sky130_fd_sc_hd__dlygate4sd3_1
XFILLER_18_469 VGND VGND VPWR VPWR sky130_fd_sc_hd__fill_4
XFILLER_61_737 VGND VGND VPWR VPWR sky130_fd_sc_hd__fill_2
XTAP_TAPCELL_ROW_44_957 VGND VPWR sky130_fd_sc_hd__tapvpwrvgnd_1
XANTENNA__2788__A1 _3076_/A1 VGND VGND VPWR VPWR sky130_fd_sc_hd__diode_2
XFILLER_13_141 VGND VGND VPWR VPWR sky130_fd_sc_hd__fill_1
XANTENNA__4206__S _4228_/S VGND VGND VPWR VPWR sky130_fd_sc_hd__diode_2
XFILLER_9_123 VPWR VGND VPWR VGND sky130_ef_sc_hd__decap_40_12
XFILLER_14_697 VGND VGND VPWR VPWR sky130_fd_sc_hd__fill_2
XFILLER_6_841 VGND VGND VPWR VPWR sky130_fd_sc_hd__fill_1
XANTENNA__2960__A1 _3094_/C1 VGND VGND VPWR VPWR sky130_fd_sc_hd__diode_2
XANTENNA__3346__A _5034_/B VGND VGND VPWR VPWR sky130_fd_sc_hd__diode_2
XFILLER_5_373 VPWR VGND VPWR VGND sky130_ef_sc_hd__decap_40_12
XANTENNA__4876__S _4880_/S VGND VGND VPWR VPWR sky130_fd_sc_hd__diode_2
XFILLER_123_783 VGND VGND VPWR VPWR sky130_fd_sc_hd__fill_1
XFILLER_96_601 VPWR VGND VPWR VGND sky130_ef_sc_hd__decap_40_12
XFILLER_69_837 VGND VGND VPWR VPWR sky130_fd_sc_hd__fill_2
X_4130_ _4271_/S1 _4129_/X _4126_/Y _4128_/Y VGND VGND VPWR VPWR _4130_/X sky130_fd_sc_hd__o2bb2a_1
XFILLER_110_433 VPWR VGND VPWR VGND sky130_ef_sc_hd__decap_40_12
XFILLER_96_645 VPWR VGND VPWR VGND sky130_ef_sc_hd__decap_40_12
XFILLER_95_122 VGND VGND VPWR VPWR sky130_fd_sc_hd__fill_1
XFILLER_68_325 VGND VGND VPWR VPWR sky130_fd_sc_hd__fill_4
XFILLER_95_166 VGND VGND VPWR VPWR sky130_fd_sc_hd__fill_2
XANTENNA__5111__C1 _5034_/B VGND VGND VPWR VPWR sky130_fd_sc_hd__diode_2
XFILLER_3_97 VGND VGND VPWR VPWR sky130_fd_sc_hd__fill_2
X_4061_ _4260_/S _4053_/X _4060_/Y _5343_/Q VGND VGND VPWR VPWR _4061_/X sky130_fd_sc_hd__a211o_1
X_3012_ _3153_/A1 _3011_/A _2996_/X _3011_/Y VGND VGND VPWR VPWR _3012_/X sky130_fd_sc_hd__a22o_1
XFILLER_49_572 VGND VGND VPWR VPWR sky130_fd_sc_hd__fill_2
XTAP_TAPCELL_ROW_69_1332 VGND VPWR sky130_fd_sc_hd__tapvpwrvgnd_1
XFILLER_64_531 VGND VGND VPWR VPWR sky130_fd_sc_hd__fill_1
XFILLER_91_372 VGND VGND VPWR VPWR sky130_fd_sc_hd__fill_1
XANTENNA__4217__A1 _4260_/S VGND VGND VPWR VPWR sky130_fd_sc_hd__diode_2
XFILLER_24_417 VGND VGND VPWR VPWR sky130_fd_sc_hd__fill_2
XFILLER_36_255 VGND VGND VPWR VPWR sky130_fd_sc_hd__fill_1
XTAP_TAPCELL_ROW_82_1532 VGND VPWR sky130_fd_sc_hd__tapvpwrvgnd_1
X_4963_ _5215_/A1 _4963_/A1 _4964_/S VGND VGND VPWR VPWR _4963_/X sky130_fd_sc_hd__mux2_1
X_3914_ hold833/X _5212_/A1 _3918_/S VGND VGND VPWR VPWR _3914_/X sky130_fd_sc_hd__mux2_1
X_4894_ _4894_/A _5069_/B VGND VGND VPWR VPWR _4906_/S sky130_fd_sc_hd__or2_4
XFILLER_20_601 VPWR VGND VPWR VGND sky130_ef_sc_hd__decap_40_12
XTAP_TAPCELL_ROW_22_629 VGND VPWR sky130_fd_sc_hd__tapvpwrvgnd_1
X_3845_ _2625_/A _3837_/A _4922_/C _3844_/X _5176_/A VGND VGND VPWR VPWR _5836_/D
+ sky130_fd_sc_hd__o311a_1
XFILLER_20_645 VPWR VGND VPWR VGND sky130_ef_sc_hd__decap_40_12
XFILLER_138_29 VPWR VGND VPWR VGND sky130_ef_sc_hd__decap_40_12
XFILLER_118_533 VPWR VGND VPWR VGND sky130_ef_sc_hd__decap_40_12
XANTENNA_fanout127_A _5814_/Q VGND VGND VPWR VPWR sky130_fd_sc_hd__diode_2
X_3776_ _4984_/A1 _3776_/A1 _3776_/S VGND VGND VPWR VPWR _3776_/X sky130_fd_sc_hd__mux2_1
XANTENNA__4640__A _4809_/A VGND VGND VPWR VPWR sky130_fd_sc_hd__diode_2
X_5515_ _6437_/CLK _5515_/D VGND VGND VPWR VPWR _5515_/Q sky130_fd_sc_hd__dfxtp_1
X_2727_ _3029_/A _3030_/S _2727_/C VGND VGND VPWR VPWR _2732_/C sky130_fd_sc_hd__and3_1
XFILLER_133_503 VGND VGND VPWR VPWR sky130_fd_sc_hd__fill_1
X_5446_ clkload7/A _5446_/D VGND VGND VPWR VPWR _5446_/Q sky130_fd_sc_hd__dfxtp_1
XFILLER_121_709 VPWR VGND VPWR VGND sky130_ef_sc_hd__decap_40_12
X_2658_ _3085_/A _2658_/B VGND VGND VPWR VPWR _2658_/X sky130_fd_sc_hd__xor2_1
X_5377_ _6148_/CLK _5377_/D VGND VGND VPWR VPWR _5377_/Q sky130_fd_sc_hd__dfxtp_1
XFILLER_99_461 VGND VGND VPWR VPWR sky130_fd_sc_hd__fill_1
XTAP_TAPCELL_ROW_93_1694 VGND VPWR sky130_fd_sc_hd__tapvpwrvgnd_1
Xfanout113 _5821_/Q VGND VGND VPWR VPWR _5238_/A1 sky130_fd_sc_hd__buf_4
Xfanout102 _4980_/A1 VGND VGND VPWR VPWR _5043_/A1 sky130_fd_sc_hd__clkbuf_4
XANTENNA__3690__S _3698_/S VGND VGND VPWR VPWR sky130_fd_sc_hd__diode_2
Xfanout124 hold2234/X VGND VGND VPWR VPWR _5080_/A0 sky130_fd_sc_hd__buf_4
Xfanout135 _5810_/Q VGND VGND VPWR VPWR _4887_/A1 sky130_fd_sc_hd__buf_4
XFILLER_59_325 VGND VGND VPWR VPWR sky130_fd_sc_hd__fill_8
X_4328_ _5040_/A1 _4328_/A1 _4335_/S VGND VGND VPWR VPWR _5974_/D sky130_fd_sc_hd__mux2_1
Xfanout146 _4803_/S VGND VGND VPWR VPWR _4801_/S sky130_fd_sc_hd__clkbuf_8
Xfanout179 _3027_/A VGND VGND VPWR VPWR _3094_/C1 sky130_fd_sc_hd__buf_4
XFILLER_59_369 VGND VGND VPWR VPWR sky130_fd_sc_hd__fill_2
XANTENNA_input1_A i2c_scl_i VGND VGND VPWR VPWR sky130_fd_sc_hd__diode_2
X_4259_ _4255_/X _4256_/X _4257_/X _4258_/X _2636_/Y _3172_/B VGND VGND VPWR VPWR
+ _4259_/X sky130_fd_sc_hd__mux4_1
Xfanout168 _4221_/S VGND VGND VPWR VPWR _4257_/S sky130_fd_sc_hd__clkbuf_8
Xfanout157 _4205_/A VGND VGND VPWR VPWR _4149_/A sky130_fd_sc_hd__buf_4
XFILLER_101_499 VGND VGND VPWR VPWR sky130_fd_sc_hd__fill_4
XFILLER_101_477 VGND VGND VPWR VPWR sky130_fd_sc_hd__fill_2
XFILLER_74_317 VGND VGND VPWR VPWR sky130_fd_sc_hd__fill_4
XTAP_TAPCELL_ROW_2_332 VGND VPWR sky130_fd_sc_hd__tapvpwrvgnd_1
XTAP_TAPCELL_ROW_124_2160 VGND VPWR sky130_fd_sc_hd__tapvpwrvgnd_1
XFILLER_15_417 VPWR VGND VPWR VGND sky130_ef_sc_hd__decap_40_12
XFILLER_27_277 VGND VGND VPWR VPWR sky130_fd_sc_hd__fill_1
XFILLER_103_87 VGND VGND VPWR VPWR sky130_fd_sc_hd__fill_1
XTAP_TAPCELL_ROW_41_916 VGND VPWR sky130_fd_sc_hd__tapvpwrvgnd_1
XFILLER_129_809 VPWR VGND VPWR VGND sky130_ef_sc_hd__decap_40_12
XFILLER_70_589 VGND VGND VPWR VPWR sky130_fd_sc_hd__fill_2
XFILLER_51_781 VGND VGND VPWR VPWR sky130_fd_sc_hd__fill_2
XFILLER_23_461 VPWR VGND VPWR VGND sky130_ef_sc_hd__decap_40_12
XFILLER_137_3 VPWR VGND VPWR VGND sky130_ef_sc_hd__decap_40_12
XANTENNA__3865__S _3869_/S VGND VGND VPWR VPWR sky130_fd_sc_hd__diode_2
XFILLER_23_494 VGND VGND VPWR VPWR sky130_fd_sc_hd__fill_8
XANTENNA__3195__A1 _5821_/Q VGND VGND VPWR VPWR sky130_fd_sc_hd__diode_2
XANTENNA__4392__A0 _4980_/A1 VGND VGND VPWR VPWR sky130_fd_sc_hd__diode_2
XFILLER_124_525 VGND VGND VPWR VPWR sky130_fd_sc_hd__fill_4
XFILLER_3_833 VGND VGND VPWR VPWR sky130_fd_sc_hd__fill_4
XFILLER_124_569 VPWR VGND VPWR VGND sky130_ef_sc_hd__decap_40_12
XTAP_TAPCELL_ROW_53_1100 VGND VPWR sky130_fd_sc_hd__tapvpwrvgnd_1
XFILLER_2_365 VPWR VGND VPWR VGND sky130_ef_sc_hd__decap_40_12
XFILLER_105_783 VGND VGND VPWR VPWR sky130_fd_sc_hd__fill_1
XFILLER_77_111 VGND VGND VPWR VPWR sky130_fd_sc_hd__fill_1
XFILLER_120_753 VGND VGND VPWR VPWR sky130_fd_sc_hd__fill_2
XANTENNA_clkbuf_leaf_8_clk_A clkbuf_leaf_9_clk/A VGND VGND VPWR VPWR sky130_fd_sc_hd__diode_2
XANTENNA__4447__B2 _4446_/X VGND VGND VPWR VPWR sky130_fd_sc_hd__diode_2
XFILLER_93_615 VGND VGND VPWR VPWR sky130_fd_sc_hd__fill_1
XFILLER_65_317 VGND VGND VPWR VPWR sky130_fd_sc_hd__fill_2
XTAP_TAPCELL_ROW_109_1933 VGND VPWR sky130_fd_sc_hd__tapvpwrvgnd_1
XFILLER_46_542 VGND VGND VPWR VPWR sky130_fd_sc_hd__fill_4
XTAP_TAPCELL_ROW_29_740 VGND VPWR sky130_fd_sc_hd__tapvpwrvgnd_1
XFILLER_73_361 VGND VGND VPWR VPWR sky130_fd_sc_hd__fill_4
XANTENNA_clkbuf_3_7__f_clk_X clkload6/A VGND VGND VPWR VPWR sky130_fd_sc_hd__diode_2
XTAP_TAPCELL_ROW_64_1262 VGND VPWR sky130_fd_sc_hd__tapvpwrvgnd_1
XANTENNA__4460__A _4881_/A VGND VGND VPWR VPWR sky130_fd_sc_hd__diode_2
X_3630_ _3630_/A0 _4515_/A1 _3637_/S VGND VGND VPWR VPWR _3630_/X sky130_fd_sc_hd__mux2_1
XANTENNA__3186__A1 _4886_/A1 VGND VGND VPWR VPWR sky130_fd_sc_hd__diode_2
X_3561_ _3926_/A1 _4733_/A0 _3562_/S VGND VGND VPWR VPWR _5600_/D sky130_fd_sc_hd__mux2_1
X_5300_ _6143_/CLK _5300_/D VGND VGND VPWR VPWR _5300_/Q sky130_fd_sc_hd__dfxtp_1
XFILLER_115_503 VGND VGND VPWR VPWR sky130_fd_sc_hd__fill_1
XFILLER_52_3 VGND VGND VPWR VPWR sky130_fd_sc_hd__fill_1
X_3492_ _5238_/A1 _3492_/A1 _3503_/S VGND VGND VPWR VPWR _3492_/X sky130_fd_sc_hd__mux2_1
XFILLER_6_693 VGND VGND VPWR VPWR sky130_fd_sc_hd__fill_4
X_6280_ _6313_/CLK _6280_/D VGND VGND VPWR VPWR _6280_/Q sky130_fd_sc_hd__dfxtp_1
X_5231_ _5810_/Q _5231_/A1 _5237_/S VGND VGND VPWR VPWR _5231_/X sky130_fd_sc_hd__mux2_1
XFILLER_103_709 VPWR VGND VPWR VGND sky130_ef_sc_hd__decap_40_12
XFILLER_5_192 VGND VGND VPWR VPWR sky130_fd_sc_hd__fill_1
XANTENNA__4230__S0 _4262_/S VGND VGND VPWR VPWR sky130_fd_sc_hd__diode_2
X_5162_ _5162_/A _5162_/B VGND VGND VPWR VPWR _5162_/Y sky130_fd_sc_hd__nand2_1
XFILLER_111_753 VPWR VGND VPWR VGND sky130_ef_sc_hd__decap_40_12
X_5093_ _5093_/A0 _5093_/A1 _5094_/S VGND VGND VPWR VPWR _5093_/X sky130_fd_sc_hd__mux2_1
Xhold1806 _5688_/Q VGND VGND VPWR VPWR _3663_/A1 sky130_fd_sc_hd__dlygate4sd3_1
Xhold1817 _3933_/X VGND VGND VPWR VPWR _5909_/D sky130_fd_sc_hd__dlygate4sd3_1
X_4113_ _4252_/A1 _4112_/X _3172_/B VGND VGND VPWR VPWR _4113_/Y sky130_fd_sc_hd__o21ai_1
Xhold1839 _5070_/X VGND VGND VPWR VPWR _6361_/D sky130_fd_sc_hd__dlygate4sd3_1
Xhold1828 _5568_/Q VGND VGND VPWR VPWR _3525_/A1 sky130_fd_sc_hd__dlygate4sd3_1
XFILLER_111_797 VPWR VGND VPWR VGND sky130_ef_sc_hd__decap_40_12
XANTENNA__4438__A1 _5396_/Q VGND VGND VPWR VPWR sky130_fd_sc_hd__diode_2
XANTENNA__3110__A1 _5235_/A0 VGND VGND VPWR VPWR sky130_fd_sc_hd__diode_2
X_4044_ _4252_/B1 _4043_/X _4040_/Y _4042_/Y VGND VGND VPWR VPWR _4044_/X sky130_fd_sc_hd__o2bb2a_1
Xi2c_master_axil_217 VGND VGND VPWR VPWR i2c_master_axil_217/HI s_axil_rdata[23] sky130_fd_sc_hd__conb_1
XFILLER_80_810 VGND VGND VPWR VPWR sky130_fd_sc_hd__fill_2
XANTENNA__4635__A _4802_/A VGND VGND VPWR VPWR sky130_fd_sc_hd__diode_2
XANTENNA__2707__X _2716_/S VGND VGND VPWR VPWR sky130_fd_sc_hd__diode_2
XFILLER_92_681 VPWR VGND VPWR VGND sky130_ef_sc_hd__decap_40_12
X_5995_ _6345_/CLK _5995_/D VGND VGND VPWR VPWR _5995_/Q sky130_fd_sc_hd__dfxtp_1
X_4946_ _4976_/A1 _4946_/A1 _4954_/S VGND VGND VPWR VPWR _4946_/X sky130_fd_sc_hd__mux2_1
XFILLER_33_781 VGND VGND VPWR VPWR sky130_fd_sc_hd__fill_2
XFILLER_138_617 VGND VGND VPWR VPWR sky130_fd_sc_hd__fill_4
X_4877_ _4877_/A0 _4903_/A0 _4880_/S VGND VGND VPWR VPWR _4877_/X sky130_fd_sc_hd__mux2_1
X_3828_ input22/X _5043_/A1 _3835_/S VGND VGND VPWR VPWR _5827_/D sky130_fd_sc_hd__mux2_1
XFILLER_20_475 VGND VGND VPWR VPWR sky130_fd_sc_hd__fill_1
XANTENNA__4374__A0 _5045_/A1 VGND VGND VPWR VPWR sky130_fd_sc_hd__diode_2
XFILLER_118_363 VGND VGND VPWR VPWR sky130_fd_sc_hd__fill_1
XTAP_TAPCELL_ROW_95_1723 VGND VPWR sky130_fd_sc_hd__tapvpwrvgnd_1
X_3759_ hold403/X _5052_/A1 _3766_/S VGND VGND VPWR VPWR _3759_/X sky130_fd_sc_hd__mux2_1
XFILLER_133_333 VGND VGND VPWR VPWR sky130_fd_sc_hd__fill_1
XFILLER_106_569 VPWR VGND VPWR VGND sky130_ef_sc_hd__decap_40_12
X_5429_ _6408_/CLK _5429_/D VGND VGND VPWR VPWR _5429_/Q sky130_fd_sc_hd__dfxtp_1
XTAP_TAPCELL_ROW_7_402 VGND VPWR sky130_fd_sc_hd__tapvpwrvgnd_1
XFILLER_87_420 VGND VGND VPWR VPWR sky130_fd_sc_hd__fill_4
XFILLER_59_111 VGND VGND VPWR VPWR sky130_fd_sc_hd__fill_1
XFILLER_0_825 VGND VGND VPWR VPWR sky130_fd_sc_hd__fill_4
XANTENNA__2783__S0 _2984_/S VGND VGND VPWR VPWR sky130_fd_sc_hd__diode_2
XFILLER_102_753 VGND VGND VPWR VPWR sky130_fd_sc_hd__fill_2
XANTENNA__4772__S1 _4789_/A VGND VGND VPWR VPWR sky130_fd_sc_hd__diode_2
XANTENNA_input4_X input4/X VGND VGND VPWR VPWR sky130_fd_sc_hd__diode_2
XFILLER_48_807 VGND VGND VPWR VPWR sky130_fd_sc_hd__fill_4
XFILLER_101_263 VPWR VGND VPWR VGND sky130_ef_sc_hd__decap_40_12
XANTENNA__3101__A1 _5238_/A1 VGND VGND VPWR VPWR sky130_fd_sc_hd__diode_2
XFILLER_15_225 VGND VGND VPWR VPWR sky130_fd_sc_hd__fill_1
XFILLER_16_737 VPWR VGND VPWR VGND sky130_ef_sc_hd__decap_40_12
XFILLER_130_41 VGND VGND VPWR VPWR sky130_fd_sc_hd__fill_8
XFILLER_130_85 VGND VGND VPWR VPWR sky130_fd_sc_hd__fill_4
XTAP_TAPCELL_ROW_104_1863 VGND VPWR sky130_fd_sc_hd__tapvpwrvgnd_1
XFILLER_24_781 VPWR VGND VPWR VGND sky130_ef_sc_hd__decap_40_12
XFILLER_31_729 VGND VGND VPWR VPWR sky130_fd_sc_hd__fill_1
XFILLER_129_617 VPWR VGND VPWR VGND sky130_ef_sc_hd__decap_40_12
XANTENNA__3595__S _3595_/S VGND VGND VPWR VPWR sky130_fd_sc_hd__diode_2
XTAP_TAPCELL_ROW_137_2362 VGND VPWR sky130_fd_sc_hd__tapvpwrvgnd_1
XTAP_TAPCELL_ROW_137_2351 VGND VPWR sky130_fd_sc_hd__tapvpwrvgnd_1
XFILLER_11_497 VGND VGND VPWR VPWR sky130_fd_sc_hd__fill_4
XANTENNA__2915__A1 _3031_/A1 VGND VGND VPWR VPWR sky130_fd_sc_hd__diode_2
XFILLER_109_352 VGND VGND VPWR VPWR sky130_fd_sc_hd__fill_4
XFILLER_136_193 VGND VGND VPWR VPWR sky130_fd_sc_hd__fill_1
XFILLER_112_517 VPWR VGND VPWR VGND sky130_ef_sc_hd__decap_40_12
XFILLER_3_641 VPWR VGND VPWR VGND sky130_ef_sc_hd__decap_40_12
XFILLER_3_685 VPWR VGND VPWR VGND sky130_ef_sc_hd__decap_40_12
XANTENNA__4763__S1 _4809_/A VGND VGND VPWR VPWR sky130_fd_sc_hd__diode_2
XFILLER_93_445 VGND VGND VPWR VPWR sky130_fd_sc_hd__fill_2
XFILLER_48_80 VGND VGND VPWR VPWR sky130_fd_sc_hd__fill_4
XANTENNA__2674__S _5241_/S VGND VGND VPWR VPWR sky130_fd_sc_hd__diode_2
XFILLER_93_467 VGND VGND VPWR VPWR sky130_fd_sc_hd__fill_4
XFILLER_62_810 VGND VGND VPWR VPWR sky130_fd_sc_hd__fill_2
XFILLER_19_553 VGND VGND VPWR VPWR sky130_fd_sc_hd__fill_4
XFILLER_19_597 VPWR VGND VPWR VGND sky130_ef_sc_hd__decap_40_12
X_4800_ _4799_/A _4792_/X _4799_/Y _3278_/A VGND VGND VPWR VPWR _4800_/X sky130_fd_sc_hd__a211o_1
X_2992_ _2642_/Y _2991_/X _3027_/A VGND VGND VPWR VPWR _2992_/Y sky130_fd_sc_hd__o21ai_1
X_5780_ _5908_/CLK _5780_/D VGND VGND VPWR VPWR _5780_/Q sky130_fd_sc_hd__dfxtp_1
XFILLER_15_781 VGND VGND VPWR VPWR sky130_fd_sc_hd__fill_2
X_4731_ hold93/X _4962_/A1 _4790_/S VGND VGND VPWR VPWR _4732_/B sky130_fd_sc_hd__mux2_1
X_4662_ _6102_/Q hold27/A _6084_/Q _5882_/Q _4803_/S _4802_/A VGND VGND VPWR VPWR
+ _4663_/B sky130_fd_sc_hd__mux4_1
XTAP_TAPCELL_ROW_32_779 VGND VPWR sky130_fd_sc_hd__tapvpwrvgnd_1
XFILLER_135_609 VGND VGND VPWR VPWR sky130_fd_sc_hd__fill_4
X_3613_ hold147/X _4961_/A0 _3616_/S VGND VGND VPWR VPWR _3613_/X sky130_fd_sc_hd__mux2_1
X_6401_ _6403_/CLK _6401_/D VGND VGND VPWR VPWR _6401_/Q sky130_fd_sc_hd__dfxtp_1
XTAP_TAPCELL_ROW_12_481 VGND VPWR sky130_fd_sc_hd__tapvpwrvgnd_1
Xhold903 _2744_/X VGND VGND VPWR VPWR _5274_/D sky130_fd_sc_hd__dlygate4sd3_1
X_4593_ _4809_/A _4593_/B VGND VGND VPWR VPWR _4593_/X sky130_fd_sc_hd__or2_1
Xhold936 _5524_/Q VGND VGND VPWR VPWR hold936/X sky130_fd_sc_hd__dlygate4sd3_1
XTAP_TAPCELL_ROW_77_1453 VGND VPWR sky130_fd_sc_hd__tapvpwrvgnd_1
X_3544_ hold890/X _4484_/A0 _3552_/S VGND VGND VPWR VPWR _3544_/X sky130_fd_sc_hd__mux2_1
Xhold914 _5257_/Q VGND VGND VPWR VPWR hold914/X sky130_fd_sc_hd__dlygate4sd3_1
X_6332_ _6408_/CLK _6332_/D VGND VGND VPWR VPWR _6332_/Q sky130_fd_sc_hd__dfxtp_1
Xhold925 _4288_/X VGND VGND VPWR VPWR _5939_/D sky130_fd_sc_hd__dlygate4sd3_1
X_3475_ _5814_/Q _3475_/A1 _3477_/S VGND VGND VPWR VPWR _3475_/X sky130_fd_sc_hd__mux2_1
Xhold958 _5492_/Q VGND VGND VPWR VPWR hold958/X sky130_fd_sc_hd__dlygate4sd3_1
XANTENNA__2849__S _3086_/S VGND VGND VPWR VPWR sky130_fd_sc_hd__diode_2
XFILLER_89_729 VPWR VGND VPWR VGND sky130_ef_sc_hd__decap_40_12
Xhold947 _3258_/X VGND VGND VPWR VPWR _5394_/D sky130_fd_sc_hd__dlygate4sd3_1
X_6263_ _6302_/CLK _6263_/D VGND VGND VPWR VPWR _6263_/Q sky130_fd_sc_hd__dfxtp_1
XANTENNA__4108__B1 _4252_/B1 VGND VGND VPWR VPWR sky130_fd_sc_hd__diode_2
Xhold969 _3634_/X VGND VGND VPWR VPWR _5662_/D sky130_fd_sc_hd__dlygate4sd3_1
XFILLER_115_388 VGND VGND VPWR VPWR sky130_fd_sc_hd__fill_1
X_5214_ _5214_/A0 _5214_/A1 _5215_/S VGND VGND VPWR VPWR _5214_/X sky130_fd_sc_hd__mux2_1
X_6194_ _6238_/CLK _6194_/D VGND VGND VPWR VPWR _6194_/Q sky130_fd_sc_hd__dfxtp_1
XTAP_TAPCELL_ROW_90_1653 VGND VPWR sky130_fd_sc_hd__tapvpwrvgnd_1
XFILLER_111_561 VPWR VGND VPWR VGND sky130_ef_sc_hd__decap_40_12
Xhold1625 _6191_/Q VGND VGND VPWR VPWR _4838_/A1 sky130_fd_sc_hd__dlygate4sd3_1
Xhold1614 _5549_/Q VGND VGND VPWR VPWR _3505_/A1 sky130_fd_sc_hd__dlygate4sd3_1
X_5145_ _5145_/A _5145_/B VGND VGND VPWR VPWR _5145_/Y sky130_fd_sc_hd__nand2_1
Xhold1603 _3753_/X VGND VGND VPWR VPWR _5766_/D sky130_fd_sc_hd__dlygate4sd3_1
Xhold1647 _5072_/X VGND VGND VPWR VPWR _6363_/D sky130_fd_sc_hd__dlygate4sd3_1
X_5076_ _5232_/A0 _5076_/A1 _5081_/S VGND VGND VPWR VPWR _5076_/X sky130_fd_sc_hd__mux2_1
Xhold1658 _6205_/Q VGND VGND VPWR VPWR _4853_/A1 sky130_fd_sc_hd__dlygate4sd3_1
Xhold1669 _2753_/X VGND VGND VPWR VPWR _5283_/D sky130_fd_sc_hd__dlygate4sd3_1
XFILLER_57_648 VGND VGND VPWR VPWR sky130_fd_sc_hd__fill_4
Xhold1636 _4274_/X VGND VGND VPWR VPWR _5927_/D sky130_fd_sc_hd__dlygate4sd3_1
X_4027_ _5928_/Q _6317_/Q _4228_/S VGND VGND VPWR VPWR _4027_/X sky130_fd_sc_hd__mux2_1
XFILLER_44_309 VGND VGND VPWR VPWR sky130_fd_sc_hd__fill_2
XFILLER_53_821 VPWR VGND VPWR VGND sky130_ef_sc_hd__decap_40_12
XFILLER_13_729 VPWR VGND VPWR VGND sky130_ef_sc_hd__decap_40_12
X_5978_ clkload7/A _5978_/D VGND VGND VPWR VPWR _5978_/Q sky130_fd_sc_hd__dfxtp_1
XANTENNA__4595__B1 _2628_/A VGND VGND VPWR VPWR sky130_fd_sc_hd__diode_2
X_4929_ hold904/X _4929_/A1 _4934_/S VGND VGND VPWR VPWR _4929_/X sky130_fd_sc_hd__mux2_1
XFILLER_12_239 VGND VGND VPWR VPWR sky130_fd_sc_hd__fill_2
XANTENNA__3398__A1 _5044_/A1 VGND VGND VPWR VPWR sky130_fd_sc_hd__diode_2
XFILLER_138_469 VGND VGND VPWR VPWR sky130_fd_sc_hd__fill_4
XFILLER_138_447 VGND VGND VPWR VPWR sky130_fd_sc_hd__fill_1
XTAP_TAPCELL_ROW_119_2081 VGND VPWR sky130_fd_sc_hd__tapvpwrvgnd_1
XTAP_TAPCELL_ROW_119_2092 VGND VPWR sky130_fd_sc_hd__tapvpwrvgnd_1
XTAP_TAPCELL_ROW_132_2281 VGND VPWR sky130_fd_sc_hd__tapvpwrvgnd_1
XANTENNA__3570__A1 _4488_/A0 VGND VGND VPWR VPWR sky130_fd_sc_hd__diode_2
XFILLER_134_697 VGND VGND VPWR VPWR sky130_fd_sc_hd__fill_2
XFILLER_122_837 VGND VGND VPWR VPWR sky130_fd_sc_hd__fill_4
XFILLER_79_239 VPWR VGND VPWR VGND sky130_ef_sc_hd__decap_40_12
XFILLER_133_196 VGND VGND VPWR VPWR sky130_fd_sc_hd__fill_1
XFILLER_0_699 VGND VGND VPWR VPWR sky130_fd_sc_hd__fill_1
XANTENNA__4974__S _4974_/S VGND VGND VPWR VPWR sky130_fd_sc_hd__diode_2
XANTENNA_fanout62_X _3031_/A1 VGND VGND VPWR VPWR sky130_fd_sc_hd__diode_2
XFILLER_87_294 VGND VGND VPWR VPWR sky130_fd_sc_hd__fill_1
XTAP_TAPCELL_ROW_48_1021 VGND VPWR sky130_fd_sc_hd__tapvpwrvgnd_1
XFILLER_16_501 VPWR VGND VPWR VGND sky130_ef_sc_hd__decap_40_12
XFILLER_18_83 VGND VGND VPWR VPWR sky130_fd_sc_hd__fill_1
XTAP_TAPCELL_ROW_39_890 VGND VPWR sky130_fd_sc_hd__tapvpwrvgnd_1
XFILLER_16_545 VPWR VGND VPWR VGND sky130_ef_sc_hd__decap_40_12
XFILLER_16_589 VPWR VGND VPWR VGND sky130_ef_sc_hd__decap_40_12
XTAP_TAPCELL_ROW_61_1221 VGND VPWR sky130_fd_sc_hd__tapvpwrvgnd_1
XTAP_TAPCELL_ROW_61_1210 VGND VPWR sky130_fd_sc_hd__tapvpwrvgnd_1
XANTENNA__3389__A1 _4983_/A1 VGND VGND VPWR VPWR sky130_fd_sc_hd__diode_2
XANTENNA__4586__B1 _2628_/A VGND VGND VPWR VPWR sky130_fd_sc_hd__diode_2
XFILLER_117_609 VGND VGND VPWR VPWR sky130_fd_sc_hd__fill_4
XFILLER_79_8 VPWR VGND VPWR VGND sky130_ef_sc_hd__decap_40_12
XFILLER_8_755 VGND VGND VPWR VPWR sky130_fd_sc_hd__fill_1
XFILLER_116_119 VGND VGND VPWR VPWR sky130_fd_sc_hd__fill_4
XANTENNA__4889__A1 _4889_/A1 VGND VGND VPWR VPWR sky130_fd_sc_hd__diode_2
XANTENNA__2669__S _5241_/S VGND VGND VPWR VPWR sky130_fd_sc_hd__diode_2
XFILLER_125_653 VPWR VGND VPWR VGND sky130_ef_sc_hd__decap_40_12
XTAP_TAPCELL_ROW_59_1183 VGND VPWR sky130_fd_sc_hd__tapvpwrvgnd_1
XFILLER_125_697 VPWR VGND VPWR VGND sky130_ef_sc_hd__decap_40_12
XFILLER_113_837 VGND VGND VPWR VPWR sky130_fd_sc_hd__fill_2
XANTENNA__3849__C1 _5176_/A VGND VGND VPWR VPWR sky130_fd_sc_hd__diode_2
X_3260_ hold2216/X _4994_/A VGND VGND VPWR VPWR _3265_/B sky130_fd_sc_hd__and2b_1
XANTENNA__3313__A1 _5035_/C VGND VGND VPWR VPWR sky130_fd_sc_hd__diode_2
XANTENNA__4884__S _4893_/S VGND VGND VPWR VPWR sky130_fd_sc_hd__diode_2
X_3191_ hold823/X _5235_/A0 _3193_/S VGND VGND VPWR VPWR _3191_/X sky130_fd_sc_hd__mux2_1
XFILLER_78_261 VGND VGND VPWR VPWR sky130_fd_sc_hd__fill_4
XTAP_TAPCELL_ROW_72_1383 VGND VPWR sky130_fd_sc_hd__tapvpwrvgnd_1
XFILLER_15_3 VPWR VGND VPWR VGND sky130_ef_sc_hd__decap_40_12
XANTENNA__3801__B _3801_/B VGND VGND VPWR VPWR sky130_fd_sc_hd__diode_2
XFILLER_38_169 VGND VGND VPWR VPWR sky130_fd_sc_hd__fill_1
XANTENNA_clkbuf_leaf_80_clk_A clkload1/A VGND VGND VPWR VPWR sky130_fd_sc_hd__diode_2
XFILLER_19_372 VPWR VGND VPWR VGND sky130_ef_sc_hd__decap_40_12
X_5901_ _6122_/CLK _5901_/D VGND VGND VPWR VPWR _5901_/Q sky130_fd_sc_hd__dfxtp_1
XFILLER_35_821 VPWR VGND VPWR VGND sky130_ef_sc_hd__decap_40_12
XTAP_TAPCELL_ROW_37_849 VGND VPWR sky130_fd_sc_hd__tapvpwrvgnd_1
XFILLER_62_640 VGND VGND VPWR VPWR sky130_fd_sc_hd__fill_4
X_5832_ _6342_/CLK _5832_/D VGND VGND VPWR VPWR _5832_/Q sky130_fd_sc_hd__dfxtp_2
XFILLER_50_813 VPWR VGND VPWR VGND sky130_ef_sc_hd__decap_40_12
XTAP_TAPCELL_ROW_17_551 VGND VPWR sky130_fd_sc_hd__tapvpwrvgnd_1
XTAP_TAPCELL_ROW_17_562 VGND VPWR sky130_fd_sc_hd__tapvpwrvgnd_1
XFILLER_61_194 VGND VGND VPWR VPWR sky130_fd_sc_hd__fill_2
X_5763_ _6307_/CLK _5763_/D VGND VGND VPWR VPWR _5763_/Q sky130_fd_sc_hd__dfxtp_1
XFILLER_14_19 VGND VGND VPWR VPWR sky130_fd_sc_hd__fill_1
X_2975_ _3050_/A _2975_/B VGND VGND VPWR VPWR _2975_/X sky130_fd_sc_hd__or2_1
X_4714_ _4710_/X _4711_/X _4712_/X _4713_/X _4791_/A1 _4792_/A1 VGND VGND VPWR VPWR
+ _4714_/X sky130_fd_sc_hd__mux4_1
XANTENNA_clkbuf_leaf_95_clk_A clkbuf_leaf_9_clk/A VGND VGND VPWR VPWR sky130_fd_sc_hd__diode_2
X_5694_ _5898_/CLK _5694_/D VGND VGND VPWR VPWR _5694_/Q sky130_fd_sc_hd__dfxtp_1
XANTENNA__4329__A0 _5053_/A1 VGND VGND VPWR VPWR sky130_fd_sc_hd__diode_2
X_4645_ _4813_/S _4644_/X _4638_/Y _3278_/A VGND VGND VPWR VPWR _4646_/B sky130_fd_sc_hd__o211a_1
XFILLER_128_491 VPWR VGND VPWR VGND sky130_ef_sc_hd__decap_40_12
Xhold700 _6196_/Q VGND VGND VPWR VPWR hold700/X sky130_fd_sc_hd__dlygate4sd3_1
Xhold711 _3616_/X VGND VGND VPWR VPWR _5647_/D sky130_fd_sc_hd__dlygate4sd3_1
X_4576_ _6099_/Q _5888_/Q _6081_/Q _5879_/Q _4801_/S _4802_/A VGND VGND VPWR VPWR
+ _4577_/B sky130_fd_sc_hd__mux4_1
Xhold722 _5514_/Q VGND VGND VPWR VPWR hold722/X sky130_fd_sc_hd__dlygate4sd3_1
X_3527_ _4904_/A0 _3527_/A1 _3529_/S VGND VGND VPWR VPWR _3527_/X sky130_fd_sc_hd__mux2_1
Xhold755 _5379_/Q VGND VGND VPWR VPWR hold755/X sky130_fd_sc_hd__dlygate4sd3_1
XANTENNA__3552__A1 _4964_/A0 VGND VGND VPWR VPWR sky130_fd_sc_hd__diode_2
X_6315_ _6315_/CLK _6315_/D VGND VGND VPWR VPWR _6315_/Q sky130_fd_sc_hd__dfxtp_1
Xhold744 _3924_/X VGND VGND VPWR VPWR _5901_/D sky130_fd_sc_hd__dlygate4sd3_1
Xhold733 _5796_/Q VGND VGND VPWR VPWR hold733/X sky130_fd_sc_hd__dlygate4sd3_1
XFILLER_116_697 VGND VGND VPWR VPWR sky130_fd_sc_hd__fill_2
XFILLER_104_837 VGND VGND VPWR VPWR sky130_fd_sc_hd__fill_4
Xhold788 _3714_/X VGND VGND VPWR VPWR _5734_/D sky130_fd_sc_hd__dlygate4sd3_1
Xhold777 _6113_/Q VGND VGND VPWR VPWR hold777/X sky130_fd_sc_hd__dlygate4sd3_1
Xhold766 _3918_/X VGND VGND VPWR VPWR _5896_/D sky130_fd_sc_hd__dlygate4sd3_1
X_6246_ _6432_/CLK _6246_/D VGND VGND VPWR VPWR _6246_/Q sky130_fd_sc_hd__dfxtp_1
X_3458_ hold323/X _4901_/A0 _3463_/S VGND VGND VPWR VPWR _3458_/X sky130_fd_sc_hd__mux2_1
XANTENNA_clkbuf_leaf_33_clk_A clkload4/A VGND VGND VPWR VPWR sky130_fd_sc_hd__diode_2
XFILLER_89_559 VGND VGND VPWR VPWR sky130_fd_sc_hd__fill_1
XANTENNA__3304__A1 _5233_/A0 VGND VGND VPWR VPWR sky130_fd_sc_hd__diode_2
Xhold2112 _3381_/X VGND VGND VPWR VPWR _5440_/D sky130_fd_sc_hd__dlygate4sd3_1
Xhold2101 _6343_/Q VGND VGND VPWR VPWR _5208_/A0 sky130_fd_sc_hd__dlygate4sd3_1
Xhold799 _5993_/Q VGND VGND VPWR VPWR hold799/X sky130_fd_sc_hd__dlygate4sd3_1
XPHY_EDGE_ROW_110_Left_249 VGND VGND VPWR VPWR sky130_fd_sc_hd__decap_3
Xhold1400 _5237_/X VGND VGND VPWR VPWR _6434_/D sky130_fd_sc_hd__dlygate4sd3_1
X_6177_ _6237_/CLK _6177_/D VGND VGND VPWR VPWR _6177_/Q sky130_fd_sc_hd__dfxtp_1
Xhold2145 _5385_/Q VGND VGND VPWR VPWR _3244_/B sky130_fd_sc_hd__dlygate4sd3_1
Xhold2123 _5048_/X VGND VGND VPWR VPWR _5049_/S sky130_fd_sc_hd__dlygate4sd3_1
X_3389_ hold873/X _4983_/A1 _3390_/S VGND VGND VPWR VPWR _3389_/X sky130_fd_sc_hd__mux2_1
Xhold2134 _5324_/Q VGND VGND VPWR VPWR _3138_/B sky130_fd_sc_hd__dlygate4sd3_1
Xhold1433 _5273_/Q VGND VGND VPWR VPWR _2743_/A0 sky130_fd_sc_hd__dlygate4sd3_1
Xhold1411 _5686_/Q VGND VGND VPWR VPWR _3661_/A1 sky130_fd_sc_hd__dlygate4sd3_1
X_5128_ _5834_/Q _5833_/Q _5194_/S VGND VGND VPWR VPWR _5128_/X sky130_fd_sc_hd__mux2_1
Xhold2178 _5915_/Q VGND VGND VPWR VPWR _5117_/A sky130_fd_sc_hd__dlygate4sd3_1
Xhold2167 _6373_/Q VGND VGND VPWR VPWR _3957_/B sky130_fd_sc_hd__dlygate4sd3_1
Xhold1422 _3770_/X VGND VGND VPWR VPWR _5780_/D sky130_fd_sc_hd__dlygate4sd3_1
Xhold2156 _3160_/Y VGND VGND VPWR VPWR wire60/A sky130_fd_sc_hd__dlygate4sd3_1
Xhold1466 _5231_/X VGND VGND VPWR VPWR _6428_/D sky130_fd_sc_hd__dlygate4sd3_1
Xhold1455 _6423_/Q VGND VGND VPWR VPWR _5226_/A1 sky130_fd_sc_hd__dlygate4sd3_1
Xhold1477 _5548_/Q VGND VGND VPWR VPWR _3503_/A1 sky130_fd_sc_hd__dlygate4sd3_1
XFILLER_85_776 VGND VGND VPWR VPWR sky130_fd_sc_hd__fill_8
Xhold2189 _5837_/Q VGND VGND VPWR VPWR _3846_/A sky130_fd_sc_hd__dlygate4sd3_1
XANTENNA__5057__A1 _5829_/Q VGND VGND VPWR VPWR sky130_fd_sc_hd__diode_2
Xhold1444 _3751_/X VGND VGND VPWR VPWR _5764_/D sky130_fd_sc_hd__dlygate4sd3_1
XANTENNA_clkbuf_leaf_48_clk_A clkload6/A VGND VGND VPWR VPWR sky130_fd_sc_hd__diode_2
Xhold1488 _6201_/Q VGND VGND VPWR VPWR _4849_/A1 sky130_fd_sc_hd__dlygate4sd3_1
X_5059_ hold871/X _5832_/Q _5059_/S VGND VGND VPWR VPWR _5059_/X sky130_fd_sc_hd__mux2_1
Xhold1499 _4374_/X VGND VGND VPWR VPWR _6015_/D sky130_fd_sc_hd__dlygate4sd3_1
XANTENNA__4804__A1 _4811_/A1 VGND VGND VPWR VPWR sky130_fd_sc_hd__diode_2
XFILLER_111_87 VGND VGND VPWR VPWR sky130_fd_sc_hd__fill_1
XTAP_TAPCELL_ROW_101_1822 VGND VPWR sky130_fd_sc_hd__tapvpwrvgnd_1
XTAP_TAPCELL_ROW_101_1811 VGND VPWR sky130_fd_sc_hd__tapvpwrvgnd_1
XFILLER_13_559 VGND VGND VPWR VPWR sky130_fd_sc_hd__fill_1
XANTENNA__4034__S _4237_/S VGND VGND VPWR VPWR sky130_fd_sc_hd__diode_2
XFILLER_40_345 VGND VGND VPWR VPWR sky130_fd_sc_hd__fill_4
XTAP_TAPCELL_ROW_134_2310 VGND VPWR sky130_fd_sc_hd__tapvpwrvgnd_1
XPHY_EDGE_ROW_109_Right_109 VGND VGND VPWR VPWR sky130_fd_sc_hd__decap_3
XANTENNA_clkbuf_leaf_106_clk_A clkload0/A VGND VGND VPWR VPWR sky130_fd_sc_hd__diode_2
XANTENNA__4969__S _4974_/S VGND VGND VPWR VPWR sky130_fd_sc_hd__diode_2
XANTENNA__3791__A1 _5210_/A1 VGND VGND VPWR VPWR sky130_fd_sc_hd__diode_2
XFILLER_5_725 VGND VGND VPWR VPWR sky130_fd_sc_hd__fill_2
XFILLER_107_653 VPWR VGND VPWR VGND sky130_ef_sc_hd__decap_40_12
XFILLER_122_601 VPWR VGND VPWR VGND sky130_ef_sc_hd__decap_40_12
XFILLER_107_697 VPWR VGND VPWR VGND sky130_ef_sc_hd__decap_40_12
XFILLER_122_645 VPWR VGND VPWR VGND sky130_ef_sc_hd__decap_40_12
XFILLER_121_111 VGND VGND VPWR VPWR sky130_fd_sc_hd__fill_1
XFILLER_0_430 VGND VGND VPWR VPWR sky130_fd_sc_hd__fill_4
XFILLER_121_144 VGND VGND VPWR VPWR sky130_fd_sc_hd__fill_1
XTAP_TAPCELL_ROW_112_1984 VGND VPWR sky130_fd_sc_hd__tapvpwrvgnd_1
XTAP_TAPCELL_ROW_112_1973 VGND VPWR sky130_fd_sc_hd__tapvpwrvgnd_1
XFILLER_67_209 VGND VGND VPWR VPWR sky130_fd_sc_hd__fill_4
XFILLER_0_441 VGND VGND VPWR VPWR sky130_fd_sc_hd__fill_4
XFILLER_29_71 VGND VGND VPWR VPWR sky130_fd_sc_hd__fill_1
Xhold71 hold71/A VGND VGND VPWR VPWR hold71/X sky130_fd_sc_hd__dlygate4sd3_1
Xhold60 hold60/A VGND VGND VPWR VPWR hold60/X sky130_fd_sc_hd__dlygate4sd3_1
Xhold82 hold82/A VGND VGND VPWR VPWR hold82/X sky130_fd_sc_hd__dlygate4sd3_1
XANTENNA__3059__B1 _3089_/C1 VGND VGND VPWR VPWR sky130_fd_sc_hd__diode_2
Xhold93 hold93/A VGND VGND VPWR VPWR hold93/X sky130_fd_sc_hd__dlygate4sd3_1
XFILLER_17_821 VPWR VGND VPWR VGND sky130_ef_sc_hd__decap_40_12
XFILLER_29_670 VGND VGND VPWR VPWR sky130_fd_sc_hd__fill_2
XANTENNA__2806__B1 _3085_/A VGND VGND VPWR VPWR sky130_fd_sc_hd__diode_2
XTAP_TAPCELL_ROW_34_808 VGND VPWR sky130_fd_sc_hd__tapvpwrvgnd_1
XANTENNA__4008__C1 _5034_/B VGND VGND VPWR VPWR sky130_fd_sc_hd__diode_2
XFILLER_50_109 VGND VGND VPWR VPWR sky130_fd_sc_hd__fill_1
XFILLER_32_813 VPWR VGND VPWR VGND sky130_ef_sc_hd__decap_40_12
XTAP_TAPCELL_ROW_14_510 VGND VPWR sky130_fd_sc_hd__tapvpwrvgnd_1
XFILLER_16_397 VPWR VGND VPWR VGND sky130_ef_sc_hd__decap_40_12
X_2760_ _5537_/Q _5561_/Q _3051_/S VGND VGND VPWR VPWR _2761_/B sky130_fd_sc_hd__mux2_1
XFILLER_12_581 VGND VGND VPWR VPWR sky130_fd_sc_hd__fill_4
X_2691_ _4548_/A _3113_/B _4548_/C VGND VGND VPWR VPWR _3438_/A sky130_fd_sc_hd__or3_4
XANTENNA__4879__S _4880_/S VGND VGND VPWR VPWR sky130_fd_sc_hd__diode_2
XANTENNA__3782__A1 _5211_/A1 VGND VGND VPWR VPWR sky130_fd_sc_hd__diode_2
XANTENNA_2 _5832_/Q VGND VGND VPWR VPWR sky130_fd_sc_hd__diode_2
X_4430_ _6408_/Q _4427_/B _3801_/B VGND VGND VPWR VPWR _4430_/X sky130_fd_sc_hd__a21o_1
XANTENNA_hold2074_A _6416_/Q VGND VGND VPWR VPWR sky130_fd_sc_hd__diode_2
XFILLER_8_585 VGND VGND VPWR VPWR sky130_fd_sc_hd__fill_2
XANTENNA__2968__S0 _2984_/S VGND VGND VPWR VPWR sky130_fd_sc_hd__diode_2
XANTENNA__3534__A1 _4886_/A1 VGND VGND VPWR VPWR sky130_fd_sc_hd__diode_2
XTAP_TAPCELL_ROW_74_1412 VGND VPWR sky130_fd_sc_hd__tapvpwrvgnd_1
X_6100_ _6418_/CLK _6100_/D VGND VGND VPWR VPWR _6100_/Q sky130_fd_sc_hd__dfxtp_1
X_4361_ hold262/X _5042_/A1 _4366_/S VGND VGND VPWR VPWR _4361_/X sky130_fd_sc_hd__mux2_1
X_3312_ _6385_/Q _3339_/A VGND VGND VPWR VPWR _3312_/Y sky130_fd_sc_hd__nor2_1
X_4292_ _4292_/A0 _4982_/A1 _4294_/S VGND VGND VPWR VPWR _4292_/X sky130_fd_sc_hd__mux2_1
XFILLER_58_209 VGND VGND VPWR VPWR sky130_fd_sc_hd__fill_8
X_3243_ _3777_/A _5384_/Q _3243_/C VGND VGND VPWR VPWR _3707_/S sky130_fd_sc_hd__nand3_4
X_6031_ clkload9/A _6031_/D VGND VGND VPWR VPWR _6031_/Q sky130_fd_sc_hd__dfxtp_1
XANTENNA__5039__A1 _5051_/A1 VGND VGND VPWR VPWR sky130_fd_sc_hd__diode_2
X_3174_ _3175_/B _3174_/B VGND VGND VPWR VPWR _5342_/D sky130_fd_sc_hd__nor2_1
XFILLER_82_724 VGND VGND VPWR VPWR sky130_fd_sc_hd__fill_1
XFILLER_81_212 VGND VGND VPWR VPWR sky130_fd_sc_hd__fill_1
XFILLER_54_426 VGND VGND VPWR VPWR sky130_fd_sc_hd__fill_1
XFILLER_54_404 VGND VGND VPWR VPWR sky130_fd_sc_hd__fill_1
XFILLER_82_757 VGND VGND VPWR VPWR sky130_fd_sc_hd__fill_4
XFILLER_26_139 VGND VGND VPWR VPWR sky130_fd_sc_hd__fill_1
XANTENNA__3470__A0 _4899_/A0 VGND VGND VPWR VPWR sky130_fd_sc_hd__diode_2
XTAP_TAPCELL_ROW_85_1574 VGND VPWR sky130_fd_sc_hd__tapvpwrvgnd_1
X_5815_ _6065_/CLK _5815_/D VGND VGND VPWR VPWR _5815_/Q sky130_fd_sc_hd__dfxtp_4
XFILLER_50_643 VGND VGND VPWR VPWR sky130_fd_sc_hd__fill_1
XFILLER_50_621 VGND VGND VPWR VPWR sky130_fd_sc_hd__fill_2
XANTENNA_fanout157_A _4205_/A VGND VGND VPWR VPWR sky130_fd_sc_hd__diode_2
XANTENNA__5211__A1 _5211_/A1 VGND VGND VPWR VPWR sky130_fd_sc_hd__diode_2
X_2958_ _6190_/Q _5484_/Q _3062_/S VGND VGND VPWR VPWR _2958_/X sky130_fd_sc_hd__mux2_1
XFILLER_10_529 VGND VGND VPWR VPWR sky130_fd_sc_hd__fill_2
X_5746_ _6307_/CLK _5746_/D VGND VGND VPWR VPWR _5746_/Q sky130_fd_sc_hd__dfxtp_1
XFILLER_22_389 VPWR VGND VPWR VGND sky130_ef_sc_hd__decap_40_12
XFILLER_108_417 VGND VGND VPWR VPWR sky130_fd_sc_hd__fill_2
XANTENNA__4970__A0 _4980_/A1 VGND VGND VPWR VPWR sky130_fd_sc_hd__diode_2
X_5677_ _5682_/CLK hold62/X VGND VGND VPWR VPWR hold61/A sky130_fd_sc_hd__dfxtp_1
XFILLER_136_737 VPWR VGND VPWR VGND sky130_ef_sc_hd__decap_40_12
XTAP_TAPCELL_ROW_116_2040 VGND VPWR sky130_fd_sc_hd__tapvpwrvgnd_1
X_2889_ _6235_/Q _6211_/Q _3091_/S VGND VGND VPWR VPWR _2890_/B sky130_fd_sc_hd__mux2_1
XANTENNA_fanout112_X _4882_/A1 VGND VGND VPWR VPWR sky130_fd_sc_hd__diode_2
X_4628_ _5605_/Q _5686_/Q _6092_/Q _5872_/Q _4778_/S _4794_/A VGND VGND VPWR VPWR
+ _4628_/X sky130_fd_sc_hd__mux4_1
XANTENNA__3693__S _3698_/S VGND VGND VPWR VPWR sky130_fd_sc_hd__diode_2
Xhold530 _5969_/Q VGND VGND VPWR VPWR hold530/X sky130_fd_sc_hd__dlygate4sd3_1
Xhold541 _4546_/X VGND VGND VPWR VPWR _6148_/D sky130_fd_sc_hd__dlygate4sd3_1
XFILLER_104_601 VPWR VGND VPWR VGND sky130_ef_sc_hd__decap_40_12
X_4559_ hold696/X _4904_/A0 _4561_/S VGND VGND VPWR VPWR _4559_/X sky130_fd_sc_hd__mux2_1
Xhold552 _5478_/Q VGND VGND VPWR VPWR hold552/X sky130_fd_sc_hd__dlygate4sd3_1
Xhold563 _4502_/X VGND VGND VPWR VPWR _6107_/D sky130_fd_sc_hd__dlygate4sd3_1
Xhold596 _6078_/Q VGND VGND VPWR VPWR hold596/X sky130_fd_sc_hd__dlygate4sd3_1
Xhold574 _6153_/Q VGND VGND VPWR VPWR hold574/X sky130_fd_sc_hd__dlygate4sd3_1
XFILLER_104_645 VPWR VGND VPWR VGND sky130_ef_sc_hd__decap_40_12
Xhold585 _4364_/X VGND VGND VPWR VPWR _6006_/D sky130_fd_sc_hd__dlygate4sd3_1
X_6229_ _6233_/CLK _6229_/D VGND VGND VPWR VPWR _6229_/Q sky130_fd_sc_hd__dfxtp_1
XFILLER_89_367 VGND VGND VPWR VPWR sky130_fd_sc_hd__fill_2
XFILLER_77_529 VGND VGND VPWR VPWR sky130_fd_sc_hd__fill_1
Xhold1241 _3472_/X VGND VGND VPWR VPWR _5519_/D sky130_fd_sc_hd__dlygate4sd3_1
Xhold1230 _6210_/Q VGND VGND VPWR VPWR _4859_/A1 sky130_fd_sc_hd__dlygate4sd3_1
XFILLER_106_98 VGND VGND VPWR VPWR sky130_fd_sc_hd__fill_1
Xhold1252 _6040_/Q VGND VGND VPWR VPWR _4402_/A1 sky130_fd_sc_hd__dlygate4sd3_1
Xhold1274 _3739_/X VGND VGND VPWR VPWR _5753_/D sky130_fd_sc_hd__dlygate4sd3_1
Xhold1285 _6351_/Q VGND VGND VPWR VPWR _5058_/A0 sky130_fd_sc_hd__dlygate4sd3_1
Xhold1263 _6270_/Q VGND VGND VPWR VPWR _4933_/A0 sky130_fd_sc_hd__dlygate4sd3_1
XFILLER_73_757 VPWR VGND VPWR VGND sky130_ef_sc_hd__decap_40_12
Xhold1296 _5034_/X VGND VGND VPWR VPWR _6332_/D sky130_fd_sc_hd__dlygate4sd3_1
XANTENNA__3868__S _3869_/S VGND VGND VPWR VPWR sky130_fd_sc_hd__diode_2
XFILLER_14_813 VPWR VGND VPWR VGND sky130_ef_sc_hd__decap_40_12
XTAP_TAPCELL_ROW_0_282 VGND VPWR sky130_fd_sc_hd__tapvpwrvgnd_1
XTAP_TAPCELL_ROW_0_293 VGND VPWR sky130_fd_sc_hd__tapvpwrvgnd_1
XFILLER_13_312 VGND VGND VPWR VPWR sky130_fd_sc_hd__fill_1
XANTENNA__5202__A1 _5202_/A1 VGND VGND VPWR VPWR sky130_fd_sc_hd__diode_2
XANTENNA__3169__A _3172_/B VGND VGND VPWR VPWR sky130_fd_sc_hd__diode_2
XFILLER_41_654 VGND VGND VPWR VPWR sky130_fd_sc_hd__fill_1
XANTENNA__3213__A0 _4899_/A0 VGND VGND VPWR VPWR sky130_fd_sc_hd__diode_2
XFILLER_13_378 VPWR VGND VPWR VGND sky130_ef_sc_hd__decap_40_12
XANTENNA__4961__A0 _4961_/A0 VGND VGND VPWR VPWR sky130_fd_sc_hd__diode_2
XANTENNA__3764__A1 _4982_/A1 VGND VGND VPWR VPWR sky130_fd_sc_hd__diode_2
XFILLER_31_61 VGND VGND VPWR VPWR sky130_fd_sc_hd__fill_1
XFILLER_135_781 VGND VGND VPWR VPWR sky130_fd_sc_hd__fill_2
Xoutput50 _5438_/Q VGND VGND VPWR VPWR s_axil_rdata[6] sky130_fd_sc_hd__buf_2
XFILLER_96_805 VGND VGND VPWR VPWR sky130_fd_sc_hd__fill_4
XTAP_TAPCELL_ROW_56_1142 VGND VPWR sky130_fd_sc_hd__tapvpwrvgnd_1
XFILLER_122_453 VGND VGND VPWR VPWR sky130_fd_sc_hd__fill_1
XFILLER_95_315 VGND VGND VPWR VPWR sky130_fd_sc_hd__fill_1
XFILLER_122_497 VPWR VGND VPWR VGND sky130_ef_sc_hd__decap_40_12
XFILLER_110_637 VGND VGND VPWR VPWR sky130_fd_sc_hd__fill_4
XFILLER_95_337 VGND VGND VPWR VPWR sky130_fd_sc_hd__fill_1
XANTENNA__3819__A2 _2665_/Y VGND VGND VPWR VPWR sky130_fd_sc_hd__diode_2
XFILLER_49_721 VGND VGND VPWR VPWR sky130_fd_sc_hd__fill_4
XFILLER_0_271 VGND VGND VPWR VPWR sky130_fd_sc_hd__fill_1
XFILLER_1_783 VGND VGND VPWR VPWR sky130_fd_sc_hd__fill_1
XFILLER_0_293 VPWR VGND VPWR VGND sky130_ef_sc_hd__decap_40_12
XFILLER_48_264 VGND VGND VPWR VPWR sky130_fd_sc_hd__fill_1
XFILLER_64_757 VPWR VGND VPWR VGND sky130_ef_sc_hd__decap_40_12
XFILLER_63_223 VGND VGND VPWR VPWR sky130_fd_sc_hd__fill_1
XTAP_TAPCELL_ROW_47_999 VGND VPWR sky130_fd_sc_hd__tapvpwrvgnd_1
X_3930_ _4976_/A1 _3930_/A1 _3938_/S VGND VGND VPWR VPWR _3930_/X sky130_fd_sc_hd__mux2_1
XFILLER_17_673 VPWR VGND VPWR VGND sky130_ef_sc_hd__decap_40_12
X_3861_ _6410_/Q _3861_/A1 _3869_/S VGND VGND VPWR VPWR _3861_/X sky130_fd_sc_hd__mux2_1
XFILLER_20_805 VGND VGND VPWR VPWR sky130_fd_sc_hd__fill_4
X_2812_ hold20/A _5371_/Q _5359_/Q _6140_/Q _2984_/S _2985_/A VGND VGND VPWR VPWR
+ _2812_/X sky130_fd_sc_hd__mux4_1
X_5600_ _6098_/CLK _5600_/D VGND VGND VPWR VPWR _5600_/Q sky130_fd_sc_hd__dfxtp_1
X_3792_ hold69/X _5211_/A1 _3797_/S VGND VGND VPWR VPWR hold70/A sky130_fd_sc_hd__mux2_1
X_5531_ _5571_/CLK _5531_/D VGND VGND VPWR VPWR _5531_/Q sky130_fd_sc_hd__dfxtp_1
X_2743_ _2743_/A0 _5239_/A1 _2753_/S VGND VGND VPWR VPWR _2743_/X sky130_fd_sc_hd__mux2_1
XTAP_TAPCELL_ROW_80_1493 VGND VPWR sky130_fd_sc_hd__tapvpwrvgnd_1
XANTENNA__4952__A0 _5045_/A1 VGND VGND VPWR VPWR sky130_fd_sc_hd__diode_2
XFILLER_118_737 VPWR VGND VPWR VGND sky130_ef_sc_hd__decap_40_12
XANTENNA__3366__X _3366_/X VGND VGND VPWR VPWR sky130_fd_sc_hd__diode_2
XANTENNA__4402__S _4406_/S VGND VGND VPWR VPWR sky130_fd_sc_hd__diode_2
XFILLER_8_360 VGND VGND VPWR VPWR sky130_fd_sc_hd__fill_4
X_2674_ hold367/X _4904_/A0 _5241_/S VGND VGND VPWR VPWR _2674_/X sky130_fd_sc_hd__mux2_1
X_5462_ _5908_/CLK _5462_/D VGND VGND VPWR VPWR _5462_/Q sky130_fd_sc_hd__dfxtp_1
XFILLER_133_729 VPWR VGND VPWR VGND sky130_ef_sc_hd__decap_40_12
XFILLER_126_781 VPWR VGND VPWR VGND sky130_ef_sc_hd__decap_40_12
X_5393_ _6408_/CLK _5393_/D VGND VGND VPWR VPWR _5393_/Q sky130_fd_sc_hd__dfxtp_1
X_4413_ _4981_/A1 _4413_/A1 _4416_/S VGND VGND VPWR VPWR _4413_/X sky130_fd_sc_hd__mux2_1
XANTENNA__4180__A1 _4252_/A1 VGND VGND VPWR VPWR sky130_fd_sc_hd__diode_2
X_4344_ hold859/X _5046_/A1 _4345_/S VGND VGND VPWR VPWR _4344_/X sky130_fd_sc_hd__mux2_1
XANTENNA__2857__S _3072_/S VGND VGND VPWR VPWR sky130_fd_sc_hd__diode_2
XFILLER_101_615 VGND VGND VPWR VPWR sky130_fd_sc_hd__fill_1
XFILLER_99_665 VGND VGND VPWR VPWR sky130_fd_sc_hd__fill_4
XFILLER_59_529 VGND VGND VPWR VPWR sky130_fd_sc_hd__fill_1
XFILLER_98_197 VGND VGND VPWR VPWR sky130_fd_sc_hd__fill_1
XFILLER_98_186 VGND VGND VPWR VPWR sky130_fd_sc_hd__fill_2
X_6014_ clkload9/A _6014_/D VGND VGND VPWR VPWR _6014_/Q sky130_fd_sc_hd__dfxtp_1
X_4275_ _5038_/A _4935_/A VGND VGND VPWR VPWR _4284_/S sky130_fd_sc_hd__nor2_4
XTAP_TAPCELL_ROW_87_1603 VGND VPWR sky130_fd_sc_hd__tapvpwrvgnd_1
XANTENNA__3261__B _5396_/Q VGND VGND VPWR VPWR sky130_fd_sc_hd__diode_2
X_3226_ _4663_/A _3226_/B VGND VGND VPWR VPWR _3226_/X sky130_fd_sc_hd__xor2_1
XFILLER_67_595 VGND VGND VPWR VPWR sky130_fd_sc_hd__fill_8
XFILLER_67_584 VGND VGND VPWR VPWR sky130_fd_sc_hd__fill_2
XFILLER_67_573 VGND VGND VPWR VPWR sky130_fd_sc_hd__fill_2
X_3157_ _5427_/Q _5035_/A VGND VGND VPWR VPWR _3259_/S sky130_fd_sc_hd__and2b_1
XFILLER_82_543 VGND VGND VPWR VPWR sky130_fd_sc_hd__fill_1
XFILLER_54_223 VGND VGND VPWR VPWR sky130_fd_sc_hd__fill_1
X_3088_ _3086_/S _5283_/Q _3029_/A VGND VGND VPWR VPWR _3088_/X sky130_fd_sc_hd__a21bo_1
XFILLER_50_451 VGND VGND VPWR VPWR sky130_fd_sc_hd__fill_1
XFILLER_23_665 VGND VGND VPWR VPWR sky130_fd_sc_hd__fill_4
XANTENNA__4618__S0 _4773_/S VGND VGND VPWR VPWR sky130_fd_sc_hd__diode_2
XFILLER_136_501 VPWR VGND VPWR VGND sky130_ef_sc_hd__decap_40_12
XANTENNA__4094__S1 _4149_/A VGND VGND VPWR VPWR sky130_fd_sc_hd__diode_2
XANTENNA__4943__A0 _4983_/A1 VGND VGND VPWR VPWR sky130_fd_sc_hd__diode_2
XFILLER_7_809 VPWR VGND VPWR VGND sky130_ef_sc_hd__decap_40_12
X_5729_ _5908_/CLK _5729_/D VGND VGND VPWR VPWR _5729_/Q sky130_fd_sc_hd__dfxtp_1
XTAP_TAPCELL_ROW_98_1765 VGND VPWR sky130_fd_sc_hd__tapvpwrvgnd_1
XFILLER_136_545 VPWR VGND VPWR VGND sky130_ef_sc_hd__decap_40_12
XTAP_TAPCELL_ROW_98_1776 VGND VPWR sky130_fd_sc_hd__tapvpwrvgnd_1
Xclkbuf_leaf_111_clk clkload0/A VGND VGND VPWR VPWR _5784_/CLK sky130_fd_sc_hd__clkbuf_8
XFILLER_136_589 VPWR VGND VPWR VGND sky130_ef_sc_hd__decap_40_12
XFILLER_123_206 VGND VGND VPWR VPWR sky130_fd_sc_hd__fill_2
XFILLER_117_781 VGND VGND VPWR VPWR sky130_fd_sc_hd__fill_2
Xhold371 _5669_/Q VGND VGND VPWR VPWR hold371/X sky130_fd_sc_hd__dlygate4sd3_1
XFILLER_2_525 VGND VGND VPWR VPWR sky130_fd_sc_hd__fill_4
Xhold360 _3912_/X VGND VGND VPWR VPWR _5890_/D sky130_fd_sc_hd__dlygate4sd3_1
XFILLER_117_75 VGND VGND VPWR VPWR sky130_fd_sc_hd__fill_4
XFILLER_77_35 VPWR VGND VPWR VGND sky130_ef_sc_hd__decap_40_12
Xhold382 _4297_/X VGND VGND VPWR VPWR _5947_/D sky130_fd_sc_hd__dlygate4sd3_1
XFILLER_2_569 VPWR VGND VPWR VGND sky130_ef_sc_hd__decap_40_12
Xhold393 _5437_/Q VGND VGND VPWR VPWR hold393/X sky130_fd_sc_hd__dlygate4sd3_1
XTAP_TAPCELL_ROW_129_2242 VGND VPWR sky130_fd_sc_hd__tapvpwrvgnd_1
XTAP_TAPCELL_ROW_129_2231 VGND VPWR sky130_fd_sc_hd__tapvpwrvgnd_1
XFILLER_104_475 VGND VGND VPWR VPWR sky130_fd_sc_hd__fill_1
XFILLER_89_175 VGND VGND VPWR VPWR sky130_fd_sc_hd__fill_1
XFILLER_77_57 VGND VGND VPWR VPWR sky130_fd_sc_hd__fill_1
XFILLER_92_307 VGND VGND VPWR VPWR sky130_fd_sc_hd__fill_1
XFILLER_77_359 VGND VGND VPWR VPWR sky130_fd_sc_hd__fill_4
XTAP_TAPCELL_ROW_51_1061 VGND VPWR sky130_fd_sc_hd__tapvpwrvgnd_1
XFILLER_100_681 VPWR VGND VPWR VGND sky130_ef_sc_hd__decap_40_12
Xhold1060 _6225_/Q VGND VGND VPWR VPWR _4875_/A0 sky130_fd_sc_hd__dlygate4sd3_1
XANTENNA__5440__Q _5440_/Q VGND VGND VPWR VPWR sky130_fd_sc_hd__diode_2
XTAP_TAPCELL_ROW_51_1072 VGND VPWR sky130_fd_sc_hd__tapvpwrvgnd_1
XTAP_TAPCELL_ROW_5_374 VGND VPWR sky130_fd_sc_hd__tapvpwrvgnd_1
XANTENNA__4982__S _4984_/S VGND VGND VPWR VPWR sky130_fd_sc_hd__diode_2
XANTENNA__3682__A0 _4958_/A0 VGND VGND VPWR VPWR sky130_fd_sc_hd__diode_2
Xhold1071 _4904_/X VGND VGND VPWR VPWR _6252_/D sky130_fd_sc_hd__dlygate4sd3_1
Xhold1093 _3630_/X VGND VGND VPWR VPWR _5658_/D sky130_fd_sc_hd__dlygate4sd3_1
Xhold1082 _6048_/Q VGND VGND VPWR VPWR _4411_/A1 sky130_fd_sc_hd__dlygate4sd3_1
XFILLER_33_407 VGND VGND VPWR VPWR sky130_fd_sc_hd__fill_1
XANTENNA__4631__C1 _3278_/A VGND VGND VPWR VPWR sky130_fd_sc_hd__diode_2
XFILLER_45_289 VGND VGND VPWR VPWR sky130_fd_sc_hd__fill_4
XTAP_TAPCELL_ROW_44_958 VGND VPWR sky130_fd_sc_hd__tapvpwrvgnd_1
XFILLER_14_643 VGND VGND VPWR VPWR sky130_fd_sc_hd__fill_1
XFILLER_13_153 VGND VGND VPWR VPWR sky130_fd_sc_hd__fill_1
XTAP_TAPCELL_ROW_24_660 VGND VPWR sky130_fd_sc_hd__tapvpwrvgnd_1
XANTENNA__3737__A1 _4846_/A0 VGND VGND VPWR VPWR sky130_fd_sc_hd__diode_2
XFILLER_9_135 VGND VGND VPWR VPWR sky130_fd_sc_hd__fill_2
Xclkbuf_leaf_102_clk clkload0/A VGND VGND VPWR VPWR _6302_/CLK sky130_fd_sc_hd__clkbuf_8
XFILLER_115_729 VPWR VGND VPWR VGND sky130_ef_sc_hd__decap_40_12
XFILLER_108_781 VPWR VGND VPWR VGND sky130_ef_sc_hd__decap_40_12
XFILLER_5_385 VGND VGND VPWR VPWR sky130_fd_sc_hd__fill_4
XFILLER_96_613 VPWR VGND VPWR VGND sky130_ef_sc_hd__decap_40_12
XANTENNA__3370__C1 _3801_/B VGND VGND VPWR VPWR sky130_fd_sc_hd__diode_2
XANTENNA__5053__S _5059_/S VGND VGND VPWR VPWR sky130_fd_sc_hd__diode_2
XFILLER_110_445 VGND VGND VPWR VPWR sky130_fd_sc_hd__fill_4
XFILLER_96_657 VPWR VGND VPWR VGND sky130_ef_sc_hd__decap_40_12
X_4060_ _4260_/S _4060_/B VGND VGND VPWR VPWR _4060_/Y sky130_fd_sc_hd__nor2_1
XANTENNA__4892__S _4893_/S VGND VGND VPWR VPWR sky130_fd_sc_hd__diode_2
X_3011_ _3011_/A _3011_/B VGND VGND VPWR VPWR _3011_/Y sky130_fd_sc_hd__nor2_1
XANTENNA__3673__A0 _4517_/A1 VGND VGND VPWR VPWR sky130_fd_sc_hd__diode_2
XFILLER_92_841 VGND VGND VPWR VPWR sky130_fd_sc_hd__fill_1
XFILLER_76_392 VGND VGND VPWR VPWR sky130_fd_sc_hd__fill_1
XTAP_TAPCELL_ROW_69_1333 VGND VPWR sky130_fd_sc_hd__tapvpwrvgnd_1
XFILLER_49_595 VGND VGND VPWR VPWR sky130_fd_sc_hd__fill_1
XANTENNA_hold2204_A _6459_/A VGND VGND VPWR VPWR sky130_fd_sc_hd__diode_2
XFILLER_51_204 VGND VGND VPWR VPWR sky130_fd_sc_hd__fill_1
X_4962_ _5214_/A1 _4962_/A1 _4964_/S VGND VGND VPWR VPWR _4962_/X sky130_fd_sc_hd__mux2_1
XTAP_TAPCELL_ROW_82_1533 VGND VPWR sky130_fd_sc_hd__tapvpwrvgnd_1
X_4893_ hold417/X _4906_/A0 _4893_/S VGND VGND VPWR VPWR _4893_/X sky130_fd_sc_hd__mux2_1
X_3913_ hold27/X _5211_/A1 _3918_/S VGND VGND VPWR VPWR hold28/A sky130_fd_sc_hd__mux2_1
X_3844_ _3844_/A _3852_/B VGND VGND VPWR VPWR _3844_/X sky130_fd_sc_hd__or2_1
XFILLER_20_613 VPWR VGND VPWR VGND sky130_ef_sc_hd__decap_40_12
XANTENNA__3728__A1 _4984_/A1 VGND VGND VPWR VPWR sky130_fd_sc_hd__diode_2
XFILLER_20_657 VPWR VGND VPWR VGND sky130_ef_sc_hd__decap_40_12
XFILLER_118_501 VPWR VGND VPWR VGND sky130_ef_sc_hd__decap_40_12
X_3775_ _4983_/A1 _3775_/A1 _3776_/S VGND VGND VPWR VPWR _3775_/X sky130_fd_sc_hd__mux2_1
X_5514_ _5565_/CLK _5514_/D VGND VGND VPWR VPWR _5514_/Q sky130_fd_sc_hd__dfxtp_1
XFILLER_118_545 VPWR VGND VPWR VGND sky130_ef_sc_hd__decap_40_12
X_2726_ _3030_/S _2727_/C _3029_/A VGND VGND VPWR VPWR _2728_/B sky130_fd_sc_hd__a21oi_1
XFILLER_118_589 VPWR VGND VPWR VGND sky130_ef_sc_hd__decap_40_12
X_2657_ _5254_/Q _5253_/Q _5252_/Q VGND VGND VPWR VPWR _4894_/A sky130_fd_sc_hd__or3_4
X_5445_ clkload7/A _5445_/D VGND VGND VPWR VPWR _5445_/Q sky130_fd_sc_hd__dfxtp_1
XFILLER_133_559 VGND VGND VPWR VPWR sky130_fd_sc_hd__fill_1
XANTENNA__4153__A1 _4264_/A1 VGND VGND VPWR VPWR sky130_fd_sc_hd__diode_2
X_5376_ _6369_/CLK _5376_/D VGND VGND VPWR VPWR _5376_/Q sky130_fd_sc_hd__dfxtp_1
XTAP_TAPCELL_ROW_93_1695 VGND VPWR sky130_fd_sc_hd__tapvpwrvgnd_1
XFILLER_87_613 VGND VGND VPWR VPWR sky130_fd_sc_hd__fill_2
Xfanout103 _5827_/Q VGND VGND VPWR VPWR _4980_/A1 sky130_fd_sc_hd__buf_4
XANTENNA__3900__A1 _5208_/A1 VGND VGND VPWR VPWR sky130_fd_sc_hd__diode_2
Xfanout114 _5239_/A1 VGND VGND VPWR VPWR _4883_/A1 sky130_fd_sc_hd__buf_4
Xfanout125 _5815_/Q VGND VGND VPWR VPWR _4905_/A0 sky130_fd_sc_hd__buf_4
Xfanout147 _4713_/S VGND VGND VPWR VPWR _4803_/S sky130_fd_sc_hd__clkbuf_8
Xfanout136 hold2176/X VGND VGND VPWR VPWR _4813_/S sky130_fd_sc_hd__buf_4
XANTENNA__3272__A _4663_/A VGND VGND VPWR VPWR sky130_fd_sc_hd__diode_2
X_4327_ _5051_/A1 _4327_/A1 _4335_/S VGND VGND VPWR VPWR _4327_/X sky130_fd_sc_hd__mux2_1
X_4258_ _6307_/Q _6289_/Q _4258_/S VGND VGND VPWR VPWR _4258_/X sky130_fd_sc_hd__mux2_1
Xfanout158 _4205_/A VGND VGND VPWR VPWR _3172_/B sky130_fd_sc_hd__buf_4
Xfanout169 _4228_/S VGND VGND VPWR VPWR _4262_/S sky130_fd_sc_hd__clkbuf_8
X_3209_ _5821_/Q hold910/X _3220_/S VGND VGND VPWR VPWR _3209_/X sky130_fd_sc_hd__mux2_1
XANTENNA__3664__A0 _4961_/A0 VGND VGND VPWR VPWR sky130_fd_sc_hd__diode_2
XFILLER_103_33 VGND VGND VPWR VPWR sky130_fd_sc_hd__fill_1
XFILLER_83_841 VGND VGND VPWR VPWR sky130_fd_sc_hd__fill_1
XTAP_TAPCELL_ROW_2_333 VGND VPWR sky130_fd_sc_hd__tapvpwrvgnd_1
XFILLER_27_234 VGND VGND VPWR VPWR sky130_fd_sc_hd__fill_1
XFILLER_28_757 VPWR VGND VPWR VGND sky130_ef_sc_hd__decap_40_12
X_4189_ _4189_/A0 _4188_/X _4189_/S VGND VGND VPWR VPWR _4189_/X sky130_fd_sc_hd__mux2_1
XTAP_TAPCELL_ROW_124_2161 VGND VPWR sky130_fd_sc_hd__tapvpwrvgnd_1
XFILLER_103_55 VGND VGND VPWR VPWR sky130_fd_sc_hd__fill_1
XFILLER_43_727 VGND VGND VPWR VPWR sky130_fd_sc_hd__fill_1
XANTENNA__3211__S _3220_/S VGND VGND VPWR VPWR sky130_fd_sc_hd__diode_2
XFILLER_15_429 VPWR VGND VPWR VGND sky130_ef_sc_hd__decap_40_12
XFILLER_42_259 VGND VGND VPWR VPWR sky130_fd_sc_hd__fill_1
XFILLER_11_613 VGND VGND VPWR VPWR sky130_fd_sc_hd__fill_2
XFILLER_23_473 VPWR VGND VPWR VGND sky130_ef_sc_hd__decap_40_12
XTAP_TAPCELL_ROW_41_917 VGND VPWR sky130_fd_sc_hd__tapvpwrvgnd_1
XFILLER_10_134 VGND VGND VPWR VPWR sky130_fd_sc_hd__fill_4
XFILLER_10_123 VGND VGND VPWR VPWR sky130_fd_sc_hd__fill_1
XFILLER_137_821 VPWR VGND VPWR VGND sky130_ef_sc_hd__decap_40_12
XFILLER_7_617 VPWR VGND VPWR VGND sky130_ef_sc_hd__decap_40_12
XFILLER_128_41 VGND VGND VPWR VPWR sky130_fd_sc_hd__fill_1
XANTENNA__4977__S _4984_/S VGND VGND VPWR VPWR sky130_fd_sc_hd__diode_2
XANTENNA__4549__Y _4561_/S VGND VGND VPWR VPWR sky130_fd_sc_hd__diode_2
XANTENNA_fanout92_X _5202_/A1 VGND VGND VPWR VPWR sky130_fd_sc_hd__diode_2
XTAP_TAPCELL_ROW_53_1101 VGND VPWR sky130_fd_sc_hd__tapvpwrvgnd_1
XFILLER_132_581 VGND VGND VPWR VPWR sky130_fd_sc_hd__fill_4
Xhold190 _4988_/X VGND VGND VPWR VPWR _6320_/D sky130_fd_sc_hd__dlygate4sd3_1
XFILLER_2_377 VGND VGND VPWR VPWR sky130_fd_sc_hd__fill_4
XFILLER_66_819 VGND VGND VPWR VPWR sky130_fd_sc_hd__fill_1
XANTENNA__4447__A2 _4457_/S VGND VGND VPWR VPWR sky130_fd_sc_hd__diode_2
XTAP_TAPCELL_ROW_109_1934 VGND VPWR sky130_fd_sc_hd__tapvpwrvgnd_1
XFILLER_46_521 VGND VGND VPWR VPWR sky130_fd_sc_hd__fill_1
XTAP_TAPCELL_ROW_29_730 VGND VPWR sky130_fd_sc_hd__tapvpwrvgnd_1
XPHY_EDGE_ROW_16_Right_16 VGND VGND VPWR VPWR sky130_fd_sc_hd__decap_3
XTAP_TAPCELL_ROW_29_741 VGND VPWR sky130_fd_sc_hd__tapvpwrvgnd_1
XANTENNA__3407__A0 _4929_/A1 VGND VGND VPWR VPWR sky130_fd_sc_hd__diode_2
XFILLER_33_204 VGND VGND VPWR VPWR sky130_fd_sc_hd__fill_1
XFILLER_61_579 VGND VGND VPWR VPWR sky130_fd_sc_hd__fill_1
XFILLER_61_557 VGND VGND VPWR VPWR sky130_fd_sc_hd__fill_2
XTAP_TAPCELL_ROW_64_1263 VGND VPWR sky130_fd_sc_hd__tapvpwrvgnd_1
XFILLER_14_473 VGND VGND VPWR VPWR sky130_fd_sc_hd__fill_2
XANTENNA__4058__S1 _4241_/A VGND VGND VPWR VPWR sky130_fd_sc_hd__diode_2
XFILLER_41_281 VGND VGND VPWR VPWR sky130_fd_sc_hd__fill_4
X_3560_ _4961_/A0 hold979/X _3563_/S VGND VGND VPWR VPWR _3560_/X sky130_fd_sc_hd__mux2_1
XPHY_EDGE_ROW_25_Right_25 VGND VGND VPWR VPWR sky130_fd_sc_hd__decap_3
XANTENNA__4383__A1 _4981_/A1 VGND VGND VPWR VPWR sky130_fd_sc_hd__diode_2
XANTENNA__4887__S _4893_/S VGND VGND VPWR VPWR sky130_fd_sc_hd__diode_2
XANTENNA__4239__A1_N _4149_/A VGND VGND VPWR VPWR sky130_fd_sc_hd__diode_2
X_5230_ _5817_/Q _5230_/A1 _5237_/S VGND VGND VPWR VPWR _5230_/X sky130_fd_sc_hd__mux2_1
XFILLER_115_559 VGND VGND VPWR VPWR sky130_fd_sc_hd__fill_1
X_3491_ _4881_/A _3517_/B VGND VGND VPWR VPWR _3503_/S sky130_fd_sc_hd__or2_4
XFILLER_45_3 VGND VGND VPWR VPWR sky130_fd_sc_hd__fill_8
XFILLER_111_721 VGND VGND VPWR VPWR sky130_fd_sc_hd__fill_4
XANTENNA__3092__A _3092_/A VGND VGND VPWR VPWR sky130_fd_sc_hd__diode_2
XFILLER_96_421 VGND VGND VPWR VPWR sky130_fd_sc_hd__fill_1
X_5161_ _3944_/A _5160_/A _5160_/Y _2682_/A VGND VGND VPWR VPWR _5161_/X sky130_fd_sc_hd__o211a_1
XFILLER_68_101 VGND VGND VPWR VPWR sky130_fd_sc_hd__fill_4
XANTENNA__4230__S1 _4263_/A VGND VGND VPWR VPWR sky130_fd_sc_hd__diode_2
Xhold1818 _5523_/Q VGND VGND VPWR VPWR _3476_/A1 sky130_fd_sc_hd__dlygate4sd3_1
XFILLER_111_765 VPWR VGND VPWR VGND sky130_ef_sc_hd__decap_40_12
Xhold1807 _6380_/Q VGND VGND VPWR VPWR _5092_/A0 sky130_fd_sc_hd__dlygate4sd3_1
X_5092_ _5092_/A0 _6168_/Q _5094_/S VGND VGND VPWR VPWR _5092_/X sky130_fd_sc_hd__mux2_1
X_4112_ _6275_/Q _6266_/Q _4258_/S VGND VGND VPWR VPWR _4112_/X sky130_fd_sc_hd__mux2_1
Xhold1829 _3525_/X VGND VGND VPWR VPWR _5568_/D sky130_fd_sc_hd__dlygate4sd3_1
XANTENNA__4438__A2 _4994_/B VGND VGND VPWR VPWR sky130_fd_sc_hd__diode_2
XFILLER_68_178 VGND VGND VPWR VPWR sky130_fd_sc_hd__fill_4
X_4043_ _5769_/Q _6027_/Q _5937_/Q _6308_/Q _4258_/S _4241_/A VGND VGND VPWR VPWR
+ _4043_/X sky130_fd_sc_hd__mux4_1
XFILLER_65_841 VGND VGND VPWR VPWR sky130_fd_sc_hd__fill_1
XFILLER_49_370 VGND VGND VPWR VPWR sky130_fd_sc_hd__fill_4
XPHY_EDGE_ROW_34_Right_34 VGND VGND VPWR VPWR sky130_fd_sc_hd__decap_3
XFILLER_64_362 VGND VGND VPWR VPWR sky130_fd_sc_hd__fill_2
Xi2c_master_axil_218 VGND VGND VPWR VPWR i2c_master_axil_218/HI s_axil_rdata[24] sky130_fd_sc_hd__conb_1
XFILLER_37_565 VGND VGND VPWR VPWR sky130_fd_sc_hd__fill_2
XFILLER_92_693 VGND VGND VPWR VPWR sky130_fd_sc_hd__fill_4
XFILLER_52_513 VGND VGND VPWR VPWR sky130_fd_sc_hd__fill_2
XFILLER_25_727 VGND VGND VPWR VPWR sky130_fd_sc_hd__fill_1
XANTENNA__4127__S _4213_/S VGND VGND VPWR VPWR sky130_fd_sc_hd__diode_2
X_5994_ _6421_/CLK _5994_/D VGND VGND VPWR VPWR _5994_/Q sky130_fd_sc_hd__dfxtp_1
X_4945_ _5038_/B _4965_/B VGND VGND VPWR VPWR _4954_/S sky130_fd_sc_hd__or2_4
XANTENNA__2870__S _3072_/S VGND VGND VPWR VPWR sky130_fd_sc_hd__diode_2
X_4876_ hold295/X _4889_/A1 _4880_/S VGND VGND VPWR VPWR _4876_/X sky130_fd_sc_hd__mux2_1
XFILLER_20_421 VPWR VGND VPWR VGND sky130_ef_sc_hd__decap_40_12
XFILLER_138_629 VPWR VGND VPWR VGND sky130_ef_sc_hd__decap_40_12
XFILLER_119_821 VPWR VGND VPWR VGND sky130_ef_sc_hd__decap_40_12
X_3827_ _2625_/A _5042_/A1 _3835_/S VGND VGND VPWR VPWR _5826_/D sky130_fd_sc_hd__mux2_1
XPHY_EDGE_ROW_43_Right_43 VGND VGND VPWR VPWR sky130_fd_sc_hd__decap_3
XANTENNA__3267__A _4773_/S VGND VGND VPWR VPWR sky130_fd_sc_hd__diode_2
X_3758_ _3758_/A0 _4976_/A1 _3766_/S VGND VGND VPWR VPWR _3758_/X sky130_fd_sc_hd__mux2_1
XFILLER_134_813 VPWR VGND VPWR VGND sky130_ef_sc_hd__decap_40_12
XTAP_TAPCELL_ROW_95_1724 VGND VPWR sky130_fd_sc_hd__tapvpwrvgnd_1
X_2709_ _5052_/A1 hold914/X _2716_/S VGND VGND VPWR VPWR _2709_/X sky130_fd_sc_hd__mux2_1
XFILLER_118_386 VGND VGND VPWR VPWR sky130_fd_sc_hd__fill_1
X_3689_ _4493_/B _3919_/B VGND VGND VPWR VPWR _3698_/S sky130_fd_sc_hd__nor2_4
XFILLER_133_345 VGND VGND VPWR VPWR sky130_fd_sc_hd__fill_1
X_5428_ _6386_/CLK _5428_/D VGND VGND VPWR VPWR _5428_/Q sky130_fd_sc_hd__dfxtp_1
XTAP_TAPCELL_ROW_7_403 VGND VPWR sky130_fd_sc_hd__tapvpwrvgnd_1
XFILLER_0_804 VGND VGND VPWR VPWR sky130_fd_sc_hd__fill_4
XFILLER_133_378 VGND VGND VPWR VPWR sky130_fd_sc_hd__fill_1
X_5359_ _6366_/CLK _5359_/D VGND VGND VPWR VPWR _5359_/Q sky130_fd_sc_hd__dfxtp_1
XFILLER_114_581 VGND VGND VPWR VPWR sky130_fd_sc_hd__fill_4
XFILLER_99_281 VGND VGND VPWR VPWR sky130_fd_sc_hd__fill_8
XFILLER_87_443 VGND VGND VPWR VPWR sky130_fd_sc_hd__fill_4
XFILLER_114_43 VGND VGND VPWR VPWR sky130_fd_sc_hd__fill_1
XFILLER_101_275 VGND VGND VPWR VPWR sky130_fd_sc_hd__fill_4
XFILLER_87_465 VGND VGND VPWR VPWR sky130_fd_sc_hd__fill_1
XFILLER_75_605 VGND VGND VPWR VPWR sky130_fd_sc_hd__fill_2
XPHY_EDGE_ROW_52_Right_52 VGND VGND VPWR VPWR sky130_fd_sc_hd__decap_3
XFILLER_56_841 VGND VGND VPWR VPWR sky130_fd_sc_hd__fill_1
XFILLER_16_749 VGND VGND VPWR VPWR sky130_fd_sc_hd__fill_4
XTAP_TAPCELL_ROW_104_1864 VGND VPWR sky130_fd_sc_hd__tapvpwrvgnd_1
XTAP_TAPCELL_ROW_104_1853 VGND VPWR sky130_fd_sc_hd__tapvpwrvgnd_1
XFILLER_70_376 VGND VGND VPWR VPWR sky130_fd_sc_hd__fill_1
XPHY_EDGE_ROW_61_Right_61 VGND VGND VPWR VPWR sky130_fd_sc_hd__decap_3
XFILLER_24_793 VPWR VGND VPWR VGND sky130_ef_sc_hd__decap_40_12
XTAP_TAPCELL_ROW_137_2352 VGND VPWR sky130_fd_sc_hd__tapvpwrvgnd_1
XFILLER_129_629 VPWR VGND VPWR VGND sky130_ef_sc_hd__decap_40_12
XANTENNA__4365__A1 _5046_/A1 VGND VGND VPWR VPWR sky130_fd_sc_hd__diode_2
XFILLER_7_447 VGND VGND VPWR VPWR sky130_fd_sc_hd__fill_1
XFILLER_137_673 VPWR VGND VPWR VGND sky130_ef_sc_hd__decap_40_12
XFILLER_99_55 VGND VGND VPWR VPWR sky130_fd_sc_hd__fill_1
XANTENNA__4117__A1 _4260_/S VGND VGND VPWR VPWR sky130_fd_sc_hd__diode_2
XFILLER_3_653 VPWR VGND VPWR VGND sky130_ef_sc_hd__decap_40_12
XFILLER_112_529 VGND VGND VPWR VPWR sky130_fd_sc_hd__fill_2
XANTENNA__3876__A0 _6415_/Q VGND VGND VPWR VPWR sky130_fd_sc_hd__diode_2
XPHY_EDGE_ROW_70_Right_70 VGND VGND VPWR VPWR sky130_fd_sc_hd__decap_3
XFILLER_3_697 VPWR VGND VPWR VGND sky130_ef_sc_hd__decap_40_12
XFILLER_38_307 VGND VGND VPWR VPWR sky130_fd_sc_hd__fill_1
XFILLER_47_841 VGND VGND VPWR VPWR sky130_fd_sc_hd__fill_1
XANTENNA_output33_A _6460_/A VGND VGND VPWR VPWR sky130_fd_sc_hd__diode_2
XFILLER_0_55 VGND VGND VPWR VPWR sky130_fd_sc_hd__fill_1
XFILLER_73_181 VGND VGND VPWR VPWR sky130_fd_sc_hd__fill_2
XFILLER_34_568 VGND VGND VPWR VPWR sky130_fd_sc_hd__fill_2
X_2991_ _5521_/Q _5533_/Q _3077_/S VGND VGND VPWR VPWR _2991_/X sky130_fd_sc_hd__mux2_1
XPHY_EDGE_ROW_14_Left_153 VGND VGND VPWR VPWR sky130_fd_sc_hd__decap_3
X_4730_ hold85/X hold289/X _4730_/A2 _4730_/A3 _4773_/S _4794_/A VGND VGND VPWR VPWR
+ _4730_/X sky130_fd_sc_hd__mux4_1
X_4661_ _4799_/A _4653_/X _4660_/Y _5401_/Q VGND VGND VPWR VPWR _4661_/X sky130_fd_sc_hd__a211o_1
XFILLER_30_752 VGND VGND VPWR VPWR sky130_fd_sc_hd__fill_4
XANTENNA__3087__A _3092_/A VGND VGND VPWR VPWR sky130_fd_sc_hd__diode_2
X_6400_ _6402_/CLK _6400_/D VGND VGND VPWR VPWR _6400_/Q sky130_fd_sc_hd__dfxtp_1
X_3612_ hold461/X _5212_/A1 _3616_/S VGND VGND VPWR VPWR _3612_/X sky130_fd_sc_hd__mux2_1
XANTENNA__4356__A1 _5047_/A1 VGND VGND VPWR VPWR sky130_fd_sc_hd__diode_2
XFILLER_116_813 VPWR VGND VPWR VGND sky130_ef_sc_hd__decap_40_12
X_4592_ _5676_/Q _5658_/Q _4810_/S VGND VGND VPWR VPWR _4593_/B sky130_fd_sc_hd__mux2_1
X_6331_ _6422_/CLK _6331_/D VGND VGND VPWR VPWR _6460_/A sky130_fd_sc_hd__dfxtp_1
Xhold904 _6266_/Q VGND VGND VPWR VPWR hold904/X sky130_fd_sc_hd__dlygate4sd3_1
XTAP_TAPCELL_ROW_12_482 VGND VPWR sky130_fd_sc_hd__tapvpwrvgnd_1
XFILLER_127_161 VGND VGND VPWR VPWR sky130_fd_sc_hd__fill_1
Xhold937 _3477_/X VGND VGND VPWR VPWR _5524_/D sky130_fd_sc_hd__dlygate4sd3_1
Xhold926 _5480_/Q VGND VGND VPWR VPWR hold926/X sky130_fd_sc_hd__dlygate4sd3_1
XTAP_TAPCELL_ROW_77_1454 VGND VPWR sky130_fd_sc_hd__tapvpwrvgnd_1
Xhold915 _2709_/X VGND VGND VPWR VPWR _5257_/D sky130_fd_sc_hd__dlygate4sd3_1
X_3543_ _4503_/A _4955_/A VGND VGND VPWR VPWR _3552_/S sky130_fd_sc_hd__nor2_4
X_3474_ _4903_/A0 _3474_/A1 _3477_/S VGND VGND VPWR VPWR _3474_/X sky130_fd_sc_hd__mux2_1
Xhold959 _3442_/X VGND VGND VPWR VPWR _5492_/D sky130_fd_sc_hd__dlygate4sd3_1
XFILLER_89_719 VGND VGND VPWR VPWR sky130_fd_sc_hd__fill_8
Xhold948 _5612_/Q VGND VGND VPWR VPWR hold948/X sky130_fd_sc_hd__dlygate4sd3_1
X_6262_ _6404_/CLK _6262_/D VGND VGND VPWR VPWR _6262_/Q sky130_fd_sc_hd__dfxtp_1
XANTENNA__4410__S _4416_/S VGND VGND VPWR VPWR sky130_fd_sc_hd__diode_2
XANTENNA__4108__A1 _4252_/A1 VGND VGND VPWR VPWR sky130_fd_sc_hd__diode_2
XPHY_EDGE_ROW_23_Left_162 VGND VGND VPWR VPWR sky130_fd_sc_hd__decap_3
X_6193_ _6242_/CLK _6193_/D VGND VGND VPWR VPWR _6193_/Q sky130_fd_sc_hd__dfxtp_1
XTAP_TAPCELL_ROW_90_1643 VGND VPWR sky130_fd_sc_hd__tapvpwrvgnd_1
XANTENNA__3867__A0 _3926_/A1 VGND VGND VPWR VPWR sky130_fd_sc_hd__diode_2
X_5213_ _5213_/A0 _5213_/A1 _5213_/S VGND VGND VPWR VPWR _6415_/D sky130_fd_sc_hd__mux2_1
XFILLER_97_741 VPWR VGND VPWR VGND sky130_ef_sc_hd__decap_40_12
XTAP_TAPCELL_ROW_90_1654 VGND VPWR sky130_fd_sc_hd__tapvpwrvgnd_1
X_5144_ _3958_/A _5143_/X _5142_/Y _3943_/B VGND VGND VPWR VPWR _5145_/B sky130_fd_sc_hd__a2bb2o_1
XFILLER_111_573 VPWR VGND VPWR VGND sky130_ef_sc_hd__decap_40_12
Xhold1604 _5551_/Q VGND VGND VPWR VPWR _3507_/A1 sky130_fd_sc_hd__dlygate4sd3_1
Xhold1615 _6185_/Q VGND VGND VPWR VPWR _4832_/A1 sky130_fd_sc_hd__dlygate4sd3_1
XFILLER_97_785 VPWR VGND VPWR VGND sky130_ef_sc_hd__decap_40_12
XFILLER_96_251 VGND VGND VPWR VPWR sky130_fd_sc_hd__fill_1
XFILLER_84_413 VGND VGND VPWR VPWR sky130_fd_sc_hd__fill_1
Xhold1626 _4838_/X VGND VGND VPWR VPWR _6191_/D sky130_fd_sc_hd__dlygate4sd3_1
XANTENNA__5241__S _5241_/S VGND VGND VPWR VPWR sky130_fd_sc_hd__diode_2
X_5075_ _5075_/A0 _5075_/A1 _5081_/S VGND VGND VPWR VPWR _5075_/X sky130_fd_sc_hd__mux2_1
XANTENNA_fanout187_A _3020_/A VGND VGND VPWR VPWR sky130_fd_sc_hd__diode_2
Xhold1648 _6076_/Q VGND VGND VPWR VPWR _4468_/A1 sky130_fd_sc_hd__dlygate4sd3_1
Xhold1659 _4853_/X VGND VGND VPWR VPWR _6205_/D sky130_fd_sc_hd__dlygate4sd3_1
XFILLER_96_295 VGND VGND VPWR VPWR sky130_fd_sc_hd__fill_2
Xhold1637 _6172_/Q VGND VGND VPWR VPWR _4818_/A1 sky130_fd_sc_hd__dlygate4sd3_1
XFILLER_56_137 VGND VGND VPWR VPWR sky130_fd_sc_hd__fill_2
XFILLER_38_841 VGND VGND VPWR VPWR sky130_fd_sc_hd__fill_1
XFILLER_84_457 VGND VGND VPWR VPWR sky130_fd_sc_hd__fill_1
X_4026_ _4212_/A _4026_/B VGND VGND VPWR VPWR _4026_/X sky130_fd_sc_hd__or2_1
XTAP_TAPCELL_ROW_121_2120 VGND VPWR sky130_fd_sc_hd__tapvpwrvgnd_1
XFILLER_53_833 VGND VGND VPWR VPWR sky130_fd_sc_hd__fill_4
Xclkbuf_leaf_91_clk clkload1/A VGND VGND VPWR VPWR _6417_/CLK sky130_fd_sc_hd__clkbuf_8
XPHY_EDGE_ROW_32_Left_171 VGND VGND VPWR VPWR sky130_fd_sc_hd__decap_3
XANTENNA__3696__S _3698_/S VGND VGND VPWR VPWR sky130_fd_sc_hd__diode_2
X_5977_ _6334_/CLK _5977_/D VGND VGND VPWR VPWR _5977_/Q sky130_fd_sc_hd__dfxtp_1
XANTENNA__4595__A1 _4811_/A1 VGND VGND VPWR VPWR sky130_fd_sc_hd__diode_2
XANTENNA_fanout142_X _4809_/A VGND VGND VPWR VPWR sky130_fd_sc_hd__diode_2
X_4928_ hold839/X _4978_/A1 _4934_/S VGND VGND VPWR VPWR _4928_/X sky130_fd_sc_hd__mux2_1
XFILLER_21_741 VPWR VGND VPWR VGND sky130_ef_sc_hd__decap_40_12
X_4859_ _5241_/A1 _4859_/A1 _4867_/S VGND VGND VPWR VPWR _6210_/D sky130_fd_sc_hd__mux2_1
XANTENNA_clkbuf_leaf_7_clk_A clkbuf_leaf_9_clk/A VGND VGND VPWR VPWR sky130_fd_sc_hd__diode_2
XFILLER_21_785 VPWR VGND VPWR VGND sky130_ef_sc_hd__decap_40_12
XFILLER_119_673 VPWR VGND VPWR VGND sky130_ef_sc_hd__decap_40_12
XTAP_TAPCELL_ROW_119_2082 VGND VPWR sky130_fd_sc_hd__tapvpwrvgnd_1
Xclkbuf_3_0__f_clk clkbuf_0_clk/X VGND VGND VPWR VPWR clkload0/A sky130_fd_sc_hd__clkbuf_16
XFILLER_4_417 VGND VGND VPWR VPWR sky130_fd_sc_hd__fill_2
XPHY_EDGE_ROW_41_Left_180 VGND VGND VPWR VPWR sky130_fd_sc_hd__decap_3
XFILLER_134_643 VGND VGND VPWR VPWR sky130_fd_sc_hd__fill_1
XTAP_TAPCELL_ROW_132_2282 VGND VPWR sky130_fd_sc_hd__tapvpwrvgnd_1
XFILLER_122_805 VGND VGND VPWR VPWR sky130_fd_sc_hd__fill_4
XFILLER_0_601 VPWR VGND VPWR VGND sky130_ef_sc_hd__decap_40_12
XFILLER_0_645 VPWR VGND VPWR VGND sky130_ef_sc_hd__decap_40_12
XFILLER_85_57 VGND VGND VPWR VPWR sky130_fd_sc_hd__fill_4
XFILLER_47_137 VGND VGND VPWR VPWR sky130_fd_sc_hd__fill_2
XFILLER_29_841 VGND VGND VPWR VPWR sky130_fd_sc_hd__fill_1
XFILLER_85_79 VGND VGND VPWR VPWR sky130_fd_sc_hd__fill_1
XANTENNA__4990__S _4993_/S VGND VGND VPWR VPWR sky130_fd_sc_hd__diode_2
XTAP_TAPCELL_ROW_48_1022 VGND VPWR sky130_fd_sc_hd__tapvpwrvgnd_1
XFILLER_44_811 VGND VGND VPWR VPWR sky130_fd_sc_hd__fill_1
XFILLER_16_513 VPWR VGND VPWR VGND sky130_ef_sc_hd__decap_40_12
XFILLER_28_373 VPWR VGND VPWR VGND sky130_ef_sc_hd__decap_40_12
XTAP_TAPCELL_ROW_39_880 VGND VPWR sky130_fd_sc_hd__tapvpwrvgnd_1
XFILLER_16_557 VPWR VGND VPWR VGND sky130_ef_sc_hd__decap_40_12
Xclkbuf_leaf_82_clk clkload1/A VGND VGND VPWR VPWR _5902_/CLK sky130_fd_sc_hd__clkbuf_8
XTAP_TAPCELL_ROW_39_891 VGND VPWR sky130_fd_sc_hd__tapvpwrvgnd_1
XFILLER_31_505 VGND VGND VPWR VPWR sky130_fd_sc_hd__fill_4
XANTENNA__2804__A _3005_/A VGND VGND VPWR VPWR sky130_fd_sc_hd__diode_2
XTAP_TAPCELL_ROW_61_1222 VGND VPWR sky130_fd_sc_hd__tapvpwrvgnd_1
XTAP_TAPCELL_ROW_61_1211 VGND VPWR sky130_fd_sc_hd__tapvpwrvgnd_1
XANTENNA__4586__A1 _4811_/A1 VGND VGND VPWR VPWR sky130_fd_sc_hd__diode_2
XFILLER_8_701 VPWR VGND VPWR VGND sky130_ef_sc_hd__decap_40_12
XFILLER_7_200 VGND VGND VPWR VPWR sky130_fd_sc_hd__fill_2
XANTENNA__4338__A1 _5040_/A1 VGND VGND VPWR VPWR sky130_fd_sc_hd__diode_2
XFILLER_116_109 VGND VGND VPWR VPWR sky130_fd_sc_hd__fill_1
XFILLER_7_277 VGND VGND VPWR VPWR sky130_fd_sc_hd__fill_1
XFILLER_125_665 VGND VGND VPWR VPWR sky130_fd_sc_hd__fill_4
XTAP_TAPCELL_ROW_59_1184 VGND VPWR sky130_fd_sc_hd__tapvpwrvgnd_1
XFILLER_3_461 VPWR VGND VPWR VGND sky130_ef_sc_hd__decap_40_12
XFILLER_124_197 VGND VGND VPWR VPWR sky130_fd_sc_hd__fill_4
X_3190_ hold790/X _5234_/A0 _3193_/S VGND VGND VPWR VPWR _5353_/D sky130_fd_sc_hd__mux2_1
XFILLER_79_785 VPWR VGND VPWR VGND sky130_ef_sc_hd__decap_40_12
XFILLER_78_251 VGND VGND VPWR VPWR sky130_fd_sc_hd__fill_1
XTAP_TAPCELL_ROW_72_1384 VGND VPWR sky130_fd_sc_hd__tapvpwrvgnd_1
XTAP_TAPCELL_ROW_72_1373 VGND VPWR sky130_fd_sc_hd__tapvpwrvgnd_1
XANTENNA__4510__A1 _5214_/A1 VGND VGND VPWR VPWR sky130_fd_sc_hd__diode_2
XFILLER_94_755 VGND VGND VPWR VPWR sky130_fd_sc_hd__fill_1
XFILLER_66_479 VGND VGND VPWR VPWR sky130_fd_sc_hd__fill_1
XFILLER_93_298 VGND VGND VPWR VPWR sky130_fd_sc_hd__fill_1
X_5900_ _6120_/CLK _5900_/D VGND VGND VPWR VPWR _5900_/Q sky130_fd_sc_hd__dfxtp_1
XFILLER_19_384 VGND VGND VPWR VPWR sky130_fd_sc_hd__fill_8
XFILLER_35_833 VGND VGND VPWR VPWR sky130_fd_sc_hd__fill_4
Xclkbuf_leaf_73_clk clkload2/A VGND VGND VPWR VPWR _6123_/CLK sky130_fd_sc_hd__clkbuf_8
XANTENNA__3369__X _4994_/B VGND VGND VPWR VPWR sky130_fd_sc_hd__diode_2
X_5831_ _6404_/CLK _5831_/D VGND VGND VPWR VPWR _5831_/Q sky130_fd_sc_hd__dfxtp_1
XFILLER_50_825 VPWR VGND VPWR VGND sky130_ef_sc_hd__decap_40_12
XTAP_TAPCELL_ROW_17_552 VGND VPWR sky130_fd_sc_hd__tapvpwrvgnd_1
X_2974_ _5544_/Q _5568_/Q _3051_/S VGND VGND VPWR VPWR _2975_/B sky130_fd_sc_hd__mux2_1
XFILLER_61_173 VGND VGND VPWR VPWR sky130_fd_sc_hd__fill_1
XANTENNA__4405__S _4406_/S VGND VGND VPWR VPWR sky130_fd_sc_hd__diode_2
X_5762_ _6310_/CLK _5762_/D VGND VGND VPWR VPWR _5762_/Q sky130_fd_sc_hd__dfxtp_1
XFILLER_34_398 VGND VGND VPWR VPWR sky130_fd_sc_hd__fill_4
X_4713_ hold252/X _5857_/Q _4713_/S VGND VGND VPWR VPWR _4713_/X sky130_fd_sc_hd__mux2_1
X_5693_ _6120_/CLK _5693_/D VGND VGND VPWR VPWR _5693_/Q sky130_fd_sc_hd__dfxtp_1
XFILLER_30_19 VGND VGND VPWR VPWR sky130_fd_sc_hd__fill_2
X_4644_ _4811_/C1 _4643_/X _4640_/Y _4642_/Y VGND VGND VPWR VPWR _4644_/X sky130_fd_sc_hd__o2bb2a_1
Xhold701 _4844_/X VGND VGND VPWR VPWR _6196_/D sky130_fd_sc_hd__dlygate4sd3_1
X_4575_ _4799_/A _4567_/X _4574_/Y _3278_/A VGND VGND VPWR VPWR _4575_/X sky130_fd_sc_hd__a211o_1
Xhold712 _5450_/Q VGND VGND VPWR VPWR hold712/X sky130_fd_sc_hd__dlygate4sd3_1
Xhold723 _3467_/X VGND VGND VPWR VPWR _5514_/D sky130_fd_sc_hd__dlygate4sd3_1
X_3526_ _4903_/A0 _3526_/A1 _3529_/S VGND VGND VPWR VPWR _3526_/X sky130_fd_sc_hd__mux2_1
XFILLER_116_643 VGND VGND VPWR VPWR sky130_fd_sc_hd__fill_1
XFILLER_104_805 VGND VGND VPWR VPWR sky130_fd_sc_hd__fill_4
Xhold745 _5498_/Q VGND VGND VPWR VPWR hold745/X sky130_fd_sc_hd__dlygate4sd3_1
XANTENNA_fanout102_A _4980_/A1 VGND VGND VPWR VPWR sky130_fd_sc_hd__diode_2
X_6314_ _6314_/CLK _6314_/D VGND VGND VPWR VPWR _6314_/Q sky130_fd_sc_hd__dfxtp_1
XANTENNA__4140__S _4257_/S VGND VGND VPWR VPWR sky130_fd_sc_hd__diode_2
Xhold734 _3789_/X VGND VGND VPWR VPWR _5796_/D sky130_fd_sc_hd__dlygate4sd3_1
X_6245_ _6248_/CLK _6245_/D VGND VGND VPWR VPWR _6245_/Q sky130_fd_sc_hd__dfxtp_1
XFILLER_131_613 VGND VGND VPWR VPWR sky130_fd_sc_hd__fill_2
Xhold756 _3219_/X VGND VGND VPWR VPWR _5379_/D sky130_fd_sc_hd__dlygate4sd3_1
XANTENNA__4188__S0 _4260_/S VGND VGND VPWR VPWR sky130_fd_sc_hd__diode_2
Xhold778 _4509_/X VGND VGND VPWR VPWR _6113_/D sky130_fd_sc_hd__dlygate4sd3_1
Xhold767 _5798_/Q VGND VGND VPWR VPWR hold767/X sky130_fd_sc_hd__dlygate4sd3_1
X_3457_ hold163/X _4887_/A1 _3463_/S VGND VGND VPWR VPWR _3457_/X sky130_fd_sc_hd__mux2_1
XFILLER_103_326 VGND VGND VPWR VPWR sky130_fd_sc_hd__fill_1
XFILLER_89_549 VGND VGND VPWR VPWR sky130_fd_sc_hd__fill_2
Xhold789 _6126_/Q VGND VGND VPWR VPWR hold789/X sky130_fd_sc_hd__dlygate4sd3_1
Xhold2102 _5203_/X VGND VGND VPWR VPWR _6407_/D sky130_fd_sc_hd__dlygate4sd3_1
X_6176_ _6237_/CLK _6176_/D VGND VGND VPWR VPWR _6176_/Q sky130_fd_sc_hd__dfxtp_1
Xhold2113 _6360_/Q VGND VGND VPWR VPWR _2649_/A sky130_fd_sc_hd__dlygate4sd3_1
Xhold2124 _6389_/Q VGND VGND VPWR VPWR _5126_/A1 sky130_fd_sc_hd__dlygate4sd3_1
X_3388_ hold843/X _4982_/A1 _3390_/S VGND VGND VPWR VPWR _3388_/X sky130_fd_sc_hd__mux2_1
Xhold1401 _5803_/Q VGND VGND VPWR VPWR _3796_/A0 sky130_fd_sc_hd__dlygate4sd3_1
XANTENNA__4501__A1 _5215_/A1 VGND VGND VPWR VPWR sky130_fd_sc_hd__diode_2
Xhold2135 _3140_/X VGND VGND VPWR VPWR _5324_/D sky130_fd_sc_hd__dlygate4sd3_1
Xhold1434 _2743_/X VGND VGND VPWR VPWR _5273_/D sky130_fd_sc_hd__dlygate4sd3_1
Xhold1412 _3661_/X VGND VGND VPWR VPWR _5686_/D sky130_fd_sc_hd__dlygate4sd3_1
X_5127_ _5127_/A _6389_/Q VGND VGND VPWR VPWR _5127_/Y sky130_fd_sc_hd__nand2_1
Xhold1423 _5264_/Q VGND VGND VPWR VPWR _2716_/A1 sky130_fd_sc_hd__dlygate4sd3_1
Xhold2179 _5381_/Q VGND VGND VPWR VPWR _3222_/B sky130_fd_sc_hd__dlygate4sd3_1
Xhold2168 _4007_/X VGND VGND VPWR VPWR _4008_/B1 sky130_fd_sc_hd__dlygate4sd3_1
Xhold2146 _3246_/X VGND VGND VPWR VPWR _5385_/D sky130_fd_sc_hd__dlygate4sd3_1
Xhold2157 _5917_/Q VGND VGND VPWR VPWR _5123_/A sky130_fd_sc_hd__dlygate4sd3_1
Xhold1456 _5226_/X VGND VGND VPWR VPWR _6423_/D sky130_fd_sc_hd__dlygate4sd3_1
X_5058_ _5058_/A0 _5830_/Q _5059_/S VGND VGND VPWR VPWR _5058_/X sky130_fd_sc_hd__mux2_1
Xhold1467 _5736_/Q VGND VGND VPWR VPWR _3716_/A0 sky130_fd_sc_hd__dlygate4sd3_1
XPHY_EDGE_ROW_2_Right_2 VGND VGND VPWR VPWR sky130_fd_sc_hd__decap_3
Xhold1445 _5742_/Q VGND VGND VPWR VPWR _4137_/A1 sky130_fd_sc_hd__dlygate4sd3_1
XFILLER_29_148 VGND VGND VPWR VPWR sky130_fd_sc_hd__fill_4
Xhold1478 _3503_/X VGND VGND VPWR VPWR _5548_/D sky130_fd_sc_hd__dlygate4sd3_1
Xhold1489 _4849_/X VGND VGND VPWR VPWR _6201_/D sky130_fd_sc_hd__dlygate4sd3_1
X_4009_ _4010_/A _5019_/B VGND VGND VPWR VPWR _4009_/Y sky130_fd_sc_hd__nor2_1
XFILLER_44_129 VGND VGND VPWR VPWR sky130_fd_sc_hd__fill_1
XFILLER_26_811 VGND VGND VPWR VPWR sky130_fd_sc_hd__fill_1
Xclkbuf_leaf_64_clk clkload5/A VGND VGND VPWR VPWR _5870_/CLK sky130_fd_sc_hd__clkbuf_8
XFILLER_25_332 VGND VGND VPWR VPWR sky130_fd_sc_hd__fill_2
XFILLER_13_505 VPWR VGND VPWR VGND sky130_ef_sc_hd__decap_40_12
XFILLER_25_365 VPWR VGND VPWR VGND sky130_ef_sc_hd__decap_40_12
XTAP_TAPCELL_ROW_101_1812 VGND VPWR sky130_fd_sc_hd__tapvpwrvgnd_1
XFILLER_40_313 VGND VGND VPWR VPWR sky130_fd_sc_hd__fill_1
XTAP_TAPCELL_ROW_134_2311 VGND VPWR sky130_fd_sc_hd__tapvpwrvgnd_1
XFILLER_21_593 VGND VGND VPWR VPWR sky130_fd_sc_hd__fill_2
XFILLER_112_3 VPWR VGND VPWR VGND sky130_ef_sc_hd__decap_40_12
XFILLER_107_665 VGND VGND VPWR VPWR sky130_fd_sc_hd__fill_4
XFILLER_136_41 VPWR VGND VPWR VGND sky130_ef_sc_hd__decap_40_12
XFILLER_122_613 VPWR VGND VPWR VGND sky130_ef_sc_hd__decap_40_12
XFILLER_136_85 VGND VGND VPWR VPWR sky130_fd_sc_hd__fill_2
XFILLER_122_657 VPWR VGND VPWR VGND sky130_ef_sc_hd__decap_40_12
XANTENNA__4985__S _4993_/S VGND VGND VPWR VPWR sky130_fd_sc_hd__diode_2
XFILLER_121_167 VGND VGND VPWR VPWR sky130_fd_sc_hd__fill_1
XTAP_TAPCELL_ROW_112_1985 VGND VPWR sky130_fd_sc_hd__tapvpwrvgnd_1
XTAP_TAPCELL_ROW_112_1974 VGND VPWR sky130_fd_sc_hd__tapvpwrvgnd_1
XFILLER_76_733 VGND VGND VPWR VPWR sky130_fd_sc_hd__fill_2
XFILLER_75_221 VGND VGND VPWR VPWR sky130_fd_sc_hd__fill_1
XFILLER_0_475 VGND VGND VPWR VPWR sky130_fd_sc_hd__fill_1
Xhold50 hold50/A VGND VGND VPWR VPWR hold50/X sky130_fd_sc_hd__dlygate4sd3_1
Xhold72 hold72/A VGND VGND VPWR VPWR hold72/X sky130_fd_sc_hd__dlygate4sd3_1
XFILLER_76_755 VGND VGND VPWR VPWR sky130_fd_sc_hd__fill_1
Xhold83 hold83/A VGND VGND VPWR VPWR hold83/X sky130_fd_sc_hd__dlygate4sd3_1
Xhold61 hold61/A VGND VGND VPWR VPWR hold61/X sky130_fd_sc_hd__dlygate4sd3_1
XFILLER_91_725 VGND VGND VPWR VPWR sky130_fd_sc_hd__fill_2
Xhold94 hold94/A VGND VGND VPWR VPWR hold94/X sky130_fd_sc_hd__dlygate4sd3_1
Xhold1990 _4815_/X VGND VGND VPWR VPWR _6170_/D sky130_fd_sc_hd__dlygate4sd3_1
XANTENNA__2806__A1 _3031_/A1 VGND VGND VPWR VPWR sky130_fd_sc_hd__diode_2
Xclkbuf_leaf_55_clk clkload6/A VGND VGND VPWR VPWR _6237_/CLK sky130_fd_sc_hd__clkbuf_8
XFILLER_16_321 VGND VGND VPWR VPWR sky130_fd_sc_hd__fill_2
XFILLER_16_332 VGND VGND VPWR VPWR sky130_fd_sc_hd__fill_1
XFILLER_17_833 VGND VGND VPWR VPWR sky130_fd_sc_hd__fill_4
XFILLER_32_825 VPWR VGND VPWR VGND sky130_ef_sc_hd__decap_40_12
XTAP_TAPCELL_ROW_34_809 VGND VPWR sky130_fd_sc_hd__tapvpwrvgnd_1
XANTENNA__4559__A1 _4904_/A0 VGND VGND VPWR VPWR sky130_fd_sc_hd__diode_2
XFILLER_91_8 VPWR VGND VPWR VGND sky130_ef_sc_hd__decap_40_12
XFILLER_43_173 VGND VGND VPWR VPWR sky130_fd_sc_hd__fill_4
XTAP_TAPCELL_ROW_14_511 VGND VPWR sky130_fd_sc_hd__tapvpwrvgnd_1
XFILLER_31_357 VGND VGND VPWR VPWR sky130_fd_sc_hd__fill_2
XFILLER_8_531 VGND VGND VPWR VPWR sky130_fd_sc_hd__fill_1
X_2690_ _2688_/A _2686_/Y _4547_/S _2682_/A VGND VGND VPWR VPWR _2690_/X sky130_fd_sc_hd__a22o_1
XTAP_TAPCELL_ROW_74_1413 VGND VPWR sky130_fd_sc_hd__tapvpwrvgnd_1
X_4360_ hold161/X _5053_/A1 _4366_/S VGND VGND VPWR VPWR _4360_/X sky130_fd_sc_hd__mux2_1
XFILLER_6_54 VGND VGND VPWR VPWR sky130_fd_sc_hd__fill_1
XANTENNA__5056__S _5059_/S VGND VGND VPWR VPWR sky130_fd_sc_hd__diode_2
XFILLER_125_484 VPWR VGND VPWR VGND sky130_ef_sc_hd__decap_40_12
XFILLER_113_613 VGND VGND VPWR VPWR sky130_fd_sc_hd__fill_2
X_3311_ _5035_/A _3311_/B VGND VGND VPWR VPWR _3311_/Y sky130_fd_sc_hd__nand2_1
XFILLER_6_87 VGND VGND VPWR VPWR sky130_fd_sc_hd__fill_1
XANTENNA__4895__S _4906_/S VGND VGND VPWR VPWR sky130_fd_sc_hd__diode_2
XFILLER_4_781 VPWR VGND VPWR VGND sky130_ef_sc_hd__decap_40_12
X_4291_ _4291_/A0 _4981_/A1 _4294_/S VGND VGND VPWR VPWR _4291_/X sky130_fd_sc_hd__mux2_1
XANTENNA__3298__A1 _4883_/A1 VGND VGND VPWR VPWR sky130_fd_sc_hd__diode_2
XANTENNA_hold2234_A _5815_/Q VGND VGND VPWR VPWR sky130_fd_sc_hd__diode_2
X_3242_ _3223_/B _3243_/C _3241_/Y VGND VGND VPWR VPWR _3242_/X sky130_fd_sc_hd__o21a_1
X_6030_ _6302_/CLK _6030_/D VGND VGND VPWR VPWR _6030_/Q sky130_fd_sc_hd__dfxtp_1
XFILLER_67_733 VGND VGND VPWR VPWR sky130_fd_sc_hd__fill_2
X_3173_ _4272_/S _3171_/A _5200_/A VGND VGND VPWR VPWR _3174_/B sky130_fd_sc_hd__o21ai_1
XFILLER_94_530 VGND VGND VPWR VPWR sky130_fd_sc_hd__fill_2
XFILLER_39_457 VGND VGND VPWR VPWR sky130_fd_sc_hd__fill_4
XFILLER_94_585 VGND VGND VPWR VPWR sky130_fd_sc_hd__fill_2
XFILLER_67_799 VGND VGND VPWR VPWR sky130_fd_sc_hd__fill_1
Xclkbuf_leaf_46_clk clkload4/A VGND VGND VPWR VPWR _6252_/CLK sky130_fd_sc_hd__clkbuf_8
XANTENNA__4483__X _4492_/S VGND VGND VPWR VPWR sky130_fd_sc_hd__diode_2
XTAP_TAPCELL_ROW_85_1575 VGND VPWR sky130_fd_sc_hd__tapvpwrvgnd_1
X_5814_ _5820_/CLK _5814_/D VGND VGND VPWR VPWR _5814_/Q sky130_fd_sc_hd__dfxtp_4
X_2957_ _3005_/A _2957_/B VGND VGND VPWR VPWR _2957_/X sky130_fd_sc_hd__or2_1
X_5745_ _6310_/CLK _5745_/D VGND VGND VPWR VPWR _5745_/Q sky130_fd_sc_hd__dfxtp_1
X_2888_ _2883_/X _2887_/X _2995_/A VGND VGND VPWR VPWR _2888_/Y sky130_fd_sc_hd__o21ai_1
X_5676_ _5714_/CLK _5676_/D VGND VGND VPWR VPWR _5676_/Q sky130_fd_sc_hd__dfxtp_1
XFILLER_136_749 VGND VGND VPWR VPWR sky130_fd_sc_hd__fill_4
XTAP_TAPCELL_ROW_116_2041 VGND VPWR sky130_fd_sc_hd__tapvpwrvgnd_1
X_4627_ _4791_/A1 _4626_/X _4792_/A1 VGND VGND VPWR VPWR _4627_/Y sky130_fd_sc_hd__o21ai_1
Xhold520 _5621_/Q VGND VGND VPWR VPWR hold520/X sky130_fd_sc_hd__dlygate4sd3_1
XFILLER_104_613 VPWR VGND VPWR VGND sky130_ef_sc_hd__decap_40_12
X_4558_ hold266/X _4903_/A0 _4561_/S VGND VGND VPWR VPWR _4558_/X sky130_fd_sc_hd__mux2_1
XFILLER_89_302 VGND VGND VPWR VPWR sky130_fd_sc_hd__fill_4
Xhold553 _3427_/X VGND VGND VPWR VPWR _5478_/D sky130_fd_sc_hd__dlygate4sd3_1
XANTENNA_fanout105_X _5042_/A1 VGND VGND VPWR VPWR sky130_fd_sc_hd__diode_2
Xhold542 _5982_/Q VGND VGND VPWR VPWR hold542/X sky130_fd_sc_hd__dlygate4sd3_1
Xhold531 _4322_/X VGND VGND VPWR VPWR _5969_/D sky130_fd_sc_hd__dlygate4sd3_1
Xhold564 _6073_/Q VGND VGND VPWR VPWR hold564/X sky130_fd_sc_hd__dlygate4sd3_1
Xhold597 _4470_/X VGND VGND VPWR VPWR _6078_/D sky130_fd_sc_hd__dlygate4sd3_1
Xhold586 _5306_/Q VGND VGND VPWR VPWR hold586/X sky130_fd_sc_hd__dlygate4sd3_1
Xhold575 _4553_/X VGND VGND VPWR VPWR _6153_/D sky130_fd_sc_hd__dlygate4sd3_1
XFILLER_104_657 VPWR VGND VPWR VGND sky130_ef_sc_hd__decap_40_12
X_3509_ _4886_/A1 _3509_/A1 _3516_/S VGND VGND VPWR VPWR _5553_/D sky130_fd_sc_hd__mux2_1
X_4489_ _4961_/A0 _4489_/A1 _4492_/S VGND VGND VPWR VPWR _4489_/X sky130_fd_sc_hd__mux2_1
XFILLER_131_465 VPWR VGND VPWR VGND sky130_ef_sc_hd__decap_40_12
XANTENNA__3289__A1 _4887_/A1 VGND VGND VPWR VPWR sky130_fd_sc_hd__diode_2
XFILLER_103_167 VGND VGND VPWR VPWR sky130_fd_sc_hd__fill_1
X_6228_ _6241_/CLK _6228_/D VGND VGND VPWR VPWR _6228_/Q sky130_fd_sc_hd__dfxtp_1
XANTENNA__4486__A0 _4958_/A0 VGND VGND VPWR VPWR sky130_fd_sc_hd__diode_2
X_6159_ _6241_/CLK _6159_/D VGND VGND VPWR VPWR _6159_/Q sky130_fd_sc_hd__dfxtp_1
Xhold1231 _5297_/Q VGND VGND VPWR VPWR _3102_/A0 sky130_fd_sc_hd__dlygate4sd3_1
Xhold1220 _2670_/X VGND VGND VPWR VPWR _5243_/D sky130_fd_sc_hd__dlygate4sd3_1
XANTENNA__3214__S _3220_/S VGND VGND VPWR VPWR sky130_fd_sc_hd__diode_2
XFILLER_100_841 VGND VGND VPWR VPWR sky130_fd_sc_hd__fill_1
XFILLER_97_390 VGND VGND VPWR VPWR sky130_fd_sc_hd__fill_2
Xhold1242 _5388_/Q VGND VGND VPWR VPWR _3362_/A1 sky130_fd_sc_hd__dlygate4sd3_1
Xhold1275 _5587_/Q VGND VGND VPWR VPWR _4621_/A1 sky130_fd_sc_hd__dlygate4sd3_1
Xhold1253 _4402_/X VGND VGND VPWR VPWR _6040_/D sky130_fd_sc_hd__dlygate4sd3_1
XANTENNA__4238__B1 _4252_/B1 VGND VGND VPWR VPWR sky130_fd_sc_hd__diode_2
Xhold1264 _4933_/X VGND VGND VPWR VPWR _6270_/D sky130_fd_sc_hd__dlygate4sd3_1
Xclkbuf_leaf_37_clk clkload4/A VGND VGND VPWR VPWR _6365_/CLK sky130_fd_sc_hd__clkbuf_8
XFILLER_122_43 VGND VGND VPWR VPWR sky130_fd_sc_hd__fill_1
XFILLER_73_769 VPWR VGND VPWR VGND sky130_ef_sc_hd__decap_40_12
Xhold1297 _5616_/Q VGND VGND VPWR VPWR _3580_/A0 sky130_fd_sc_hd__dlygate4sd3_1
Xhold1286 _5058_/X VGND VGND VPWR VPWR _6351_/D sky130_fd_sc_hd__dlygate4sd3_1
XFILLER_122_98 VGND VGND VPWR VPWR sky130_fd_sc_hd__fill_1
XFILLER_26_674 VGND VGND VPWR VPWR sky130_fd_sc_hd__fill_4
XANTENNA__3461__A1 _4904_/A0 VGND VGND VPWR VPWR sky130_fd_sc_hd__diode_2
XANTENNA__4045__S _4260_/S VGND VGND VPWR VPWR sky130_fd_sc_hd__diode_2
XTAP_TAPCELL_ROW_0_283 VGND VPWR sky130_fd_sc_hd__tapvpwrvgnd_1
XTAP_TAPCELL_ROW_0_294 VGND VPWR sky130_fd_sc_hd__tapvpwrvgnd_1
XFILLER_14_825 VPWR VGND VPWR VGND sky130_ef_sc_hd__decap_40_12
XFILLER_41_611 VGND VGND VPWR VPWR sky130_fd_sc_hd__fill_1
XANTENNA__5438__Q _5438_/Q VGND VGND VPWR VPWR sky130_fd_sc_hd__diode_2
XANTENNA__4410__A0 _5053_/A1 VGND VGND VPWR VPWR sky130_fd_sc_hd__diode_2
XFILLER_40_154 VGND VGND VPWR VPWR sky130_fd_sc_hd__fill_1
XFILLER_127_727 VGND VGND VPWR VPWR sky130_fd_sc_hd__fill_1
XANTENNA__2972__B1 _3075_/C1 VGND VGND VPWR VPWR sky130_fd_sc_hd__diode_2
XFILLER_5_501 VGND VGND VPWR VPWR sky130_fd_sc_hd__fill_2
XFILLER_31_95 VGND VGND VPWR VPWR sky130_fd_sc_hd__fill_1
XANTENNA__2724__B1 _5222_/A VGND VGND VPWR VPWR sky130_fd_sc_hd__diode_2
Xoutput40 _6064_/Q VGND VGND VPWR VPWR s_axil_rdata[11] sky130_fd_sc_hd__buf_2
XTAP_TAPCELL_ROW_56_1143 VGND VPWR sky130_fd_sc_hd__tapvpwrvgnd_1
Xoutput51 _5437_/Q VGND VGND VPWR VPWR s_axil_rdata[7] sky130_fd_sc_hd__buf_2
XFILLER_122_443 VGND VGND VPWR VPWR sky130_fd_sc_hd__fill_2
XANTENNA_clkbuf_leaf_94_clk_A clkbuf_leaf_9_clk/A VGND VGND VPWR VPWR sky130_fd_sc_hd__diode_2
XANTENNA__4229__B1 _4205_/A VGND VGND VPWR VPWR sky130_fd_sc_hd__diode_2
XANTENNA__2963__S _2963_/S VGND VGND VPWR VPWR sky130_fd_sc_hd__diode_2
Xclkbuf_leaf_28_clk clkload3/A VGND VGND VPWR VPWR _5820_/CLK sky130_fd_sc_hd__clkbuf_8
XFILLER_64_769 VPWR VGND VPWR VGND sky130_ef_sc_hd__decap_40_12
XFILLER_17_641 VPWR VGND VPWR VGND sky130_ef_sc_hd__decap_40_12
XANTENNA__3452__A1 _5238_/A1 VGND VGND VPWR VPWR sky130_fd_sc_hd__diode_2
XFILLER_17_685 VPWR VGND VPWR VGND sky130_ef_sc_hd__decap_40_12
X_3860_ _4513_/A _3870_/A VGND VGND VPWR VPWR _3869_/S sky130_fd_sc_hd__or2_4
XANTENNA__3204__A1 _5235_/A0 VGND VGND VPWR VPWR sky130_fd_sc_hd__diode_2
XANTENNA_clkbuf_leaf_32_clk_A clkload4/A VGND VGND VPWR VPWR sky130_fd_sc_hd__diode_2
X_2811_ hold4/X _3011_/A _2810_/X VGND VGND VPWR VPWR hold5/A sky130_fd_sc_hd__a21o_1
X_3791_ hold767/X _5210_/A1 _3797_/S VGND VGND VPWR VPWR _3791_/X sky130_fd_sc_hd__mux2_1
XANTENNA__4401__A0 _5042_/A1 VGND VGND VPWR VPWR sky130_fd_sc_hd__diode_2
X_5530_ _5571_/CLK _5530_/D VGND VGND VPWR VPWR _5530_/Q sky130_fd_sc_hd__dfxtp_1
X_2742_ hold598/X _4882_/A1 _2753_/S VGND VGND VPWR VPWR _2742_/X sky130_fd_sc_hd__mux2_1
XTAP_TAPCELL_ROW_80_1494 VGND VPWR sky130_fd_sc_hd__tapvpwrvgnd_1
XFILLER_118_749 VGND VGND VPWR VPWR sky130_fd_sc_hd__fill_4
X_5461_ _5731_/CLK _5461_/D VGND VGND VPWR VPWR _5461_/Q sky130_fd_sc_hd__dfxtp_1
X_2673_ _2673_/A0 _4903_/A0 _5241_/S VGND VGND VPWR VPWR _2673_/X sky130_fd_sc_hd__mux2_1
XANTENNA_clkbuf_leaf_47_clk_A clkload4/A VGND VGND VPWR VPWR sky130_fd_sc_hd__diode_2
X_4412_ _5827_/Q hold908/X _4416_/S VGND VGND VPWR VPWR _4412_/X sky130_fd_sc_hd__mux2_1
XANTENNA__2715__A0 _5046_/A1 VGND VGND VPWR VPWR sky130_fd_sc_hd__diode_2
X_5392_ _6420_/CLK _5392_/D VGND VGND VPWR VPWR _5392_/Q sky130_fd_sc_hd__dfxtp_1
XFILLER_126_793 VPWR VGND VPWR VGND sky130_ef_sc_hd__decap_40_12
XFILLER_125_292 VGND VGND VPWR VPWR sky130_fd_sc_hd__fill_1
XPHY_EDGE_ROW_99_Right_99 VGND VGND VPWR VPWR sky130_fd_sc_hd__decap_3
X_4343_ hold18/X _4982_/A1 _4345_/S VGND VGND VPWR VPWR hold19/A sky130_fd_sc_hd__mux2_1
XANTENNA__4468__A0 _5233_/A0 VGND VGND VPWR VPWR sky130_fd_sc_hd__diode_2
XFILLER_98_143 VGND VGND VPWR VPWR sky130_fd_sc_hd__fill_2
X_4274_ _4274_/A0 _4273_/X _4274_/S VGND VGND VPWR VPWR _4274_/X sky130_fd_sc_hd__mux2_1
XFILLER_87_839 VGND VGND VPWR VPWR sky130_fd_sc_hd__fill_1
X_3225_ _4785_/S _3244_/B _3606_/A _4802_/A _3222_/X VGND VGND VPWR VPWR _3263_/B
+ sky130_fd_sc_hd__a221o_1
X_6013_ _6349_/CLK _6013_/D VGND VGND VPWR VPWR _6013_/Q sky130_fd_sc_hd__dfxtp_1
XFILLER_79_390 VGND VGND VPWR VPWR sky130_fd_sc_hd__fill_2
XANTENNA__5811__Q _5811_/Q VGND VGND VPWR VPWR sky130_fd_sc_hd__diode_2
XANTENNA_clkbuf_leaf_105_clk_A clkload0/A VGND VGND VPWR VPWR sky130_fd_sc_hd__diode_2
XANTENNA__3140__B1 _3390_/S VGND VGND VPWR VPWR sky130_fd_sc_hd__diode_2
XTAP_TAPCELL_ROW_87_1604 VGND VPWR sky130_fd_sc_hd__tapvpwrvgnd_1
X_3156_ _5067_/A0 hold81/X _3156_/S VGND VGND VPWR VPWR _3156_/X sky130_fd_sc_hd__mux2_1
XFILLER_27_405 VPWR VGND VPWR VGND sky130_ef_sc_hd__decap_40_12
XANTENNA__4925__Y _4934_/S VGND VGND VPWR VPWR sky130_fd_sc_hd__diode_2
XFILLER_39_276 VGND VGND VPWR VPWR sky130_fd_sc_hd__fill_4
X_3087_ _3092_/A _5759_/Q VGND VGND VPWR VPWR _3087_/X sky130_fd_sc_hd__and2_1
Xclkbuf_leaf_19_clk clkload3/A VGND VGND VPWR VPWR _6394_/CLK sky130_fd_sc_hd__clkbuf_8
XPHY_EDGE_ROW_6_Left_145 VGND VGND VPWR VPWR sky130_fd_sc_hd__decap_3
XFILLER_27_449 VGND VGND VPWR VPWR sky130_fd_sc_hd__fill_4
XFILLER_42_419 VGND VGND VPWR VPWR sky130_fd_sc_hd__fill_1
XANTENNA__3443__A1 _4886_/A1 VGND VGND VPWR VPWR sky130_fd_sc_hd__diode_2
XANTENNA__4618__S1 _4789_/A VGND VGND VPWR VPWR sky130_fd_sc_hd__diode_2
XFILLER_11_839 VGND VGND VPWR VPWR sky130_fd_sc_hd__fill_1
X_5728_ _6237_/CLK _5728_/D VGND VGND VPWR VPWR _5728_/Q sky130_fd_sc_hd__dfxtp_1
X_3989_ _5117_/A _5201_/A VGND VGND VPWR VPWR _5010_/A sky130_fd_sc_hd__nand2_1
XFILLER_136_513 VPWR VGND VPWR VGND sky130_ef_sc_hd__decap_40_12
XFILLER_109_727 VGND VGND VPWR VPWR sky130_fd_sc_hd__fill_1
XFILLER_136_557 VPWR VGND VPWR VGND sky130_ef_sc_hd__decap_40_12
XANTENNA__3209__S _3220_/S VGND VGND VPWR VPWR sky130_fd_sc_hd__diode_2
XFILLER_108_248 VGND VGND VPWR VPWR sky130_fd_sc_hd__fill_1
XTAP_TAPCELL_ROW_98_1777 VGND VPWR sky130_fd_sc_hd__tapvpwrvgnd_1
XTAP_TAPCELL_ROW_98_1766 VGND VPWR sky130_fd_sc_hd__tapvpwrvgnd_1
X_5659_ _5682_/CLK _5659_/D VGND VGND VPWR VPWR _5659_/Q sky130_fd_sc_hd__dfxtp_1
XFILLER_104_421 VGND VGND VPWR VPWR sky130_fd_sc_hd__fill_4
Xhold350 _4976_/X VGND VGND VPWR VPWR _6308_/D sky130_fd_sc_hd__dlygate4sd3_1
Xhold361 _6089_/Q VGND VGND VPWR VPWR hold361/X sky130_fd_sc_hd__dlygate4sd3_1
Xhold383 _6136_/Q VGND VGND VPWR VPWR hold383/X sky130_fd_sc_hd__dlygate4sd3_1
Xhold372 _3642_/X VGND VGND VPWR VPWR _5669_/D sky130_fd_sc_hd__dlygate4sd3_1
Xhold394 _3371_/X VGND VGND VPWR VPWR _5437_/D sky130_fd_sc_hd__dlygate4sd3_1
XTAP_TAPCELL_ROW_129_2232 VGND VPWR sky130_fd_sc_hd__tapvpwrvgnd_1
XFILLER_77_47 VGND VGND VPWR VPWR sky130_fd_sc_hd__fill_8
XANTENNA__4459__B1 _4458_/X VGND VGND VPWR VPWR sky130_fd_sc_hd__diode_2
XANTENNA_fanout82_A _5212_/A1 VGND VGND VPWR VPWR sky130_fd_sc_hd__diode_2
XFILLER_93_809 VPWR VGND VPWR VGND sky130_ef_sc_hd__decap_40_12
XTAP_TAPCELL_ROW_51_1062 VGND VPWR sky130_fd_sc_hd__tapvpwrvgnd_1
Xhold1050 _5579_/Q VGND VGND VPWR VPWR _3536_/A0 sky130_fd_sc_hd__dlygate4sd3_1
XTAP_TAPCELL_ROW_5_375 VGND VPWR sky130_fd_sc_hd__tapvpwrvgnd_1
Xhold1072 _6145_/Q VGND VGND VPWR VPWR _4543_/A0 sky130_fd_sc_hd__dlygate4sd3_1
XFILLER_100_693 VGND VGND VPWR VPWR sky130_fd_sc_hd__fill_4
Xhold1061 _4875_/X VGND VGND VPWR VPWR _6225_/D sky130_fd_sc_hd__dlygate4sd3_1
XANTENNA__4564__A _4789_/A VGND VGND VPWR VPWR sky130_fd_sc_hd__diode_2
XFILLER_46_747 VGND VGND VPWR VPWR sky130_fd_sc_hd__fill_1
Xhold1094 _5733_/Q VGND VGND VPWR VPWR _4134_/A0 sky130_fd_sc_hd__dlygate4sd3_1
Xhold1083 _4411_/X VGND VGND VPWR VPWR _6048_/D sky130_fd_sc_hd__dlygate4sd3_1
XANTENNA__3434__A1 _4903_/A0 VGND VGND VPWR VPWR sky130_fd_sc_hd__diode_2
XFILLER_61_739 VGND VGND VPWR VPWR sky130_fd_sc_hd__fill_1
XFILLER_45_279 VGND VGND VPWR VPWR sky130_fd_sc_hd__fill_1
XTAP_TAPCELL_ROW_44_959 VGND VPWR sky130_fd_sc_hd__tapvpwrvgnd_1
XFILLER_13_110 VGND VGND VPWR VPWR sky130_fd_sc_hd__fill_2
XFILLER_26_493 VGND VGND VPWR VPWR sky130_fd_sc_hd__fill_1
XFILLER_14_699 VGND VGND VPWR VPWR sky130_fd_sc_hd__fill_1
XTAP_TAPCELL_ROW_24_661 VGND VPWR sky130_fd_sc_hd__tapvpwrvgnd_1
XANTENNA__4934__A1 _4984_/A1 VGND VGND VPWR VPWR sky130_fd_sc_hd__diode_2
XANTENNA__2945__B1 _2995_/A VGND VGND VPWR VPWR sky130_fd_sc_hd__diode_2
XFILLER_127_557 VGND VGND VPWR VPWR sky130_fd_sc_hd__fill_2
XANTENNA__4147__C1 _5343_/Q VGND VGND VPWR VPWR sky130_fd_sc_hd__diode_2
XFILLER_108_793 VPWR VGND VPWR VGND sky130_ef_sc_hd__decap_40_12
XANTENNA__2958__S _3062_/S VGND VGND VPWR VPWR sky130_fd_sc_hd__diode_2
XANTENNA__4698__B1 _4811_/C1 VGND VGND VPWR VPWR sky130_fd_sc_hd__diode_2
XFILLER_123_741 VPWR VGND VPWR VGND sky130_ef_sc_hd__decap_40_12
XFILLER_69_806 VPWR VGND VPWR VGND sky130_ef_sc_hd__decap_40_12
XANTENNA__3370__B1 _4994_/B VGND VGND VPWR VPWR sky130_fd_sc_hd__diode_2
XFILLER_123_785 VPWR VGND VPWR VGND sky130_ef_sc_hd__decap_40_12
XFILLER_96_625 VPWR VGND VPWR VGND sky130_ef_sc_hd__decap_40_12
XFILLER_69_839 VGND VGND VPWR VPWR sky130_fd_sc_hd__fill_1
XFILLER_3_55 VGND VGND VPWR VPWR sky130_fd_sc_hd__fill_1
XFILLER_96_669 VPWR VGND VPWR VGND sky130_ef_sc_hd__decap_40_12
X_3010_ _2967_/S _3009_/X _3003_/Y _2735_/A VGND VGND VPWR VPWR _3011_/B sky130_fd_sc_hd__o211a_1
XFILLER_67_80 VGND VGND VPWR VPWR sky130_fd_sc_hd__fill_2
XFILLER_49_574 VGND VGND VPWR VPWR sky130_fd_sc_hd__fill_1
XTAP_TAPCELL_ROW_69_1334 VGND VPWR sky130_fd_sc_hd__tapvpwrvgnd_1
XTAP_TAPCELL_ROW_82_1523 VGND VPWR sky130_fd_sc_hd__tapvpwrvgnd_1
X_4961_ _4961_/A0 _4961_/A1 _4964_/S VGND VGND VPWR VPWR _4961_/X sky130_fd_sc_hd__mux2_1
XANTENNA__4622__B1 _4791_/B1 VGND VGND VPWR VPWR sky130_fd_sc_hd__diode_2
XFILLER_24_419 VGND VGND VPWR VPWR sky130_fd_sc_hd__fill_1
X_4892_ hold653/X _4905_/A0 _4893_/S VGND VGND VPWR VPWR _4892_/X sky130_fd_sc_hd__mux2_1
XTAP_TAPCELL_ROW_82_1534 VGND VPWR sky130_fd_sc_hd__tapvpwrvgnd_1
X_3912_ hold359/X _5210_/A1 _3918_/S VGND VGND VPWR VPWR _3912_/X sky130_fd_sc_hd__mux2_1
X_3843_ input20/X _3837_/A _4922_/C _3842_/X _5200_/A VGND VGND VPWR VPWR _5835_/D
+ sky130_fd_sc_hd__o311a_1
XFILLER_20_625 VPWR VGND VPWR VGND sky130_ef_sc_hd__decap_40_12
XANTENNA__3377__X _3377_/X VGND VGND VPWR VPWR sky130_fd_sc_hd__diode_2
XANTENNA__4413__S _4416_/S VGND VGND VPWR VPWR sky130_fd_sc_hd__diode_2
XFILLER_118_513 VPWR VGND VPWR VGND sky130_ef_sc_hd__decap_40_12
X_3774_ _4982_/A1 _4191_/A0 _3776_/S VGND VGND VPWR VPWR _3774_/X sky130_fd_sc_hd__mux2_1
XFILLER_20_669 VPWR VGND VPWR VGND sky130_ef_sc_hd__decap_40_12
XFILLER_118_557 VPWR VGND VPWR VGND sky130_ef_sc_hd__decap_40_12
X_5513_ _6254_/CLK _5513_/D VGND VGND VPWR VPWR _5513_/Q sky130_fd_sc_hd__dfxtp_1
XTAP_TAPCELL_ROW_113_2000 VGND VPWR sky130_fd_sc_hd__tapvpwrvgnd_1
X_2725_ _3030_/S _2727_/C _2724_/Y VGND VGND VPWR VPWR _5266_/D sky130_fd_sc_hd__o21a_1
XFILLER_133_505 VPWR VGND VPWR VGND sky130_ef_sc_hd__decap_40_12
X_2656_ _2656_/A VGND VGND VPWR VPWR _2656_/Y sky130_fd_sc_hd__inv_2
Xclkbuf_leaf_8_clk clkbuf_leaf_9_clk/A VGND VGND VPWR VPWR _6338_/CLK sky130_fd_sc_hd__clkbuf_8
X_5444_ _5731_/CLK _5444_/D VGND VGND VPWR VPWR _5444_/Q sky130_fd_sc_hd__dfxtp_1
X_5375_ _6148_/CLK _5375_/D VGND VGND VPWR VPWR _5375_/Q sky130_fd_sc_hd__dfxtp_1
Xfanout104 _5042_/A1 VGND VGND VPWR VPWR _4929_/A1 sky130_fd_sc_hd__buf_4
XTAP_TAPCELL_ROW_93_1696 VGND VPWR sky130_fd_sc_hd__tapvpwrvgnd_1
XFILLER_87_636 VGND VGND VPWR VPWR sky130_fd_sc_hd__fill_4
Xfanout115 _5820_/Q VGND VGND VPWR VPWR _5239_/A1 sky130_fd_sc_hd__buf_4
Xfanout126 hold2231/X VGND VGND VPWR VPWR _5235_/A0 sky130_fd_sc_hd__buf_4
Xfanout137 _5400_/Q VGND VGND VPWR VPWR _4799_/A sky130_fd_sc_hd__clkbuf_4
XANTENNA__3272__B _4600_/A VGND VGND VPWR VPWR sky130_fd_sc_hd__diode_2
X_4326_ _5038_/B _4336_/B VGND VGND VPWR VPWR _4335_/S sky130_fd_sc_hd__or2_4
XFILLER_87_669 VGND VGND VPWR VPWR sky130_fd_sc_hd__fill_1
XFILLER_75_809 VPWR VGND VPWR VGND sky130_ef_sc_hd__decap_40_12
X_4257_ _6280_/Q _6271_/Q _4257_/S VGND VGND VPWR VPWR _4257_/X sky130_fd_sc_hd__mux2_1
Xfanout159 hold2237/X VGND VGND VPWR VPWR _4205_/A sky130_fd_sc_hd__buf_4
Xfanout148 _4810_/S VGND VGND VPWR VPWR _4808_/S sky130_fd_sc_hd__clkbuf_8
X_3208_ _3208_/A _5069_/B VGND VGND VPWR VPWR _3220_/S sky130_fd_sc_hd__or2_4
XFILLER_101_479 VGND VGND VPWR VPWR sky130_fd_sc_hd__fill_1
XTAP_TAPCELL_ROW_2_323 VGND VPWR sky130_fd_sc_hd__tapvpwrvgnd_1
XFILLER_28_703 VGND VGND VPWR VPWR sky130_fd_sc_hd__fill_1
X_4188_ _4169_/X _4175_/X _4187_/X _4181_/X _4260_/S _2634_/Y VGND VGND VPWR VPWR
+ _4188_/X sky130_fd_sc_hd__mux4_1
XANTENNA__4861__A0 _4887_/A1 VGND VGND VPWR VPWR sky130_fd_sc_hd__diode_2
XANTENNA__3699__S _3707_/S VGND VGND VPWR VPWR sky130_fd_sc_hd__diode_2
XTAP_TAPCELL_ROW_2_334 VGND VPWR sky130_fd_sc_hd__tapvpwrvgnd_1
X_3139_ _5050_/B _3708_/B VGND VGND VPWR VPWR _3390_/S sky130_fd_sc_hd__nor2_4
XTAP_TAPCELL_ROW_124_2162 VGND VPWR sky130_fd_sc_hd__tapvpwrvgnd_1
XFILLER_27_246 VGND VGND VPWR VPWR sky130_fd_sc_hd__fill_1
XFILLER_28_769 VPWR VGND VPWR VGND sky130_ef_sc_hd__decap_40_12
XANTENNA__3416__A1 _5209_/A1 VGND VGND VPWR VPWR sky130_fd_sc_hd__diode_2
XANTENNA__4613__B1 _4792_/A1 VGND VGND VPWR VPWR sky130_fd_sc_hd__diode_2
XFILLER_70_558 VGND VGND VPWR VPWR sky130_fd_sc_hd__fill_2
XFILLER_23_441 VGND VGND VPWR VPWR sky130_fd_sc_hd__fill_4
XFILLER_51_783 VGND VGND VPWR VPWR sky130_fd_sc_hd__fill_1
XFILLER_51_761 VPWR VGND VPWR VGND sky130_ef_sc_hd__decap_40_12
XTAP_TAPCELL_ROW_41_918 VGND VPWR sky130_fd_sc_hd__tapvpwrvgnd_1
XFILLER_10_102 VGND VGND VPWR VPWR sky130_fd_sc_hd__fill_1
XTAP_TAPCELL_ROW_21_620 VGND VPWR sky130_fd_sc_hd__tapvpwrvgnd_1
XFILLER_23_485 VGND VGND VPWR VPWR sky130_fd_sc_hd__fill_1
XFILLER_137_833 VGND VGND VPWR VPWR sky130_fd_sc_hd__fill_4
XFILLER_109_513 VPWR VGND VPWR VGND sky130_ef_sc_hd__decap_40_12
XFILLER_7_629 VPWR VGND VPWR VGND sky130_ef_sc_hd__decap_40_12
XFILLER_11_669 VGND VGND VPWR VPWR sky130_fd_sc_hd__fill_2
XFILLER_109_557 VGND VGND VPWR VPWR sky130_fd_sc_hd__fill_2
XFILLER_105_741 VPWR VGND VPWR VGND sky130_ef_sc_hd__decap_40_12
XTAP_TAPCELL_ROW_53_1102 VGND VPWR sky130_fd_sc_hd__tapvpwrvgnd_1
Xhold180 _4303_/X VGND VGND VPWR VPWR _5953_/D sky130_fd_sc_hd__dlygate4sd3_1
XFILLER_5_3 VPWR VGND VPWR VGND sky130_ef_sc_hd__decap_40_12
XANTENNA__3352__B1 _5201_/B VGND VGND VPWR VPWR sky130_fd_sc_hd__diode_2
Xhold191 _5410_/Q VGND VGND VPWR VPWR hold191/X sky130_fd_sc_hd__dlygate4sd3_1
XFILLER_105_785 VPWR VGND VPWR VGND sky130_ef_sc_hd__decap_40_12
XFILLER_104_251 VGND VGND VPWR VPWR sky130_fd_sc_hd__fill_1
XANTENNA_fanout85_X _5211_/A1 VGND VGND VPWR VPWR sky130_fd_sc_hd__diode_2
XFILLER_120_755 VGND VGND VPWR VPWR sky130_fd_sc_hd__fill_1
XFILLER_78_669 VGND VGND VPWR VPWR sky130_fd_sc_hd__fill_4
XANTENNA__4993__S _4993_/S VGND VGND VPWR VPWR sky130_fd_sc_hd__diode_2
XFILLER_93_617 VPWR VGND VPWR VGND sky130_ef_sc_hd__decap_40_12
XPHY_EDGE_ROW_69_Left_208 VGND VGND VPWR VPWR sky130_fd_sc_hd__decap_3
XFILLER_65_319 VGND VGND VPWR VPWR sky130_fd_sc_hd__fill_1
XTAP_TAPCELL_ROW_109_1935 VGND VPWR sky130_fd_sc_hd__tapvpwrvgnd_1
XANTENNA__4852__A0 _4904_/A0 VGND VGND VPWR VPWR sky130_fd_sc_hd__diode_2
XANTENNA__3655__A1 _3926_/A1 VGND VGND VPWR VPWR sky130_fd_sc_hd__diode_2
XFILLER_19_725 VGND VGND VPWR VPWR sky130_fd_sc_hd__fill_2
XTAP_TAPCELL_ROW_29_731 VGND VPWR sky130_fd_sc_hd__tapvpwrvgnd_1
XFILLER_18_257 VGND VGND VPWR VPWR sky130_fd_sc_hd__fill_2
XTAP_TAPCELL_ROW_29_742 VGND VPWR sky130_fd_sc_hd__tapvpwrvgnd_1
XFILLER_37_61 VGND VGND VPWR VPWR sky130_fd_sc_hd__fill_1
XFILLER_73_396 VGND VGND VPWR VPWR sky130_fd_sc_hd__fill_1
XFILLER_42_750 VGND VGND VPWR VPWR sky130_fd_sc_hd__fill_2
XTAP_TAPCELL_ROW_64_1264 VGND VPWR sky130_fd_sc_hd__tapvpwrvgnd_1
XTAP_TAPCELL_ROW_64_1253 VGND VPWR sky130_fd_sc_hd__tapvpwrvgnd_1
XPHY_EDGE_ROW_78_Left_217 VGND VGND VPWR VPWR sky130_fd_sc_hd__decap_3
XFILLER_128_811 VGND VGND VPWR VPWR sky130_fd_sc_hd__fill_1
XFILLER_115_505 VPWR VGND VPWR VGND sky130_ef_sc_hd__decap_40_12
X_3490_ _3490_/A0 _4906_/A0 _3490_/S VGND VGND VPWR VPWR _3490_/X sky130_fd_sc_hd__mux2_1
XPHY_EDGE_ROW_87_Left_226 VGND VGND VPWR VPWR sky130_fd_sc_hd__decap_3
XANTENNA__3894__A1 _6413_/Q VGND VGND VPWR VPWR sky130_fd_sc_hd__diode_2
X_5160_ _5160_/A _5160_/B VGND VGND VPWR VPWR _5160_/Y sky130_fd_sc_hd__nand2_1
XANTENNA_hold2147_A _6410_/Q VGND VGND VPWR VPWR sky130_fd_sc_hd__diode_2
XFILLER_38_3 VPWR VGND VPWR VGND sky130_ef_sc_hd__decap_40_12
Xhold1808 _5092_/X VGND VGND VPWR VPWR _6380_/D sky130_fd_sc_hd__dlygate4sd3_1
X_5091_ _5091_/A0 hold987/X _5094_/S VGND VGND VPWR VPWR _5091_/X sky130_fd_sc_hd__mux2_1
XFILLER_57_809 VPWR VGND VPWR VGND sky130_ef_sc_hd__decap_40_12
X_4111_ _4241_/A _4111_/B VGND VGND VPWR VPWR _4111_/Y sky130_fd_sc_hd__nor2_1
Xhold1819 _3476_/X VGND VGND VPWR VPWR _5523_/D sky130_fd_sc_hd__dlygate4sd3_1
XFILLER_111_777 VGND VGND VPWR VPWR sky130_fd_sc_hd__fill_4
X_4042_ _4252_/A1 _4041_/X _3172_/B VGND VGND VPWR VPWR _4042_/Y sky130_fd_sc_hd__o21ai_1
XANTENNA__4843__A0 _5238_/A1 VGND VGND VPWR VPWR sky130_fd_sc_hd__diode_2
XANTENNA__3646__A1 _4521_/A1 VGND VGND VPWR VPWR sky130_fd_sc_hd__diode_2
Xi2c_master_axil_208 VGND VGND VPWR VPWR i2c_master_axil_208/HI s_axil_bresp[0] sky130_fd_sc_hd__conb_1
XFILLER_64_341 VGND VGND VPWR VPWR sky130_fd_sc_hd__fill_4
XANTENNA__4408__S _4416_/S VGND VGND VPWR VPWR sky130_fd_sc_hd__diode_2
Xi2c_master_axil_219 VGND VGND VPWR VPWR i2c_master_axil_219/HI s_axil_rdata[25] sky130_fd_sc_hd__conb_1
X_5993_ _6347_/CLK _5993_/D VGND VGND VPWR VPWR _5993_/Q sky130_fd_sc_hd__dfxtp_1
X_4944_ _4984_/A1 _4944_/A1 _4944_/S VGND VGND VPWR VPWR _4944_/X sky130_fd_sc_hd__mux2_1
XPHY_EDGE_ROW_96_Left_235 VGND VGND VPWR VPWR sky130_fd_sc_hd__decap_3
XFILLER_33_783 VGND VGND VPWR VPWR sky130_fd_sc_hd__fill_1
XANTENNA__5239__S _5241_/S VGND VGND VPWR VPWR sky130_fd_sc_hd__diode_2
X_4875_ _4875_/A0 _4901_/A0 _4880_/S VGND VGND VPWR VPWR _4875_/X sky130_fd_sc_hd__mux2_1
XFILLER_20_433 VPWR VGND VPWR VGND sky130_ef_sc_hd__decap_40_12
X_3826_ input20/X _5053_/A1 _3835_/S VGND VGND VPWR VPWR _5825_/D sky130_fd_sc_hd__mux2_1
XFILLER_119_833 VGND VGND VPWR VPWR sky130_fd_sc_hd__fill_4
XANTENNA__3031__C1 _3089_/C1 VGND VGND VPWR VPWR sky130_fd_sc_hd__diode_2
XFILLER_20_477 VPWR VGND VPWR VGND sky130_ef_sc_hd__decap_40_12
X_3757_ _4965_/A _4975_/B VGND VGND VPWR VPWR _3766_/S sky130_fd_sc_hd__nor2_4
XFILLER_134_825 VPWR VGND VPWR VGND sky130_ef_sc_hd__decap_40_12
XTAP_TAPCELL_ROW_95_1725 VGND VPWR sky130_fd_sc_hd__tapvpwrvgnd_1
X_2708_ _5823_/Q _2708_/A1 _2716_/S VGND VGND VPWR VPWR _2708_/X sky130_fd_sc_hd__mux2_1
X_3688_ _5202_/A1 _3688_/A1 _3688_/S VGND VGND VPWR VPWR _3688_/X sky130_fd_sc_hd__mux2_1
X_2639_ _2735_/A VGND VGND VPWR VPWR _2981_/S sky130_fd_sc_hd__inv_2
X_5427_ _6409_/CLK _5427_/D VGND VGND VPWR VPWR _5427_/Q sky130_fd_sc_hd__dfxtp_1
XTAP_TAPCELL_ROW_7_404 VGND VPWR sky130_fd_sc_hd__tapvpwrvgnd_1
X_5358_ _6148_/CLK _5358_/D VGND VGND VPWR VPWR _5358_/Q sky130_fd_sc_hd__dfxtp_1
XANTENNA__3885__A1 _6414_/Q VGND VGND VPWR VPWR sky130_fd_sc_hd__diode_2
XFILLER_58_27 VGND VGND VPWR VPWR sky130_fd_sc_hd__fill_1
XFILLER_102_755 VGND VGND VPWR VPWR sky130_fd_sc_hd__fill_1
X_4309_ hold741/X _5053_/A1 _4315_/S VGND VGND VPWR VPWR _4309_/X sky130_fd_sc_hd__mux2_1
X_5289_ _6398_/CLK _5289_/D VGND VGND VPWR VPWR _5289_/Q sky130_fd_sc_hd__dfxtp_1
XANTENNA__4834__A0 _4886_/A1 VGND VGND VPWR VPWR sky130_fd_sc_hd__diode_2
XANTENNA__3637__A1 _5202_/A1 VGND VGND VPWR VPWR sky130_fd_sc_hd__diode_2
XFILLER_74_149 VGND VGND VPWR VPWR sky130_fd_sc_hd__fill_2
XFILLER_71_801 VPWR VGND VPWR VGND sky130_ef_sc_hd__decap_40_12
XANTENNA__2627__A _3278_/A VGND VGND VPWR VPWR sky130_fd_sc_hd__diode_2
XANTENNA__4842__A _5069_/B VGND VGND VPWR VPWR sky130_fd_sc_hd__diode_2
XTAP_TAPCELL_ROW_104_1865 VGND VPWR sky130_fd_sc_hd__tapvpwrvgnd_1
XTAP_TAPCELL_ROW_104_1854 VGND VPWR sky130_fd_sc_hd__tapvpwrvgnd_1
XTAP_TAPCELL_ROW_137_2353 VGND VPWR sky130_fd_sc_hd__tapvpwrvgnd_1
XFILLER_128_107 VGND VGND VPWR VPWR sky130_fd_sc_hd__fill_1
XFILLER_137_641 VPWR VGND VPWR VGND sky130_ef_sc_hd__decap_40_12
XANTENNA__4988__S _4993_/S VGND VGND VPWR VPWR sky130_fd_sc_hd__diode_2
XANTENNA__3892__S _3899_/S VGND VGND VPWR VPWR sky130_fd_sc_hd__diode_2
XFILLER_137_685 VPWR VGND VPWR VGND sky130_ef_sc_hd__decap_40_12
XANTENNA__4748__S0 _4803_/S VGND VGND VPWR VPWR sky130_fd_sc_hd__diode_2
XFILLER_3_665 VGND VGND VPWR VPWR sky130_fd_sc_hd__fill_4
XFILLER_120_530 VGND VGND VPWR VPWR sky130_fd_sc_hd__fill_2
XANTENNA__5078__A0 _5234_/A0 VGND VGND VPWR VPWR sky130_fd_sc_hd__diode_2
XFILLER_2_186 VGND VGND VPWR VPWR sky130_fd_sc_hd__fill_1
XFILLER_39_809 VPWR VGND VPWR VGND sky130_ef_sc_hd__decap_40_12
XFILLER_66_628 VPWR VGND VPWR VGND sky130_ef_sc_hd__decap_40_12
XFILLER_120_585 VGND VGND VPWR VPWR sky130_fd_sc_hd__fill_2
XANTENNA__3089__C1 _3089_/C1 VGND VGND VPWR VPWR sky130_fd_sc_hd__diode_2
XFILLER_93_447 VGND VGND VPWR VPWR sky130_fd_sc_hd__fill_1
XANTENNA__4825__A0 _5813_/Q VGND VGND VPWR VPWR sky130_fd_sc_hd__diode_2
XANTENNA__4228__S _4228_/S VGND VGND VPWR VPWR sky130_fd_sc_hd__diode_2
XFILLER_80_119 VGND VGND VPWR VPWR sky130_fd_sc_hd__fill_1
XFILLER_74_694 VGND VGND VPWR VPWR sky130_fd_sc_hd__fill_4
XFILLER_46_363 VGND VGND VPWR VPWR sky130_fd_sc_hd__fill_1
XANTENNA__2971__S _3072_/S VGND VGND VPWR VPWR sky130_fd_sc_hd__diode_2
XFILLER_64_81 VGND VGND VPWR VPWR sky130_fd_sc_hd__fill_1
XANTENNA__4752__A _4809_/A VGND VGND VPWR VPWR sky130_fd_sc_hd__diode_2
XANTENNA__4589__C1 _3278_/A VGND VGND VPWR VPWR sky130_fd_sc_hd__diode_2
X_2990_ _3020_/A _2990_/B VGND VGND VPWR VPWR _2990_/Y sky130_fd_sc_hd__nor2_1
XANTENNA__4053__A1 _4149_/A VGND VGND VPWR VPWR sky130_fd_sc_hd__diode_2
XANTENNA__3800__A1 _5176_/A VGND VGND VPWR VPWR sky130_fd_sc_hd__diode_2
XANTENNA__5059__S _5059_/S VGND VGND VPWR VPWR sky130_fd_sc_hd__diode_2
XFILLER_15_783 VGND VGND VPWR VPWR sky130_fd_sc_hd__fill_1
X_4660_ _4799_/A _4660_/B VGND VGND VPWR VPWR _4660_/Y sky130_fd_sc_hd__nor2_1
XANTENNA__4898__S _4906_/S VGND VGND VPWR VPWR sky130_fd_sc_hd__diode_2
XFILLER_128_641 VGND VGND VPWR VPWR sky130_fd_sc_hd__fill_2
XANTENNA__2779__A1_N _3096_/A1 VGND VGND VPWR VPWR sky130_fd_sc_hd__diode_2
X_3611_ hold592/X _5211_/A1 _3616_/S VGND VGND VPWR VPWR _3611_/X sky130_fd_sc_hd__mux2_1
X_4591_ _4591_/A1 _4676_/A _4575_/X _4590_/Y VGND VGND VPWR VPWR _4591_/X sky130_fd_sc_hd__a22o_1
X_6330_ _6418_/CLK _6330_/D VGND VGND VPWR VPWR _6330_/Q sky130_fd_sc_hd__dfxtp_1
XTAP_TAPCELL_ROW_12_483 VGND VPWR sky130_fd_sc_hd__tapvpwrvgnd_1
XFILLER_116_825 VPWR VGND VPWR VGND sky130_ef_sc_hd__decap_40_12
Xhold927 _3429_/X VGND VGND VPWR VPWR _5480_/D sky130_fd_sc_hd__dlygate4sd3_1
Xhold916 _5629_/Q VGND VGND VPWR VPWR hold916/X sky130_fd_sc_hd__dlygate4sd3_1
XTAP_TAPCELL_ROW_77_1455 VGND VPWR sky130_fd_sc_hd__tapvpwrvgnd_1
X_3542_ _3585_/A _3668_/C _5384_/Q VGND VGND VPWR VPWR _4955_/A sky130_fd_sc_hd__or3b_4
Xhold905 _4929_/X VGND VGND VPWR VPWR _6266_/D sky130_fd_sc_hd__dlygate4sd3_1
Xhold938 _6243_/Q VGND VGND VPWR VPWR hold938/X sky130_fd_sc_hd__dlygate4sd3_1
X_3473_ _4889_/A1 _3473_/A1 _3477_/S VGND VGND VPWR VPWR _3473_/X sky130_fd_sc_hd__mux2_1
Xhold949 _3576_/X VGND VGND VPWR VPWR _5612_/D sky130_fd_sc_hd__dlygate4sd3_1
X_6261_ _6261_/CLK _6261_/D VGND VGND VPWR VPWR _6261_/Q sky130_fd_sc_hd__dfxtp_1
X_6192_ _6241_/CLK _6192_/D VGND VGND VPWR VPWR _6192_/Q sky130_fd_sc_hd__dfxtp_1
XFILLER_69_411 VGND VGND VPWR VPWR sky130_fd_sc_hd__fill_1
X_5212_ _5212_/A0 _5212_/A1 _5213_/S VGND VGND VPWR VPWR _6414_/D sky130_fd_sc_hd__mux2_1
XFILLER_97_753 VPWR VGND VPWR VGND sky130_ef_sc_hd__decap_40_12
XTAP_TAPCELL_ROW_90_1655 VGND VPWR sky130_fd_sc_hd__tapvpwrvgnd_1
XTAP_TAPCELL_ROW_90_1644 VGND VPWR sky130_fd_sc_hd__tapvpwrvgnd_1
X_5143_ _5837_/Q _5836_/Q _5194_/S VGND VGND VPWR VPWR _5143_/X sky130_fd_sc_hd__mux2_1
XFILLER_111_541 VPWR VGND VPWR VGND sky130_ef_sc_hd__decap_40_12
Xhold1605 _3507_/X VGND VGND VPWR VPWR _5551_/D sky130_fd_sc_hd__dlygate4sd3_1
Xhold1616 _4832_/X VGND VGND VPWR VPWR _6185_/D sky130_fd_sc_hd__dlygate4sd3_1
X_5074_ _5817_/Q _5074_/A1 _5081_/S VGND VGND VPWR VPWR _5074_/X sky130_fd_sc_hd__mux2_1
Xhold1649 _4468_/X VGND VGND VPWR VPWR _6076_/D sky130_fd_sc_hd__dlygate4sd3_1
XFILLER_111_585 VPWR VGND VPWR VGND sky130_ef_sc_hd__decap_40_12
XFILLER_97_797 VPWR VGND VPWR VGND sky130_ef_sc_hd__decap_40_12
XFILLER_84_425 VGND VGND VPWR VPWR sky130_fd_sc_hd__fill_2
Xhold1627 _6298_/Q VGND VGND VPWR VPWR _4964_/A1 sky130_fd_sc_hd__dlygate4sd3_1
Xhold1638 _5555_/Q VGND VGND VPWR VPWR _3511_/A1 sky130_fd_sc_hd__dlygate4sd3_1
XANTENNA__3619__A1 _4484_/A0 VGND VGND VPWR VPWR sky130_fd_sc_hd__diode_2
X_4025_ _5946_/Q _6334_/Q _4228_/S VGND VGND VPWR VPWR _4026_/B sky130_fd_sc_hd__mux2_1
XANTENNA__4292__A1 _4982_/A1 VGND VGND VPWR VPWR sky130_fd_sc_hd__diode_2
XTAP_TAPCELL_ROW_121_2110 VGND VPWR sky130_fd_sc_hd__tapvpwrvgnd_1
XFILLER_25_503 VGND VGND VPWR VPWR sky130_fd_sc_hd__fill_1
XFILLER_37_352 VGND VGND VPWR VPWR sky130_fd_sc_hd__fill_1
XTAP_TAPCELL_ROW_121_2121 VGND VPWR sky130_fd_sc_hd__tapvpwrvgnd_1
XFILLER_64_193 VGND VGND VPWR VPWR sky130_fd_sc_hd__fill_2
XFILLER_52_355 VGND VGND VPWR VPWR sky130_fd_sc_hd__fill_1
XFILLER_13_709 VPWR VGND VPWR VGND sky130_ef_sc_hd__decap_40_12
X_5976_ clkload7/A _5976_/D VGND VGND VPWR VPWR _5976_/Q sky130_fd_sc_hd__dfxtp_1
XFILLER_80_697 VGND VGND VPWR VPWR sky130_fd_sc_hd__fill_2
XANTENNA__3278__A _3278_/A VGND VGND VPWR VPWR sky130_fd_sc_hd__diode_2
X_4927_ _4927_/A0 _5052_/A1 _4934_/S VGND VGND VPWR VPWR _4927_/X sky130_fd_sc_hd__mux2_1
X_4858_ _4445_/A _4858_/A1 _4867_/S VGND VGND VPWR VPWR _4858_/X sky130_fd_sc_hd__mux2_1
XANTENNA_fanout135_X _4887_/A1 VGND VGND VPWR VPWR sky130_fd_sc_hd__diode_2
XFILLER_21_753 VPWR VGND VPWR VGND sky130_ef_sc_hd__decap_40_12
X_3809_ input23/X _5080_/A0 _3810_/S VGND VGND VPWR VPWR _5815_/D sky130_fd_sc_hd__mux2_1
XFILLER_21_797 VPWR VGND VPWR VGND sky130_ef_sc_hd__decap_40_12
XTAP_TAPCELL_ROW_31_770 VGND VPWR sky130_fd_sc_hd__tapvpwrvgnd_1
XFILLER_119_641 VPWR VGND VPWR VGND sky130_ef_sc_hd__decap_40_12
XTAP_TAPCELL_ROW_119_2083 VGND VPWR sky130_fd_sc_hd__tapvpwrvgnd_1
X_4789_ _4789_/A _4789_/B VGND VGND VPWR VPWR _4789_/X sky130_fd_sc_hd__or2_1
XANTENNA__3555__A0 _4484_/A0 VGND VGND VPWR VPWR sky130_fd_sc_hd__diode_2
XANTENNA__4601__S _4803_/S VGND VGND VPWR VPWR sky130_fd_sc_hd__diode_2
XFILLER_119_685 VPWR VGND VPWR VGND sky130_ef_sc_hd__decap_40_12
XTAP_TAPCELL_ROW_132_2283 VGND VPWR sky130_fd_sc_hd__tapvpwrvgnd_1
XFILLER_118_195 VGND VGND VPWR VPWR sky130_fd_sc_hd__fill_1
XANTENNA__3217__S _3220_/S VGND VGND VPWR VPWR sky130_fd_sc_hd__diode_2
X_6459_ _6459_/A VGND VGND VPWR VPWR _6459_/X sky130_fd_sc_hd__clkbuf_1
XFILLER_134_699 VGND VGND VPWR VPWR sky130_fd_sc_hd__fill_1
XFILLER_0_613 VGND VGND VPWR VPWR sky130_fd_sc_hd__fill_2
XFILLER_88_753 VGND VGND VPWR VPWR sky130_fd_sc_hd__fill_2
XANTENNA__3858__B2 _4451_/A VGND VGND VPWR VPWR sky130_fd_sc_hd__diode_2
XFILLER_0_657 VPWR VGND VPWR VGND sky130_ef_sc_hd__decap_40_12
XFILLER_102_585 VGND VGND VPWR VPWR sky130_fd_sc_hd__fill_2
XFILLER_48_639 VGND VGND VPWR VPWR sky130_fd_sc_hd__fill_1
XFILLER_75_469 VGND VGND VPWR VPWR sky130_fd_sc_hd__fill_1
XANTENNA__4283__A1 _5046_/A1 VGND VGND VPWR VPWR sky130_fd_sc_hd__diode_2
XFILLER_55_160 VGND VGND VPWR VPWR sky130_fd_sc_hd__fill_1
XFILLER_16_525 VGND VGND VPWR VPWR sky130_fd_sc_hd__fill_4
XTAP_TAPCELL_ROW_39_881 VGND VPWR sky130_fd_sc_hd__tapvpwrvgnd_1
XFILLER_83_480 VGND VGND VPWR VPWR sky130_fd_sc_hd__fill_2
XTAP_TAPCELL_ROW_48_1023 VGND VPWR sky130_fd_sc_hd__tapvpwrvgnd_1
XFILLER_43_311 VGND VGND VPWR VPWR sky130_fd_sc_hd__fill_1
XFILLER_28_385 VPWR VGND VPWR VGND sky130_ef_sc_hd__decap_40_12
XTAP_TAPCELL_ROW_39_892 VGND VPWR sky130_fd_sc_hd__tapvpwrvgnd_1
XANTENNA__5232__A0 _5232_/A0 VGND VGND VPWR VPWR sky130_fd_sc_hd__diode_2
XFILLER_70_141 VGND VGND VPWR VPWR sky130_fd_sc_hd__fill_1
XFILLER_16_569 VPWR VGND VPWR VGND sky130_ef_sc_hd__decap_40_12
XTAP_TAPCELL_ROW_61_1212 VGND VPWR sky130_fd_sc_hd__tapvpwrvgnd_1
XFILLER_31_528 VGND VGND VPWR VPWR sky130_fd_sc_hd__fill_1
XFILLER_34_51 VGND VGND VPWR VPWR sky130_fd_sc_hd__fill_2
XFILLER_8_713 VPWR VGND VPWR VGND sky130_ef_sc_hd__decap_40_12
XFILLER_12_753 VGND VGND VPWR VPWR sky130_fd_sc_hd__fill_2
XFILLER_129_449 VGND VGND VPWR VPWR sky130_fd_sc_hd__fill_4
XFILLER_8_757 VPWR VGND VPWR VGND sky130_ef_sc_hd__decap_40_12
XANTENNA__4743__C1 _3278_/A VGND VGND VPWR VPWR sky130_fd_sc_hd__diode_2
XFILLER_113_839 VGND VGND VPWR VPWR sky130_fd_sc_hd__fill_1
XTAP_TAPCELL_ROW_59_1185 VGND VPWR sky130_fd_sc_hd__tapvpwrvgnd_1
XFILLER_3_473 VPWR VGND VPWR VGND sky130_ef_sc_hd__decap_40_12
XFILLER_94_701 VPWR VGND VPWR VGND sky130_ef_sc_hd__decap_40_12
XTAP_TAPCELL_ROW_72_1385 VGND VPWR sky130_fd_sc_hd__tapvpwrvgnd_1
XTAP_TAPCELL_ROW_72_1374 VGND VPWR sky130_fd_sc_hd__tapvpwrvgnd_1
XFILLER_79_797 VPWR VGND VPWR VGND sky130_ef_sc_hd__decap_40_12
XFILLER_38_105 VGND VGND VPWR VPWR sky130_fd_sc_hd__fill_1
XFILLER_93_277 VGND VGND VPWR VPWR sky130_fd_sc_hd__fill_2
X_5830_ _6342_/CLK _5830_/D VGND VGND VPWR VPWR _5830_/Q sky130_fd_sc_hd__dfxtp_2
XTAP_TAPCELL_ROW_17_553 VGND VPWR sky130_fd_sc_hd__tapvpwrvgnd_1
X_2973_ _3076_/A1 _2968_/X _2970_/X _2972_/X VGND VGND VPWR VPWR _2973_/X sky130_fd_sc_hd__a22o_1
XFILLER_62_697 VGND VGND VPWR VPWR sky130_fd_sc_hd__fill_2
XFILLER_61_196 VGND VGND VPWR VPWR sky130_fd_sc_hd__fill_1
XFILLER_50_837 VGND VGND VPWR VPWR sky130_fd_sc_hd__fill_4
X_5761_ _6307_/CLK _5761_/D VGND VGND VPWR VPWR _5761_/Q sky130_fd_sc_hd__dfxtp_1
X_4712_ _5848_/Q hold918/X _4795_/S VGND VGND VPWR VPWR _4712_/X sky130_fd_sc_hd__mux2_1
X_5692_ _6098_/CLK _5692_/D VGND VGND VPWR VPWR _5692_/Q sky130_fd_sc_hd__dfxtp_1
X_4643_ _5713_/Q _5704_/Q _5695_/Q _5899_/Q _4808_/S _4809_/A VGND VGND VPWR VPWR
+ _4643_/X sky130_fd_sc_hd__mux4_1
Xhold702 _5488_/Q VGND VGND VPWR VPWR hold702/X sky130_fd_sc_hd__dlygate4sd3_1
XANTENNA__2730__A _5222_/A VGND VGND VPWR VPWR sky130_fd_sc_hd__diode_2
X_4574_ _4799_/A _4574_/B VGND VGND VPWR VPWR _4574_/Y sky130_fd_sc_hd__nor2_1
X_3525_ _4889_/A1 _3525_/A1 _3529_/S VGND VGND VPWR VPWR _3525_/X sky130_fd_sc_hd__mux2_1
Xhold746 _3448_/X VGND VGND VPWR VPWR _5498_/D sky130_fd_sc_hd__dlygate4sd3_1
XANTENNA__5814__Q _5814_/Q VGND VGND VPWR VPWR sky130_fd_sc_hd__diode_2
Xhold724 _5868_/Q VGND VGND VPWR VPWR hold724/X sky130_fd_sc_hd__dlygate4sd3_1
Xhold735 _5940_/Q VGND VGND VPWR VPWR hold735/X sky130_fd_sc_hd__dlygate4sd3_1
Xhold713 _3393_/X VGND VGND VPWR VPWR _5450_/D sky130_fd_sc_hd__dlygate4sd3_1
X_6313_ _6313_/CLK _6313_/D VGND VGND VPWR VPWR _6313_/Q sky130_fd_sc_hd__dfxtp_1
X_6244_ _6432_/CLK _6244_/D VGND VGND VPWR VPWR _6244_/Q sky130_fd_sc_hd__dfxtp_1
XPHY_EDGE_ROW_123_Right_123 VGND VGND VPWR VPWR sky130_fd_sc_hd__decap_3
Xhold779 _6147_/Q VGND VGND VPWR VPWR hold779/X sky130_fd_sc_hd__dlygate4sd3_1
XFILLER_116_699 VGND VGND VPWR VPWR sky130_fd_sc_hd__fill_1
XFILLER_115_165 VGND VGND VPWR VPWR sky130_fd_sc_hd__fill_1
Xhold757 _5481_/Q VGND VGND VPWR VPWR hold757/X sky130_fd_sc_hd__dlygate4sd3_1
XFILLER_89_517 VGND VGND VPWR VPWR sky130_fd_sc_hd__fill_2
Xhold768 _3791_/X VGND VGND VPWR VPWR _5798_/D sky130_fd_sc_hd__dlygate4sd3_1
X_3456_ _3456_/A0 _4899_/A0 _3463_/S VGND VGND VPWR VPWR _3456_/X sky130_fd_sc_hd__mux2_1
Xhold2103 _5253_/Q VGND VGND VPWR VPWR _2645_/A sky130_fd_sc_hd__dlygate4sd3_1
XFILLER_131_669 VGND VGND VPWR VPWR sky130_fd_sc_hd__fill_2
X_6175_ _6232_/CLK _6175_/D VGND VGND VPWR VPWR _6175_/Q sky130_fd_sc_hd__dfxtp_1
XFILLER_97_561 VPWR VGND VPWR VGND sky130_ef_sc_hd__decap_40_12
Xhold2114 _5068_/X VGND VGND VPWR VPWR _6360_/D sky130_fd_sc_hd__dlygate4sd3_1
Xhold2125 _5126_/X VGND VGND VPWR VPWR _6389_/D sky130_fd_sc_hd__dlygate4sd3_1
Xhold2136 _6460_/A VGND VGND VPWR VPWR _5032_/A1 sky130_fd_sc_hd__dlygate4sd3_1
X_3387_ hold920/X _5044_/A1 _3390_/S VGND VGND VPWR VPWR _3387_/X sky130_fd_sc_hd__mux2_1
X_5126_ _5126_/A1 _5160_/A _5125_/Y _5200_/A VGND VGND VPWR VPWR _5126_/X sky130_fd_sc_hd__o211a_1
Xhold1424 _2716_/X VGND VGND VPWR VPWR _5264_/D sky130_fd_sc_hd__dlygate4sd3_1
Xhold2158 _5201_/A VGND VGND VPWR VPWR _5099_/B sky130_fd_sc_hd__dlygate4sd3_1
Xhold2147 _6410_/Q VGND VGND VPWR VPWR hold2147/X sky130_fd_sc_hd__dlygate4sd3_1
Xhold2169 _5918_/Q VGND VGND VPWR VPWR _4013_/B sky130_fd_sc_hd__dlygate4sd3_1
Xhold1413 _5732_/Q VGND VGND VPWR VPWR _4104_/A0 sky130_fd_sc_hd__dlygate4sd3_1
Xhold1402 _3796_/X VGND VGND VPWR VPWR _5803_/D sky130_fd_sc_hd__dlygate4sd3_1
Xhold1435 _5545_/Q VGND VGND VPWR VPWR _3500_/A1 sky130_fd_sc_hd__dlygate4sd3_1
XFILLER_111_393 VGND VGND VPWR VPWR sky130_fd_sc_hd__fill_1
Xhold1457 _5594_/Q VGND VGND VPWR VPWR _4565_/A0 sky130_fd_sc_hd__dlygate4sd3_1
X_5057_ hold117/X _5829_/Q _5059_/S VGND VGND VPWR VPWR _5057_/X sky130_fd_sc_hd__mux2_1
XFILLER_45_609 VGND VGND VPWR VPWR sky130_fd_sc_hd__fill_1
Xhold1468 _3716_/X VGND VGND VPWR VPWR _5736_/D sky130_fd_sc_hd__dlygate4sd3_1
Xhold1446 _3724_/X VGND VGND VPWR VPWR _5742_/D sky130_fd_sc_hd__dlygate4sd3_1
XFILLER_84_288 VGND VGND VPWR VPWR sky130_fd_sc_hd__fill_4
Xhold1479 _6377_/Q VGND VGND VPWR VPWR _5089_/A0 sky130_fd_sc_hd__dlygate4sd3_1
X_4008_ _5123_/A _3958_/Y _4008_/B1 _5034_/B VGND VGND VPWR VPWR _5917_/D sky130_fd_sc_hd__o211a_1
XANTENNA__3500__S _3503_/S VGND VGND VPWR VPWR sky130_fd_sc_hd__diode_2
XANTENNA__2905__A _2962_/A VGND VGND VPWR VPWR sky130_fd_sc_hd__diode_2
XFILLER_53_664 VGND VGND VPWR VPWR sky130_fd_sc_hd__fill_1
XFILLER_13_517 VPWR VGND VPWR VGND sky130_ef_sc_hd__decap_40_12
XTAP_TAPCELL_ROW_36_840 VGND VPWR sky130_fd_sc_hd__tapvpwrvgnd_1
XTAP_TAPCELL_ROW_101_1813 VGND VPWR sky130_fd_sc_hd__tapvpwrvgnd_1
X_5959_ _6334_/CLK _5959_/D VGND VGND VPWR VPWR _5959_/Q sky130_fd_sc_hd__dfxtp_1
XFILLER_25_377 VPWR VGND VPWR VGND sky130_ef_sc_hd__decap_40_12
XFILLER_41_837 VGND VGND VPWR VPWR sky130_fd_sc_hd__fill_2
XANTENNA__3776__A0 _4984_/A1 VGND VGND VPWR VPWR sky130_fd_sc_hd__diode_2
XFILLER_21_561 VPWR VGND VPWR VGND sky130_ef_sc_hd__decap_40_12
XTAP_TAPCELL_ROW_134_2312 VGND VPWR sky130_fd_sc_hd__tapvpwrvgnd_1
XANTENNA__3528__A0 _5815_/Q VGND VGND VPWR VPWR sky130_fd_sc_hd__diode_2
XFILLER_5_727 VGND VGND VPWR VPWR sky130_fd_sc_hd__fill_1
XFILLER_105_3 VPWR VGND VPWR VGND sky130_ef_sc_hd__decap_40_12
XFILLER_136_53 VPWR VGND VPWR VGND sky130_ef_sc_hd__decap_40_12
XFILLER_134_474 VGND VGND VPWR VPWR sky130_fd_sc_hd__fill_2
XANTENNA__2751__A1 _5235_/A0 VGND VGND VPWR VPWR sky130_fd_sc_hd__diode_2
XFILLER_122_625 VPWR VGND VPWR VGND sky130_ef_sc_hd__decap_40_12
XFILLER_121_113 VGND VGND VPWR VPWR sky130_fd_sc_hd__fill_4
XANTENNA__2786__S _3016_/S VGND VGND VPWR VPWR sky130_fd_sc_hd__diode_2
XFILLER_122_669 VPWR VGND VPWR VGND sky130_ef_sc_hd__decap_40_12
XTAP_TAPCELL_ROW_112_1986 VGND VPWR sky130_fd_sc_hd__tapvpwrvgnd_1
XTAP_TAPCELL_ROW_112_1975 VGND VPWR sky130_fd_sc_hd__tapvpwrvgnd_1
XFILLER_110_809 VGND VGND VPWR VPWR sky130_fd_sc_hd__fill_2
XFILLER_96_57 VGND VGND VPWR VPWR sky130_fd_sc_hd__fill_1
XFILLER_76_701 VGND VGND VPWR VPWR sky130_fd_sc_hd__fill_4
XANTENNA__3700__A0 _5209_/A1 VGND VGND VPWR VPWR sky130_fd_sc_hd__diode_2
XFILLER_102_382 VGND VGND VPWR VPWR sky130_fd_sc_hd__fill_1
Xhold40 hold40/A VGND VGND VPWR VPWR hold40/X sky130_fd_sc_hd__dlygate4sd3_1
Xhold51 hold51/A VGND VGND VPWR VPWR hold51/X sky130_fd_sc_hd__dlygate4sd3_1
XFILLER_76_767 VPWR VGND VPWR VGND sky130_ef_sc_hd__decap_40_12
XANTENNA_input25_A s_axil_wdata[7] VGND VGND VPWR VPWR sky130_fd_sc_hd__diode_2
Xhold73 hold73/A VGND VGND VPWR VPWR hold73/X sky130_fd_sc_hd__dlygate4sd3_1
Xhold62 hold62/A VGND VGND VPWR VPWR hold62/X sky130_fd_sc_hd__dlygate4sd3_1
XFILLER_75_277 VGND VGND VPWR VPWR sky130_fd_sc_hd__fill_2
Xhold84 hold84/A VGND VGND VPWR VPWR hold84/X sky130_fd_sc_hd__dlygate4sd3_1
Xhold95 hold95/A VGND VGND VPWR VPWR hold95/X sky130_fd_sc_hd__dlygate4sd3_1
Xhold1980 _5920_/Q VGND VGND VPWR VPWR _4077_/A1 sky130_fd_sc_hd__dlygate4sd3_1
XFILLER_90_247 VGND VGND VPWR VPWR sky130_fd_sc_hd__fill_2
Xhold1991 _5919_/Q VGND VGND VPWR VPWR _4047_/B1 sky130_fd_sc_hd__dlygate4sd3_1
XFILLER_45_94 VGND VGND VPWR VPWR sky130_fd_sc_hd__fill_1
XTAP_TAPCELL_ROW_14_512 VGND VPWR sky130_fd_sc_hd__tapvpwrvgnd_1
XFILLER_31_303 VGND VGND VPWR VPWR sky130_fd_sc_hd__fill_8
XFILLER_32_837 VGND VGND VPWR VPWR sky130_fd_sc_hd__fill_4
XANTENNA__3519__A0 _5239_/A1 VGND VGND VPWR VPWR sky130_fd_sc_hd__diode_2
XANTENNA__4115__A1_N _4252_/B1 VGND VGND VPWR VPWR sky130_fd_sc_hd__diode_2
XFILLER_129_279 VGND VGND VPWR VPWR sky130_fd_sc_hd__fill_1
XFILLER_8_587 VGND VGND VPWR VPWR sky130_fd_sc_hd__fill_1
XFILLER_6_33 VGND VGND VPWR VPWR sky130_fd_sc_hd__fill_2
XTAP_TAPCELL_ROW_74_1403 VGND VPWR sky130_fd_sc_hd__tapvpwrvgnd_1
XFILLER_99_837 VGND VGND VPWR VPWR sky130_fd_sc_hd__fill_2
XANTENNA__2742__A1 _4882_/A1 VGND VGND VPWR VPWR sky130_fd_sc_hd__diode_2
XTAP_TAPCELL_ROW_74_1414 VGND VPWR sky130_fd_sc_hd__tapvpwrvgnd_1
X_3310_ _5102_/A _3339_/A VGND VGND VPWR VPWR _5035_/C sky130_fd_sc_hd__nor2_4
XFILLER_125_496 VGND VGND VPWR VPWR sky130_fd_sc_hd__fill_8
XFILLER_4_793 VPWR VGND VPWR VGND sky130_ef_sc_hd__decap_40_12
X_4290_ _4290_/A0 _4980_/A1 _4294_/S VGND VGND VPWR VPWR _4290_/X sky130_fd_sc_hd__mux2_1
XANTENNA__5072__S _5081_/S VGND VGND VPWR VPWR sky130_fd_sc_hd__diode_2
XANTENNA__3074__B1_N _3044_/A VGND VGND VPWR VPWR sky130_fd_sc_hd__diode_2
XFILLER_113_669 VGND VGND VPWR VPWR sky130_fd_sc_hd__fill_2
XFILLER_112_157 VGND VGND VPWR VPWR sky130_fd_sc_hd__fill_1
XFILLER_101_809 VPWR VGND VPWR VGND sky130_ef_sc_hd__decap_40_12
XANTENNA__5141__C1 _5200_/A VGND VGND VPWR VPWR sky130_fd_sc_hd__diode_2
X_3241_ _3223_/B _3243_/C _3801_/A VGND VGND VPWR VPWR _3241_/Y sky130_fd_sc_hd__a21oi_1
XANTENNA__4495__A1 _5209_/A1 VGND VGND VPWR VPWR sky130_fd_sc_hd__diode_2
XFILLER_112_179 VGND VGND VPWR VPWR sky130_fd_sc_hd__fill_1
XANTENNA_hold2227_A _5810_/Q VGND VGND VPWR VPWR sky130_fd_sc_hd__diode_2
XFILLER_67_712 VGND VGND VPWR VPWR sky130_fd_sc_hd__fill_8
XPHY_EDGE_ROW_60_Left_199 VGND VGND VPWR VPWR sky130_fd_sc_hd__decap_3
XFILLER_20_3 VPWR VGND VPWR VGND sky130_ef_sc_hd__decap_40_12
X_3172_ _4272_/S _3172_/B _3172_/C VGND VGND VPWR VPWR _3175_/B sky130_fd_sc_hd__and3_1
XFILLER_67_767 VPWR VGND VPWR VGND sky130_ef_sc_hd__decap_40_12
XFILLER_66_233 VGND VGND VPWR VPWR sky130_fd_sc_hd__fill_1
XFILLER_66_222 VGND VGND VPWR VPWR sky130_fd_sc_hd__fill_1
XANTENNA_clkbuf_leaf_6_clk_A clkbuf_leaf_9_clk/A VGND VGND VPWR VPWR sky130_fd_sc_hd__diode_2
XFILLER_81_225 VGND VGND VPWR VPWR sky130_fd_sc_hd__fill_1
XTAP_TAPCELL_ROW_85_1576 VGND VPWR sky130_fd_sc_hd__tapvpwrvgnd_1
XANTENNA__4416__S _4416_/S VGND VGND VPWR VPWR sky130_fd_sc_hd__diode_2
XFILLER_34_130 VGND VGND VPWR VPWR sky130_fd_sc_hd__fill_1
XFILLER_90_781 VPWR VGND VPWR VGND sky130_ef_sc_hd__decap_40_12
X_5813_ _6065_/CLK _5813_/D VGND VGND VPWR VPWR _5813_/Q sky130_fd_sc_hd__dfxtp_2
XFILLER_50_623 VGND VGND VPWR VPWR sky130_fd_sc_hd__fill_1
XFILLER_22_303 VGND VGND VPWR VPWR sky130_fd_sc_hd__fill_4
XFILLER_23_837 VGND VGND VPWR VPWR sky130_fd_sc_hd__fill_2
X_2956_ _4824_/A1 _4850_/A1 _3091_/S VGND VGND VPWR VPWR _2957_/B sky130_fd_sc_hd__mux2_1
X_5744_ clkload8/A _5744_/D VGND VGND VPWR VPWR _5744_/Q sky130_fd_sc_hd__dfxtp_1
XFILLER_108_408 VGND VGND VPWR VPWR sky130_fd_sc_hd__fill_1
X_2887_ _3031_/A1 _2886_/X _2885_/X _3089_/C1 VGND VGND VPWR VPWR _2887_/X sky130_fd_sc_hd__o211a_1
X_5675_ _5681_/CLK _5675_/D VGND VGND VPWR VPWR _5675_/Q sky130_fd_sc_hd__dfxtp_1
XTAP_TAPCELL_ROW_116_2042 VGND VPWR sky130_fd_sc_hd__tapvpwrvgnd_1
XFILLER_108_419 VGND VGND VPWR VPWR sky130_fd_sc_hd__fill_1
X_4626_ _5845_/Q _5623_/Q _4778_/S VGND VGND VPWR VPWR _4626_/X sky130_fd_sc_hd__mux2_1
XFILLER_116_430 VGND VGND VPWR VPWR sky130_fd_sc_hd__fill_1
Xhold510 _5051_/X VGND VGND VPWR VPWR _6344_/D sky130_fd_sc_hd__dlygate4sd3_1
XANTENNA__3081__S1 _3050_/A VGND VGND VPWR VPWR sky130_fd_sc_hd__diode_2
X_4557_ hold206/X _4889_/A1 _4561_/S VGND VGND VPWR VPWR _4557_/X sky130_fd_sc_hd__mux2_1
Xhold521 _3587_/X VGND VGND VPWR VPWR _5621_/D sky130_fd_sc_hd__dlygate4sd3_1
Xhold532 _6323_/Q VGND VGND VPWR VPWR hold532/X sky130_fd_sc_hd__dlygate4sd3_1
Xhold543 _4337_/X VGND VGND VPWR VPWR _5982_/D sky130_fd_sc_hd__dlygate4sd3_1
Xhold554 _6102_/Q VGND VGND VPWR VPWR hold554/X sky130_fd_sc_hd__dlygate4sd3_1
XANTENNA__3930__A0 _4976_/A1 VGND VGND VPWR VPWR sky130_fd_sc_hd__diode_2
Xhold565 _4465_/X VGND VGND VPWR VPWR _6073_/D sky130_fd_sc_hd__dlygate4sd3_1
Xhold576 _5309_/Q VGND VGND VPWR VPWR hold576/X sky130_fd_sc_hd__dlygate4sd3_1
Xhold587 _3111_/X VGND VGND VPWR VPWR _5306_/D sky130_fd_sc_hd__dlygate4sd3_1
XFILLER_104_625 VPWR VGND VPWR VGND sky130_ef_sc_hd__decap_40_12
X_3508_ _4846_/A0 _3508_/A1 _3516_/S VGND VGND VPWR VPWR _3508_/X sky130_fd_sc_hd__mux2_1
X_4488_ _4488_/A0 _4488_/A1 _4488_/S VGND VGND VPWR VPWR _6094_/D sky130_fd_sc_hd__mux2_1
XFILLER_104_669 VPWR VGND VPWR VGND sky130_ef_sc_hd__decap_40_12
X_6227_ _6238_/CLK _6227_/D VGND VGND VPWR VPWR _6227_/Q sky130_fd_sc_hd__dfxtp_1
XFILLER_89_369 VGND VGND VPWR VPWR sky130_fd_sc_hd__fill_1
Xhold598 _5272_/Q VGND VGND VPWR VPWR hold598/X sky130_fd_sc_hd__dlygate4sd3_1
X_3439_ hold475/X _4882_/A1 _3450_/S VGND VGND VPWR VPWR _3439_/X sky130_fd_sc_hd__mux2_1
XFILLER_131_477 VPWR VGND VPWR VGND sky130_ef_sc_hd__decap_40_12
X_6158_ _6238_/CLK _6158_/D VGND VGND VPWR VPWR _6158_/Q sky130_fd_sc_hd__dfxtp_1
XFILLER_66_27 VGND VGND VPWR VPWR sky130_fd_sc_hd__fill_1
Xhold1221 _5537_/Q VGND VGND VPWR VPWR _3492_/A1 sky130_fd_sc_hd__dlygate4sd3_1
Xhold1232 _3102_/X VGND VGND VPWR VPWR _5297_/D sky130_fd_sc_hd__dlygate4sd3_1
X_5109_ _3964_/B _5099_/B _5108_/X _3338_/B _5034_/B VGND VGND VPWR VPWR _5109_/X
+ sky130_fd_sc_hd__o221a_1
Xhold1210 _5463_/Q VGND VGND VPWR VPWR _4134_/A1 sky130_fd_sc_hd__dlygate4sd3_1
Xhold1243 _3252_/X VGND VGND VPWR VPWR _5388_/D sky130_fd_sc_hd__dlygate4sd3_1
XFILLER_73_704 VGND VGND VPWR VPWR sky130_fd_sc_hd__fill_1
Xhold1276 _3546_/X VGND VGND VPWR VPWR _5587_/D sky130_fd_sc_hd__dlygate4sd3_1
Xhold1254 _5601_/Q VGND VGND VPWR VPWR _3562_/A1 sky130_fd_sc_hd__dlygate4sd3_1
Xhold1265 _5649_/Q VGND VGND VPWR VPWR _3620_/A0 sky130_fd_sc_hd__dlygate4sd3_1
XANTENNA__4238__A1 _4252_/A1 VGND VGND VPWR VPWR sky130_fd_sc_hd__diode_2
X_6089_ _6114_/CLK _6089_/D VGND VGND VPWR VPWR _6089_/Q sky130_fd_sc_hd__dfxtp_1
Xhold1298 _3580_/X VGND VGND VPWR VPWR _5616_/D sky130_fd_sc_hd__dlygate4sd3_1
Xhold1287 _6300_/Q VGND VGND VPWR VPWR _4967_/A1 sky130_fd_sc_hd__dlygate4sd3_1
XANTENNA__2635__A _3172_/B VGND VGND VPWR VPWR sky130_fd_sc_hd__diode_2
XTAP_TAPCELL_ROW_0_284 VGND VPWR sky130_fd_sc_hd__tapvpwrvgnd_1
XTAP_TAPCELL_ROW_0_295 VGND VPWR sky130_fd_sc_hd__tapvpwrvgnd_1
XFILLER_14_837 VGND VGND VPWR VPWR sky130_fd_sc_hd__fill_4
XFILLER_26_697 VGND VGND VPWR VPWR sky130_fd_sc_hd__fill_2
XFILLER_41_601 VGND VGND VPWR VPWR sky130_fd_sc_hd__fill_1
XANTENNA__3749__A0 _4978_/A1 VGND VGND VPWR VPWR sky130_fd_sc_hd__diode_2
XFILLER_41_689 VGND VGND VPWR VPWR sky130_fd_sc_hd__fill_1
XANTENNA__2641__Y _2641_/Y VGND VGND VPWR VPWR sky130_fd_sc_hd__diode_2
XFILLER_21_391 VGND VGND VPWR VPWR sky130_fd_sc_hd__fill_1
XFILLER_119_290 VGND VGND VPWR VPWR sky130_fd_sc_hd__fill_1
XANTENNA__4174__B1 _4271_/S1 VGND VGND VPWR VPWR sky130_fd_sc_hd__diode_2
XFILLER_135_783 VGND VGND VPWR VPWR sky130_fd_sc_hd__fill_1
XANTENNA__2724__A1 _3030_/S VGND VGND VPWR VPWR sky130_fd_sc_hd__diode_2
XFILLER_5_557 VGND VGND VPWR VPWR sky130_fd_sc_hd__fill_2
Xoutput52 _6061_/Q VGND VGND VPWR VPWR s_axil_rdata[8] sky130_fd_sc_hd__buf_2
Xoutput41 _6065_/Q VGND VGND VPWR VPWR s_axil_rdata[12] sky130_fd_sc_hd__buf_2
XTAP_TAPCELL_ROW_56_1144 VGND VPWR sky130_fd_sc_hd__tapvpwrvgnd_1
XTAP_TAPCELL_ROW_56_1133 VGND VPWR sky130_fd_sc_hd__tapvpwrvgnd_1
XFILLER_1_741 VPWR VGND VPWR VGND sky130_ef_sc_hd__decap_40_12
XFILLER_122_488 VGND VGND VPWR VPWR sky130_fd_sc_hd__fill_1
XFILLER_122_477 VGND VGND VPWR VPWR sky130_fd_sc_hd__fill_8
XANTENNA__4477__A1 _5211_/A1 VGND VGND VPWR VPWR sky130_fd_sc_hd__diode_2
XFILLER_1_785 VPWR VGND VPWR VGND sky130_ef_sc_hd__decap_40_12
XANTENNA__4572__S1 _4794_/A VGND VGND VPWR VPWR sky130_fd_sc_hd__diode_2
XFILLER_49_767 VPWR VGND VPWR VGND sky130_ef_sc_hd__decap_40_12
XFILLER_91_501 VGND VGND VPWR VPWR sky130_fd_sc_hd__fill_1
XANTENNA__4229__A1 _4264_/A1 VGND VGND VPWR VPWR sky130_fd_sc_hd__diode_2
XFILLER_63_225 VGND VGND VPWR VPWR sky130_fd_sc_hd__fill_4
XFILLER_16_141 VGND VGND VPWR VPWR sky130_fd_sc_hd__fill_1
XFILLER_17_653 VPWR VGND VPWR VGND sky130_ef_sc_hd__decap_40_12
XFILLER_17_697 VPWR VGND VPWR VGND sky130_ef_sc_hd__decap_40_12
XANTENNA__4088__S0 _4252_/A1 VGND VGND VPWR VPWR sky130_fd_sc_hd__diode_2
XFILLER_31_111 VGND VGND VPWR VPWR sky130_fd_sc_hd__fill_1
X_2810_ _2735_/A _2795_/X _2809_/Y _2925_/S VGND VGND VPWR VPWR _2810_/X sky130_fd_sc_hd__o211a_1
X_3790_ hold975/X _5209_/A1 _3797_/S VGND VGND VPWR VPWR _3790_/X sky130_fd_sc_hd__mux2_1
XANTENNA__4760__A _4809_/A VGND VGND VPWR VPWR sky130_fd_sc_hd__diode_2
X_2741_ _4868_/A _4523_/B VGND VGND VPWR VPWR _2753_/S sky130_fd_sc_hd__nor2_8
XTAP_TAPCELL_ROW_80_1495 VGND VPWR sky130_fd_sc_hd__tapvpwrvgnd_1
XFILLER_9_841 VGND VGND VPWR VPWR sky130_fd_sc_hd__fill_1
X_5460_ _5731_/CLK _5460_/D VGND VGND VPWR VPWR _5460_/Q sky130_fd_sc_hd__dfxtp_1
XFILLER_133_709 VPWR VGND VPWR VGND sky130_ef_sc_hd__decap_40_12
X_2672_ hold815/X _4889_/A1 _5241_/S VGND VGND VPWR VPWR _2672_/X sky130_fd_sc_hd__mux2_1
X_4411_ _5826_/Q _4411_/A1 _4416_/S VGND VGND VPWR VPWR _4411_/X sky130_fd_sc_hd__mux2_1
X_5391_ _6420_/CLK _5391_/D VGND VGND VPWR VPWR _5391_/Q sky130_fd_sc_hd__dfxtp_1
XFILLER_125_271 VGND VGND VPWR VPWR sky130_fd_sc_hd__fill_1
XFILLER_98_122 VGND VGND VPWR VPWR sky130_fd_sc_hd__fill_2
X_4342_ hold728/X _5044_/A1 _4345_/S VGND VGND VPWR VPWR _4342_/X sky130_fd_sc_hd__mux2_1
XFILLER_113_444 VGND VGND VPWR VPWR sky130_fd_sc_hd__fill_4
X_4273_ _4260_/X _4272_/X _5343_/Q VGND VGND VPWR VPWR _4273_/X sky130_fd_sc_hd__mux2_1
XFILLER_101_617 VPWR VGND VPWR VGND sky130_ef_sc_hd__decap_40_12
XFILLER_98_166 VGND VGND VPWR VPWR sky130_fd_sc_hd__fill_1
X_3224_ _3278_/A _3777_/A _3232_/A _4803_/S VGND VGND VPWR VPWR _3263_/A sky130_fd_sc_hd__a22o_1
X_6012_ clkload9/A _6012_/D VGND VGND VPWR VPWR _6012_/Q sky130_fd_sc_hd__dfxtp_1
.ends
